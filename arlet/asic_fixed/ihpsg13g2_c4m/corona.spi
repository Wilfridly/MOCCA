* Coriolis Structural SPICE Driver
* Generated on Jan 23, 2026, 19:09
* Cell/Subckt "corona".
*
* INTERF vss
* INTERF vdd
* INTERF reset_from_pad
* INTERF clk_from_pad
* INTERF WE_to_pad
* INTERF RDY_from_pad
* INTERF NMI_from_pad
* INTERF IRQ_from_pad
* INTERF DO_to_pad[7]
* INTERF DO_to_pad[6]
* INTERF DO_to_pad[5]
* INTERF DO_to_pad[4]
* INTERF DO_to_pad[3]
* INTERF DO_to_pad[2]
* INTERF DO_to_pad[1]
* INTERF DO_to_pad[0]
* INTERF DI_from_pad[7]
* INTERF DI_from_pad[6]
* INTERF DI_from_pad[5]
* INTERF DI_from_pad[4]
* INTERF DI_from_pad[3]
* INTERF DI_from_pad[2]
* INTERF DI_from_pad[1]
* INTERF DI_from_pad[0]
* INTERF A_to_pad[9]
* INTERF A_to_pad[8]
* INTERF A_to_pad[7]
* INTERF A_to_pad[6]
* INTERF A_to_pad[5]
* INTERF A_to_pad[4]
* INTERF A_to_pad[3]
* INTERF A_to_pad[2]
* INTERF A_to_pad[15]
* INTERF A_to_pad[14]
* INTERF A_to_pad[13]
* INTERF A_to_pad[12]
* INTERF A_to_pad[11]
* INTERF A_to_pad[10]
* INTERF A_to_pad[1]
* INTERF A_to_pad[0]

.subckt corona 0 1 2 3 4 5 6 7 8 9 10 11 12 13 14 15 16 17 18 19 20 21 22 23 24 25 26 27 28 29 30 31 32 33 34 35 36 37 38 39
* NET     0 = vss
* NET     1 = vdd
* NET     2 = reset_from_pad
* NET     3 = clk_from_pad
* NET     4 = WE_to_pad
* NET     5 = RDY_from_pad
* NET     6 = NMI_from_pad
* NET     7 = IRQ_from_pad
* NET     8 = DO_to_pad[7]
* NET     9 = DO_to_pad[6]
* NET    10 = DO_to_pad[5]
* NET    11 = DO_to_pad[4]
* NET    12 = DO_to_pad[3]
* NET    13 = DO_to_pad[2]
* NET    14 = DO_to_pad[1]
* NET    15 = DO_to_pad[0]
* NET    16 = DI_from_pad[7]
* NET    17 = DI_from_pad[6]
* NET    18 = DI_from_pad[5]
* NET    19 = DI_from_pad[4]
* NET    20 = DI_from_pad[3]
* NET    21 = DI_from_pad[2]
* NET    22 = DI_from_pad[1]
* NET    23 = DI_from_pad[0]
* NET    24 = A_to_pad[9]
* NET    25 = A_to_pad[8]
* NET    26 = A_to_pad[7]
* NET    27 = A_to_pad[6]
* NET    28 = A_to_pad[5]
* NET    29 = A_to_pad[4]
* NET    30 = A_to_pad[3]
* NET    31 = A_to_pad[2]
* NET    32 = A_to_pad[15]
* NET    33 = A_to_pad[14]
* NET    34 = A_to_pad[13]
* NET    35 = A_to_pad[12]
* NET    36 = A_to_pad[11]
* NET    37 = A_to_pad[10]
* NET    38 = A_to_pad[1]
* NET    39 = A_to_pad[0]

xcore 0 1 2 3 4 5 6 7 8 9 10 11 12 13 14 15 16 17 18 19 20 21 22 23 24 25 26 27 28 29 30 31 32 33 34 35 36 37 38 39 Arlet6502
.ends corona
