* Coriolis Structural SPICE Driver
* Generated on Jan 23, 2026, 19:07
* Cell/Subckt "Arlet6502_cts_r".
*
* INTERF vss
* INTERF vdd
* INTERF reset
* INTERF clk
* INTERF WE
* INTERF RDY
* INTERF NMI
* INTERF IRQ
* INTERF DO[7]
* INTERF DO[6]
* INTERF DO[5]
* INTERF DO[4]
* INTERF DO[3]
* INTERF DO[2]
* INTERF DO[1]
* INTERF DO[0]
* INTERF DI[7]
* INTERF DI[6]
* INTERF DI[5]
* INTERF DI[4]
* INTERF DI[3]
* INTERF DI[2]
* INTERF DI[1]
* INTERF DI[0]
* INTERF A[9]
* INTERF A[8]
* INTERF A[7]
* INTERF A[6]
* INTERF A[5]
* INTERF A[4]
* INTERF A[3]
* INTERF A[2]
* INTERF A[15]
* INTERF A[14]
* INTERF A[13]
* INTERF A[12]
* INTERF A[11]
* INTERF A[10]
* INTERF A[1]
* INTERF A[0]

* Terminal models (aka standard cells) used througout all the hierarchy.
.include decap_w0.spi
.include dff_x1.spi
.include and21nor_x0.spi
.include and3_x1.spi
.include and4_x1.spi
.include nand4_x0.spi
.include nand3_x0.spi
.include inv_x0.spi
.include or2_x1.spi
.include or3_x1.spi
.include or21nand_x0.spi
.include nand2_x0.spi
.include mux2_x1.spi
.include and2_x1.spi
.include tie.spi
.include buf_x4.spi
.include nor2_x0.spi
.include or4_x1.spi
.include nor4_x0.spi
.include nor3_x0.spi
.include nexor2_x0.spi
.include xor2_x0.spi
.include diode_w1.spi

* Non-terminal models (part of the user's design hierarchy).

.subckt Arlet6502_cts_r 0 1 23 77 1957 1958 1959 2096 2097 2098 2099 2100 2101 2102 2103 2104 2105 2106 2107 2108 2109 2110 2111 2112 2113 2114 2115 2116 2117 2118 2119 2120 2121 2122 2123 2124 2125 2126 2127 2128
* NET     0 = vss
* NET     1 = vdd
* NET     2 = reset_root_tr_tr_0
* NET     3 = reset_root_tr_tl_0
* NET     4 = reset_root_tr_br_0
* NET     5 = reset_root_tr_bl_0
* NET     6 = reset_root_tr_0
* NET     7 = reset_root_tl_tr_0
* NET     8 = reset_root_tl_tl_0
* NET     9 = reset_root_tl_br_0
* NET    10 = reset_root_tl_bl_0
* NET    11 = reset_root_tl_0
* NET    12 = reset_root_br_tr_0
* NET    13 = reset_root_br_tl_0
* NET    14 = reset_root_br_br_0
* NET    15 = reset_root_br_bl_0
* NET    16 = reset_root_br_0
* NET    17 = reset_root_bl_tr_0
* NET    18 = reset_root_bl_tl_0
* NET    19 = reset_root_bl_br_0
* NET    20 = reset_root_bl_bl_0
* NET    21 = reset_root_bl_0
* NET    22 = reset_root_0
* NET    23 = reset
* NET    24 = clk_root_tr_tr_2
* NET    25 = clk_root_tr_tr_1
* NET    26 = clk_root_tr_tr_0
* NET    27 = clk_root_tr_tl_2
* NET    28 = clk_root_tr_tl_1
* NET    29 = clk_root_tr_tl_0
* NET    30 = clk_root_tr_br_2
* NET    31 = clk_root_tr_br_1
* NET    32 = clk_root_tr_br_0
* NET    33 = clk_root_tr_bl_2
* NET    34 = clk_root_tr_bl_1
* NET    35 = clk_root_tr_bl_0
* NET    36 = clk_root_tr_0
* NET    37 = clk_root_tl_tr_2
* NET    38 = clk_root_tl_tr_1
* NET    39 = clk_root_tl_tr_0
* NET    40 = clk_root_tl_tl_2
* NET    41 = clk_root_tl_tl_1
* NET    42 = clk_root_tl_tl_0
* NET    43 = clk_root_tl_br_2
* NET    44 = clk_root_tl_br_1
* NET    45 = clk_root_tl_br_0
* NET    46 = clk_root_tl_bl_2
* NET    47 = clk_root_tl_bl_1
* NET    48 = clk_root_tl_bl_0
* NET    49 = clk_root_tl_0
* NET    50 = clk_root_br_tr_2
* NET    51 = clk_root_br_tr_1
* NET    52 = clk_root_br_tr_0
* NET    53 = clk_root_br_tl_2
* NET    54 = clk_root_br_tl_1
* NET    55 = clk_root_br_tl_0
* NET    56 = clk_root_br_br_2
* NET    57 = clk_root_br_br_1
* NET    58 = clk_root_br_br_0
* NET    59 = clk_root_br_bl_2
* NET    60 = clk_root_br_bl_1
* NET    61 = clk_root_br_bl_0
* NET    62 = clk_root_br_0
* NET    63 = clk_root_bl_tr_2
* NET    64 = clk_root_bl_tr_1
* NET    65 = clk_root_bl_tr_0
* NET    66 = clk_root_bl_tl_2
* NET    67 = clk_root_bl_tl_1
* NET    68 = clk_root_bl_tl_0
* NET    69 = clk_root_bl_br_2
* NET    70 = clk_root_bl_br_1
* NET    71 = clk_root_bl_br_0
* NET    72 = clk_root_bl_bl_2
* NET    73 = clk_root_bl_bl_1
* NET    74 = clk_root_bl_bl_0
* NET    75 = clk_root_bl_0
* NET    76 = clk_root_0
* NET    77 = clk
* NET    78 = blockagenet
* NET    79 = abc_10991_techmap_MOS6502_abc_9290_memory_AXYS_wrmux_3_3_0_y_1820_7
* NET    80 = abc_10991_techmap_MOS6502_abc_9290_memory_AXYS_wrmux_3_3_0_y_1820_6
* NET    81 = abc_10991_techmap_MOS6502_abc_9290_memory_AXYS_wrmux_3_3_0_y_1820_5
* NET    82 = abc_10991_techmap_MOS6502_abc_9290_memory_AXYS_wrmux_3_3_0_y_1820_4
* NET    83 = abc_10991_techmap_MOS6502_abc_9290_memory_AXYS_wrmux_3_3_0_y_1820_3
* NET    84 = abc_10991_techmap_MOS6502_abc_9290_memory_AXYS_wrmux_3_3_0_y_1820_2
* NET    85 = abc_10991_techmap_MOS6502_abc_9290_memory_AXYS_wrmux_3_3_0_y_1820_1
* NET    86 = abc_10991_techmap_MOS6502_abc_9290_memory_AXYS_wrmux_3_3_0_y_1820_0
* NET    87 = abc_10991_techmap_MOS6502_abc_9290_memory_AXYS_wrmux_2_3_0_y_1796_7
* NET    88 = abc_10991_techmap_MOS6502_abc_9290_memory_AXYS_wrmux_2_3_0_y_1796_6
* NET    89 = abc_10991_techmap_MOS6502_abc_9290_memory_AXYS_wrmux_2_3_0_y_1796_5
* NET    90 = abc_10991_techmap_MOS6502_abc_9290_memory_AXYS_wrmux_2_3_0_y_1796_4
* NET    91 = abc_10991_techmap_MOS6502_abc_9290_memory_AXYS_wrmux_2_3_0_y_1796_3
* NET    92 = abc_10991_techmap_MOS6502_abc_9290_memory_AXYS_wrmux_2_3_0_y_1796_2
* NET    93 = abc_10991_techmap_MOS6502_abc_9290_memory_AXYS_wrmux_2_3_0_y_1796_1
* NET    94 = abc_10991_techmap_MOS6502_abc_9290_memory_AXYS_wrmux_2_3_0_y_1796_0
* NET    95 = abc_10991_techmap_MOS6502_abc_9290_memory_AXYS_wrmux_1_3_0_y_1770_7
* NET    96 = abc_10991_techmap_MOS6502_abc_9290_memory_AXYS_wrmux_1_3_0_y_1770_6
* NET    97 = abc_10991_techmap_MOS6502_abc_9290_memory_AXYS_wrmux_1_3_0_y_1770_5
* NET    98 = abc_10991_techmap_MOS6502_abc_9290_memory_AXYS_wrmux_1_3_0_y_1770_4
* NET    99 = abc_10991_techmap_MOS6502_abc_9290_memory_AXYS_wrmux_1_3_0_y_1770_3
* NET   100 = abc_10991_techmap_MOS6502_abc_9290_memory_AXYS_wrmux_1_3_0_y_1770_2
* NET   101 = abc_10991_techmap_MOS6502_abc_9290_memory_AXYS_wrmux_1_3_0_y_1770_1
* NET   102 = abc_10991_techmap_MOS6502_abc_9290_memory_AXYS_wrmux_1_3_0_y_1770_0
* NET   103 = abc_10991_techmap_MOS6502_abc_9290_memory_AXYS_wrmux_0_3_0_y_1740_7
* NET   104 = abc_10991_techmap_MOS6502_abc_9290_memory_AXYS_wrmux_0_3_0_y_1740_6
* NET   105 = abc_10991_techmap_MOS6502_abc_9290_memory_AXYS_wrmux_0_3_0_y_1740_5
* NET   106 = abc_10991_techmap_MOS6502_abc_9290_memory_AXYS_wrmux_0_3_0_y_1740_4
* NET   107 = abc_10991_techmap_MOS6502_abc_9290_memory_AXYS_wrmux_0_3_0_y_1740_3
* NET   108 = abc_10991_techmap_MOS6502_abc_9290_memory_AXYS_wrmux_0_3_0_y_1740_2
* NET   109 = abc_10991_techmap_MOS6502_abc_9290_memory_AXYS_wrmux_0_3_0_y_1740_1
* NET   110 = abc_10991_techmap_MOS6502_abc_9290_memory_AXYS_wrmux_0_3_0_y_1740_0
* NET   111 = abc_10991_techmap_MOS6502_abc_9290_auto_fsm_map_cc_170_map_fsm_1126[5]
* NET   112 = abc_10991_techmap_MOS6502_abc_9290_auto_fsm_map_cc_170_map_fsm_1126[4]
* NET   113 = abc_10991_techmap_MOS6502_abc_9290_auto_fsm_map_cc_170_map_fsm_1126[3]
* NET   114 = abc_10991_techmap_MOS6502_abc_9290_auto_fsm_map_cc_170_map_fsm_1126[2]
* NET   115 = abc_10991_techmap_MOS6502_abc_9290_auto_fsm_map_cc_170_map_fsm_1126[1]
* NET   116 = abc_10991_techmap_MOS6502_abc_9290_auto_fsm_map_cc_170_map_fsm_1126[0]
* NET   117 = abc_10991_techmap_MOS6502_ALU_0_OUT_7_0_7
* NET   118 = abc_10991_techmap_MOS6502_ALU_0_OUT_7_0_6
* NET   119 = abc_10991_techmap_MOS6502_ALU_0_OUT_7_0_5
* NET   120 = abc_10991_techmap_MOS6502_ALU_0_OUT_7_0_4
* NET   121 = abc_10991_techmap_MOS6502_ALU_0_OUT_7_0_3
* NET   122 = abc_10991_techmap_MOS6502_ALU_0_OUT_7_0_2
* NET   123 = abc_10991_techmap_MOS6502_ALU_0_OUT_7_0_1
* NET   124 = abc_10991_techmap_MOS6502_ALU_0_OUT_7_0_0
* NET   125 = abc_10991_techmap_MOS6502_ALU_0_N_0_0
* NET   126 = abc_10991_techmap_MOS6502_ALU_0_HC_0_0
* NET   127 = abc_10991_techmap_MOS6502_ALU_0_CO_0_0
* NET   128 = abc_10991_techmap_MOS6502_ALU_0_BI7_0_0
* NET   129 = abc_10991_techmap_MOS6502_ALU_0_AI7_0_0
* NET   130 = abc_10991_techmap_MOS6502_0_write_back_0_0
* NET   131 = abc_10991_techmap_MOS6502_0_store_0_0
* NET   132 = abc_10991_techmap_MOS6502_0_src_reg_1_0_1
* NET   133 = abc_10991_techmap_MOS6502_0_src_reg_1_0_0
* NET   134 = abc_10991_techmap_MOS6502_0_shift_right_0_0
* NET   135 = abc_10991_techmap_MOS6502_0_shift_0_0
* NET   136 = abc_10991_techmap_MOS6502_0_sei_0_0
* NET   137 = abc_10991_techmap_MOS6502_0_sed_0_0
* NET   138 = abc_10991_techmap_MOS6502_0_sec_0_0
* NET   139 = abc_10991_techmap_MOS6502_0_rotate_0_0
* NET   140 = abc_10991_techmap_MOS6502_0_res_0_0
* NET   141 = abc_10991_techmap_MOS6502_0_plp_0_0
* NET   142 = abc_10991_techmap_MOS6502_0_php_0_0
* NET   143 = abc_10991_techmap_MOS6502_0_op_3_0_3
* NET   144 = abc_10991_techmap_MOS6502_0_op_3_0_2
* NET   145 = abc_10991_techmap_MOS6502_0_op_3_0_1
* NET   146 = abc_10991_techmap_MOS6502_0_op_3_0_0
* NET   147 = abc_10991_techmap_MOS6502_0_load_reg_0_0
* NET   148 = abc_10991_techmap_MOS6502_0_load_only_0_0
* NET   149 = abc_10991_techmap_MOS6502_0_index_y_0_0
* NET   150 = abc_10991_techmap_MOS6502_0_inc_0_0
* NET   151 = abc_10991_techmap_MOS6502_0_dst_reg_1_0_1
* NET   152 = abc_10991_techmap_MOS6502_0_dst_reg_1_0_0
* NET   153 = abc_10991_techmap_MOS6502_0_cond_code_2_0_2
* NET   154 = abc_10991_techmap_MOS6502_0_cond_code_2_0_1
* NET   155 = abc_10991_techmap_MOS6502_0_cond_code_2_0_0
* NET   156 = abc_10991_techmap_MOS6502_0_compare_0_0
* NET   157 = abc_10991_techmap_MOS6502_0_clv_0_0
* NET   158 = abc_10991_techmap_MOS6502_0_cli_0_0
* NET   159 = abc_10991_techmap_MOS6502_0_cld_0_0
* NET   160 = abc_10991_techmap_MOS6502_0_clc_0_0
* NET   161 = abc_10991_techmap_MOS6502_0_bit_ins_0_0
* NET   162 = abc_10991_techmap_MOS6502_0_backwards_0_0
* NET   163 = abc_10991_techmap_MOS6502_0_adj_bcd_0_0
* NET   164 = abc_10991_techmap_MOS6502_0_adc_sbc_0_0
* NET   165 = abc_10991_techmap_MOS6502_0_adc_bcd_0_0
* NET   166 = abc_10991_techmap_MOS6502_0_Z_0_0
* NET   167 = abc_10991_techmap_MOS6502_0_V_0_0
* NET   168 = abc_10991_techmap_MOS6502_0_PC_15_0_9
* NET   169 = abc_10991_techmap_MOS6502_0_PC_15_0_8
* NET   170 = abc_10991_techmap_MOS6502_0_PC_15_0_7
* NET   171 = abc_10991_techmap_MOS6502_0_PC_15_0_6
* NET   172 = abc_10991_techmap_MOS6502_0_PC_15_0_5
* NET   173 = abc_10991_techmap_MOS6502_0_PC_15_0_4
* NET   174 = abc_10991_techmap_MOS6502_0_PC_15_0_3
* NET   175 = abc_10991_techmap_MOS6502_0_PC_15_0_2
* NET   176 = abc_10991_techmap_MOS6502_0_PC_15_0_15
* NET   177 = abc_10991_techmap_MOS6502_0_PC_15_0_14
* NET   178 = abc_10991_techmap_MOS6502_0_PC_15_0_13
* NET   179 = abc_10991_techmap_MOS6502_0_PC_15_0_12
* NET   180 = abc_10991_techmap_MOS6502_0_PC_15_0_11
* NET   181 = abc_10991_techmap_MOS6502_0_PC_15_0_10
* NET   182 = abc_10991_techmap_MOS6502_0_PC_15_0_1
* NET   183 = abc_10991_techmap_MOS6502_0_PC_15_0_0
* NET   184 = abc_10991_techmap_MOS6502_0_N_0_0
* NET   185 = abc_10991_techmap_MOS6502_0_NMI_edge_0_0
* NET   186 = abc_10991_techmap_MOS6502_0_I_0_0
* NET   187 = abc_10991_techmap_MOS6502_0_IRHOLD_valid_0_0
* NET   188 = abc_10991_techmap_MOS6502_0_IRHOLD_7_0_7
* NET   189 = abc_10991_techmap_MOS6502_0_IRHOLD_7_0_6
* NET   190 = abc_10991_techmap_MOS6502_0_IRHOLD_7_0_5
* NET   191 = abc_10991_techmap_MOS6502_0_IRHOLD_7_0_4
* NET   192 = abc_10991_techmap_MOS6502_0_IRHOLD_7_0_3
* NET   193 = abc_10991_techmap_MOS6502_0_IRHOLD_7_0_2
* NET   194 = abc_10991_techmap_MOS6502_0_IRHOLD_7_0_1
* NET   195 = abc_10991_techmap_MOS6502_0_IRHOLD_7_0_0
* NET   196 = abc_10991_techmap_MOS6502_0_D_0_0
* NET   197 = abc_10991_techmap_MOS6502_0_C_0_0
* NET   198 = abc_10991_techmap_MOS6502_0_ABL_7_0_7
* NET   199 = abc_10991_techmap_MOS6502_0_ABL_7_0_6
* NET   200 = abc_10991_techmap_MOS6502_0_ABL_7_0_5
* NET   201 = abc_10991_techmap_MOS6502_0_ABL_7_0_4
* NET   202 = abc_10991_techmap_MOS6502_0_ABL_7_0_3
* NET   203 = abc_10991_techmap_MOS6502_0_ABL_7_0_2
* NET   204 = abc_10991_techmap_MOS6502_0_ABL_7_0_1
* NET   205 = abc_10991_techmap_MOS6502_0_ABL_7_0_0
* NET   206 = abc_10991_techmap_MOS6502_0_ABH_7_0_7
* NET   207 = abc_10991_techmap_MOS6502_0_ABH_7_0_6
* NET   208 = abc_10991_techmap_MOS6502_0_ABH_7_0_5
* NET   209 = abc_10991_techmap_MOS6502_0_ABH_7_0_4
* NET   210 = abc_10991_techmap_MOS6502_0_ABH_7_0_3
* NET   211 = abc_10991_techmap_MOS6502_0_ABH_7_0_2
* NET   212 = abc_10991_techmap_MOS6502_0_ABH_7_0_1
* NET   213 = abc_10991_techmap_MOS6502_0_ABH_7_0_0
* NET   214 = abc_10991_new_n999
* NET   215 = abc_10991_new_n998
* NET   216 = abc_10991_new_n997
* NET   217 = abc_10991_new_n996
* NET   218 = abc_10991_new_n995
* NET   219 = abc_10991_new_n994
* NET   220 = abc_10991_new_n993
* NET   221 = abc_10991_new_n991
* NET   222 = abc_10991_new_n990
* NET   223 = abc_10991_new_n989
* NET   224 = abc_10991_new_n988
* NET   225 = abc_10991_new_n987
* NET   226 = abc_10991_new_n986
* NET   227 = abc_10991_new_n985
* NET   228 = abc_10991_new_n984
* NET   229 = abc_10991_new_n983
* NET   230 = abc_10991_new_n982
* NET   231 = abc_10991_new_n980
* NET   232 = abc_10991_new_n979
* NET   233 = abc_10991_new_n978
* NET   234 = abc_10991_new_n977
* NET   235 = abc_10991_new_n976
* NET   236 = abc_10991_new_n975
* NET   237 = abc_10991_new_n974
* NET   238 = abc_10991_new_n973
* NET   239 = abc_10991_new_n972
* NET   240 = abc_10991_new_n970
* NET   241 = abc_10991_new_n969
* NET   242 = abc_10991_new_n968
* NET   243 = abc_10991_new_n967
* NET   244 = abc_10991_new_n966
* NET   245 = abc_10991_new_n965
* NET   246 = abc_10991_new_n964
* NET   247 = abc_10991_new_n963
* NET   248 = abc_10991_new_n961
* NET   249 = abc_10991_new_n960
* NET   250 = abc_10991_new_n959
* NET   251 = abc_10991_new_n958
* NET   252 = abc_10991_new_n957
* NET   253 = abc_10991_new_n956
* NET   254 = abc_10991_new_n955
* NET   255 = abc_10991_new_n954
* NET   256 = abc_10991_new_n953
* NET   257 = abc_10991_new_n951
* NET   258 = abc_10991_new_n950
* NET   259 = abc_10991_new_n949
* NET   260 = abc_10991_new_n948
* NET   261 = abc_10991_new_n947
* NET   262 = abc_10991_new_n946
* NET   263 = abc_10991_new_n945
* NET   264 = abc_10991_new_n944
* NET   265 = abc_10991_new_n942
* NET   266 = abc_10991_new_n941
* NET   267 = abc_10991_new_n940
* NET   268 = abc_10991_new_n939
* NET   269 = abc_10991_new_n938
* NET   270 = abc_10991_new_n937
* NET   271 = abc_10991_new_n936
* NET   272 = abc_10991_new_n935
* NET   273 = abc_10991_new_n934
* NET   274 = abc_10991_new_n933
* NET   275 = abc_10991_new_n932
* NET   276 = abc_10991_new_n930
* NET   277 = abc_10991_new_n929
* NET   278 = abc_10991_new_n928
* NET   279 = abc_10991_new_n927
* NET   280 = abc_10991_new_n926
* NET   281 = abc_10991_new_n925
* NET   282 = abc_10991_new_n924
* NET   283 = abc_10991_new_n923
* NET   284 = abc_10991_new_n922
* NET   285 = abc_10991_new_n921
* NET   286 = abc_10991_new_n920
* NET   287 = abc_10991_new_n918
* NET   288 = abc_10991_new_n917
* NET   289 = abc_10991_new_n916
* NET   290 = abc_10991_new_n915
* NET   291 = abc_10991_new_n914
* NET   292 = abc_10991_new_n913
* NET   293 = abc_10991_new_n912
* NET   294 = abc_10991_new_n911
* NET   295 = abc_10991_new_n910
* NET   296 = abc_10991_new_n909
* NET   297 = abc_10991_new_n907
* NET   298 = abc_10991_new_n906
* NET   299 = abc_10991_new_n905
* NET   300 = abc_10991_new_n904
* NET   301 = abc_10991_new_n903
* NET   302 = abc_10991_new_n902
* NET   303 = abc_10991_new_n901
* NET   304 = abc_10991_new_n900
* NET   305 = abc_10991_new_n899
* NET   306 = abc_10991_new_n898
* NET   307 = abc_10991_new_n897
* NET   308 = abc_10991_new_n896
* NET   309 = abc_10991_new_n895
* NET   310 = abc_10991_new_n894
* NET   311 = abc_10991_new_n893
* NET   312 = abc_10991_new_n892
* NET   313 = abc_10991_new_n891
* NET   314 = abc_10991_new_n890
* NET   315 = abc_10991_new_n889
* NET   316 = abc_10991_new_n888
* NET   317 = abc_10991_new_n887
* NET   318 = abc_10991_new_n886
* NET   319 = abc_10991_new_n885
* NET   320 = abc_10991_new_n884
* NET   321 = abc_10991_new_n883
* NET   322 = abc_10991_new_n882
* NET   323 = abc_10991_new_n881
* NET   324 = abc_10991_new_n880
* NET   325 = abc_10991_new_n879
* NET   326 = abc_10991_new_n878
* NET   327 = abc_10991_new_n877
* NET   328 = abc_10991_new_n875
* NET   329 = abc_10991_new_n874
* NET   330 = abc_10991_new_n873
* NET   331 = abc_10991_new_n871
* NET   332 = abc_10991_new_n870
* NET   333 = abc_10991_new_n868
* NET   334 = abc_10991_new_n867
* NET   335 = abc_10991_new_n865
* NET   336 = abc_10991_new_n864
* NET   337 = abc_10991_new_n863
* NET   338 = abc_10991_new_n862
* NET   339 = abc_10991_new_n861
* NET   340 = abc_10991_new_n860
* NET   341 = abc_10991_new_n859
* NET   342 = abc_10991_new_n858
* NET   343 = abc_10991_new_n857
* NET   344 = abc_10991_new_n856
* NET   345 = abc_10991_new_n855
* NET   346 = abc_10991_new_n854
* NET   347 = abc_10991_new_n853
* NET   348 = abc_10991_new_n852
* NET   349 = abc_10991_new_n850
* NET   350 = abc_10991_new_n849
* NET   351 = abc_10991_new_n847
* NET   352 = abc_10991_new_n846
* NET   353 = abc_10991_new_n845
* NET   354 = abc_10991_new_n844
* NET   355 = abc_10991_new_n843
* NET   356 = abc_10991_new_n842
* NET   357 = abc_10991_new_n841
* NET   358 = abc_10991_new_n840
* NET   359 = abc_10991_new_n839
* NET   360 = abc_10991_new_n838
* NET   361 = abc_10991_new_n836
* NET   362 = abc_10991_new_n835
* NET   363 = abc_10991_new_n834
* NET   364 = abc_10991_new_n832
* NET   365 = abc_10991_new_n831
* NET   366 = abc_10991_new_n830
* NET   367 = abc_10991_new_n829
* NET   368 = abc_10991_new_n828
* NET   369 = abc_10991_new_n827
* NET   370 = abc_10991_new_n826
* NET   371 = abc_10991_new_n825
* NET   372 = abc_10991_new_n824
* NET   373 = abc_10991_new_n823
* NET   374 = abc_10991_new_n822
* NET   375 = abc_10991_new_n821
* NET   376 = abc_10991_new_n819
* NET   377 = abc_10991_new_n818
* NET   378 = abc_10991_new_n816
* NET   379 = abc_10991_new_n815
* NET   380 = abc_10991_new_n814
* NET   381 = abc_10991_new_n813
* NET   382 = abc_10991_new_n812
* NET   383 = abc_10991_new_n811
* NET   384 = abc_10991_new_n810
* NET   385 = abc_10991_new_n809
* NET   386 = abc_10991_new_n808
* NET   387 = abc_10991_new_n807
* NET   388 = abc_10991_new_n805
* NET   389 = abc_10991_new_n804
* NET   390 = abc_10991_new_n803
* NET   391 = abc_10991_new_n801
* NET   392 = abc_10991_new_n800
* NET   393 = abc_10991_new_n799
* NET   394 = abc_10991_new_n798
* NET   395 = abc_10991_new_n797
* NET   396 = abc_10991_new_n796
* NET   397 = abc_10991_new_n795
* NET   398 = abc_10991_new_n794
* NET   399 = abc_10991_new_n793
* NET   400 = abc_10991_new_n792
* NET   401 = abc_10991_new_n791
* NET   402 = abc_10991_new_n790
* NET   403 = abc_10991_new_n789
* NET   404 = abc_10991_new_n788
* NET   405 = abc_10991_new_n787
* NET   406 = abc_10991_new_n785
* NET   407 = abc_10991_new_n784
* NET   408 = abc_10991_new_n783
* NET   409 = abc_10991_new_n781
* NET   410 = abc_10991_new_n780
* NET   411 = abc_10991_new_n779
* NET   412 = abc_10991_new_n778
* NET   413 = abc_10991_new_n777
* NET   414 = abc_10991_new_n776
* NET   415 = abc_10991_new_n775
* NET   416 = abc_10991_new_n774
* NET   417 = abc_10991_new_n773
* NET   418 = abc_10991_new_n772
* NET   419 = abc_10991_new_n771
* NET   420 = abc_10991_new_n770
* NET   421 = abc_10991_new_n769
* NET   422 = abc_10991_new_n768
* NET   423 = abc_10991_new_n767
* NET   424 = abc_10991_new_n765
* NET   425 = abc_10991_new_n764
* NET   426 = abc_10991_new_n762
* NET   427 = abc_10991_new_n761
* NET   428 = abc_10991_new_n759
* NET   429 = abc_10991_new_n758
* NET   430 = abc_10991_new_n756
* NET   431 = abc_10991_new_n755
* NET   432 = abc_10991_new_n753
* NET   433 = abc_10991_new_n752
* NET   434 = abc_10991_new_n750
* NET   435 = abc_10991_new_n749
* NET   436 = abc_10991_new_n747
* NET   437 = abc_10991_new_n746
* NET   438 = abc_10991_new_n744
* NET   439 = abc_10991_new_n743
* NET   440 = abc_10991_new_n742
* NET   441 = abc_10991_new_n741
* NET   442 = abc_10991_new_n740
* NET   443 = abc_10991_new_n739
* NET   444 = abc_10991_new_n738
* NET   445 = abc_10991_new_n737
* NET   446 = abc_10991_new_n736
* NET   447 = abc_10991_new_n735
* NET   448 = abc_10991_new_n734
* NET   449 = abc_10991_new_n733
* NET   450 = abc_10991_new_n732
* NET   451 = abc_10991_new_n731
* NET   452 = abc_10991_new_n730
* NET   453 = abc_10991_new_n729
* NET   454 = abc_10991_new_n728
* NET   455 = abc_10991_new_n727
* NET   456 = abc_10991_new_n726
* NET   457 = abc_10991_new_n725
* NET   458 = abc_10991_new_n724
* NET   459 = abc_10991_new_n723
* NET   460 = abc_10991_new_n722
* NET   461 = abc_10991_new_n721
* NET   462 = abc_10991_new_n720
* NET   463 = abc_10991_new_n719
* NET   464 = abc_10991_new_n718
* NET   465 = abc_10991_new_n717
* NET   466 = abc_10991_new_n716
* NET   467 = abc_10991_new_n715
* NET   468 = abc_10991_new_n714
* NET   469 = abc_10991_new_n713
* NET   470 = abc_10991_new_n712
* NET   471 = abc_10991_new_n711
* NET   472 = abc_10991_new_n710
* NET   473 = abc_10991_new_n709
* NET   474 = abc_10991_new_n708
* NET   475 = abc_10991_new_n707
* NET   476 = abc_10991_new_n706
* NET   477 = abc_10991_new_n705
* NET   478 = abc_10991_new_n704
* NET   479 = abc_10991_new_n703
* NET   480 = abc_10991_new_n702
* NET   481 = abc_10991_new_n701
* NET   482 = abc_10991_new_n700
* NET   483 = abc_10991_new_n699
* NET   484 = abc_10991_new_n698
* NET   485 = abc_10991_new_n697
* NET   486 = abc_10991_new_n696
* NET   487 = abc_10991_new_n695
* NET   488 = abc_10991_new_n694
* NET   489 = abc_10991_new_n693
* NET   490 = abc_10991_new_n692
* NET   491 = abc_10991_new_n691
* NET   492 = abc_10991_new_n690
* NET   493 = abc_10991_new_n689
* NET   494 = abc_10991_new_n688
* NET   495 = abc_10991_new_n687
* NET   496 = abc_10991_new_n686
* NET   497 = abc_10991_new_n685
* NET   498 = abc_10991_new_n684
* NET   499 = abc_10991_new_n683
* NET   500 = abc_10991_new_n682
* NET   501 = abc_10991_new_n681
* NET   502 = abc_10991_new_n680
* NET   503 = abc_10991_new_n679
* NET   504 = abc_10991_new_n678
* NET   505 = abc_10991_new_n677
* NET   506 = abc_10991_new_n676
* NET   507 = abc_10991_new_n674
* NET   508 = abc_10991_new_n673
* NET   509 = abc_10991_new_n672
* NET   510 = abc_10991_new_n671
* NET   511 = abc_10991_new_n670
* NET   512 = abc_10991_new_n669
* NET   513 = abc_10991_new_n668
* NET   514 = abc_10991_new_n666
* NET   515 = abc_10991_new_n665
* NET   516 = abc_10991_new_n664
* NET   517 = abc_10991_new_n663
* NET   518 = abc_10991_new_n662
* NET   519 = abc_10991_new_n661
* NET   520 = abc_10991_new_n660
* NET   521 = abc_10991_new_n659
* NET   522 = abc_10991_new_n657
* NET   523 = abc_10991_new_n656
* NET   524 = abc_10991_new_n655
* NET   525 = abc_10991_new_n654
* NET   526 = abc_10991_new_n653
* NET   527 = abc_10991_new_n652
* NET   528 = abc_10991_new_n651
* NET   529 = abc_10991_new_n649
* NET   530 = abc_10991_new_n648
* NET   531 = abc_10991_new_n647
* NET   532 = abc_10991_new_n646
* NET   533 = abc_10991_new_n645
* NET   534 = abc_10991_new_n644
* NET   535 = abc_10991_new_n643
* NET   536 = abc_10991_new_n641
* NET   537 = abc_10991_new_n640
* NET   538 = abc_10991_new_n639
* NET   539 = abc_10991_new_n638
* NET   540 = abc_10991_new_n637
* NET   541 = abc_10991_new_n636
* NET   542 = abc_10991_new_n635
* NET   543 = abc_10991_new_n633
* NET   544 = abc_10991_new_n632
* NET   545 = abc_10991_new_n631
* NET   546 = abc_10991_new_n630
* NET   547 = abc_10991_new_n629
* NET   548 = abc_10991_new_n628
* NET   549 = abc_10991_new_n627
* NET   550 = abc_10991_new_n625
* NET   551 = abc_10991_new_n624
* NET   552 = abc_10991_new_n623
* NET   553 = abc_10991_new_n622
* NET   554 = abc_10991_new_n621
* NET   555 = abc_10991_new_n620
* NET   556 = abc_10991_new_n619
* NET   557 = abc_10991_new_n617
* NET   558 = abc_10991_new_n616
* NET   559 = abc_10991_new_n615
* NET   560 = abc_10991_new_n614
* NET   561 = abc_10991_new_n613
* NET   562 = abc_10991_new_n612
* NET   563 = abc_10991_new_n611
* NET   564 = abc_10991_new_n609
* NET   565 = abc_10991_new_n608
* NET   566 = abc_10991_new_n607
* NET   567 = abc_10991_new_n606
* NET   568 = abc_10991_new_n605
* NET   569 = abc_10991_new_n604
* NET   570 = abc_10991_new_n603
* NET   571 = abc_10991_new_n602
* NET   572 = abc_10991_new_n601
* NET   573 = abc_10991_new_n600
* NET   574 = abc_10991_new_n599
* NET   575 = abc_10991_new_n598
* NET   576 = abc_10991_new_n597
* NET   577 = abc_10991_new_n596
* NET   578 = abc_10991_new_n595
* NET   579 = abc_10991_new_n594
* NET   580 = abc_10991_new_n592
* NET   581 = abc_10991_new_n591
* NET   582 = abc_10991_new_n590
* NET   583 = abc_10991_new_n589
* NET   584 = abc_10991_new_n588
* NET   585 = abc_10991_new_n587
* NET   586 = abc_10991_new_n586
* NET   587 = abc_10991_new_n585
* NET   588 = abc_10991_new_n584
* NET   589 = abc_10991_new_n583
* NET   590 = abc_10991_new_n582
* NET   591 = abc_10991_new_n581
* NET   592 = abc_10991_new_n580
* NET   593 = abc_10991_new_n579
* NET   594 = abc_10991_new_n578
* NET   595 = abc_10991_new_n577
* NET   596 = abc_10991_new_n576
* NET   597 = abc_10991_new_n575
* NET   598 = abc_10991_new_n574
* NET   599 = abc_10991_new_n573
* NET   600 = abc_10991_new_n572
* NET   601 = abc_10991_new_n571
* NET   602 = abc_10991_new_n570
* NET   603 = abc_10991_new_n569
* NET   604 = abc_10991_new_n568
* NET   605 = abc_10991_new_n567
* NET   606 = abc_10991_new_n566
* NET   607 = abc_10991_new_n565
* NET   608 = abc_10991_new_n564
* NET   609 = abc_10991_new_n563
* NET   610 = abc_10991_new_n562
* NET   611 = abc_10991_new_n561
* NET   612 = abc_10991_new_n560
* NET   613 = abc_10991_new_n559
* NET   614 = abc_10991_new_n558
* NET   615 = abc_10991_new_n557
* NET   616 = abc_10991_new_n556
* NET   617 = abc_10991_new_n555
* NET   618 = abc_10991_new_n554
* NET   619 = abc_10991_new_n553
* NET   620 = abc_10991_new_n552
* NET   621 = abc_10991_new_n551
* NET   622 = abc_10991_new_n550
* NET   623 = abc_10991_new_n549
* NET   624 = abc_10991_new_n548
* NET   625 = abc_10991_new_n547
* NET   626 = abc_10991_new_n546
* NET   627 = abc_10991_new_n545
* NET   628 = abc_10991_new_n544
* NET   629 = abc_10991_new_n543
* NET   630 = abc_10991_new_n542
* NET   631 = abc_10991_new_n541
* NET   632 = abc_10991_new_n540
* NET   633 = abc_10991_new_n539
* NET   634 = abc_10991_new_n538
* NET   635 = abc_10991_new_n537
* NET   636 = abc_10991_new_n536
* NET   637 = abc_10991_new_n535
* NET   638 = abc_10991_new_n534
* NET   639 = abc_10991_new_n533
* NET   640 = abc_10991_new_n532
* NET   641 = abc_10991_new_n531
* NET   642 = abc_10991_new_n530
* NET   643 = abc_10991_new_n529
* NET   644 = abc_10991_new_n528
* NET   645 = abc_10991_new_n527
* NET   646 = abc_10991_new_n526
* NET   647 = abc_10991_new_n525
* NET   648 = abc_10991_new_n524
* NET   649 = abc_10991_new_n523
* NET   650 = abc_10991_new_n522
* NET   651 = abc_10991_new_n521
* NET   652 = abc_10991_new_n520
* NET   653 = abc_10991_new_n519
* NET   654 = abc_10991_new_n518
* NET   655 = abc_10991_new_n517
* NET   656 = abc_10991_new_n516
* NET   657 = abc_10991_new_n515
* NET   658 = abc_10991_new_n514
* NET   659 = abc_10991_new_n513
* NET   660 = abc_10991_new_n512
* NET   661 = abc_10991_new_n511
* NET   662 = abc_10991_new_n510
* NET   663 = abc_10991_new_n509
* NET   664 = abc_10991_new_n508
* NET   665 = abc_10991_new_n507
* NET   666 = abc_10991_new_n506
* NET   667 = abc_10991_new_n505
* NET   668 = abc_10991_new_n504
* NET   669 = abc_10991_new_n503
* NET   670 = abc_10991_new_n502
* NET   671 = abc_10991_new_n501
* NET   672 = abc_10991_new_n500
* NET   673 = abc_10991_new_n499
* NET   674 = abc_10991_new_n498
* NET   675 = abc_10991_new_n497
* NET   676 = abc_10991_new_n496
* NET   677 = abc_10991_new_n495
* NET   678 = abc_10991_new_n494
* NET   679 = abc_10991_new_n493
* NET   680 = abc_10991_new_n492
* NET   681 = abc_10991_new_n491
* NET   682 = abc_10991_new_n490
* NET   683 = abc_10991_new_n489
* NET   684 = abc_10991_new_n488
* NET   685 = abc_10991_new_n487
* NET   686 = abc_10991_new_n486
* NET   687 = abc_10991_new_n485
* NET   688 = abc_10991_new_n484
* NET   689 = abc_10991_new_n483
* NET   690 = abc_10991_new_n482
* NET   691 = abc_10991_new_n481
* NET   692 = abc_10991_new_n480
* NET   693 = abc_10991_new_n479
* NET   694 = abc_10991_new_n478
* NET   695 = abc_10991_new_n477
* NET   696 = abc_10991_new_n476
* NET   697 = abc_10991_new_n475
* NET   698 = abc_10991_new_n474
* NET   699 = abc_10991_new_n473
* NET   700 = abc_10991_new_n472
* NET   701 = abc_10991_new_n471
* NET   702 = abc_10991_new_n470
* NET   703 = abc_10991_new_n469
* NET   704 = abc_10991_new_n468
* NET   705 = abc_10991_new_n467
* NET   706 = abc_10991_new_n466
* NET   707 = abc_10991_new_n465
* NET   708 = abc_10991_new_n464
* NET   709 = abc_10991_new_n463
* NET   710 = abc_10991_new_n462
* NET   711 = abc_10991_new_n461
* NET   712 = abc_10991_new_n460
* NET   713 = abc_10991_new_n459
* NET   714 = abc_10991_new_n458
* NET   715 = abc_10991_new_n457
* NET   716 = abc_10991_new_n456
* NET   717 = abc_10991_new_n455
* NET   718 = abc_10991_new_n454
* NET   719 = abc_10991_new_n453
* NET   720 = abc_10991_new_n452
* NET   721 = abc_10991_new_n451
* NET   722 = abc_10991_new_n450
* NET   723 = abc_10991_new_n449
* NET   724 = abc_10991_new_n448
* NET   725 = abc_10991_new_n447
* NET   726 = abc_10991_new_n446
* NET   727 = abc_10991_new_n445
* NET   728 = abc_10991_new_n444
* NET   729 = abc_10991_new_n443
* NET   730 = abc_10991_new_n442
* NET   731 = abc_10991_new_n441
* NET   732 = abc_10991_new_n440
* NET   733 = abc_10991_new_n439
* NET   734 = abc_10991_new_n438
* NET   735 = abc_10991_new_n437
* NET   736 = abc_10991_new_n436
* NET   737 = abc_10991_new_n435
* NET   738 = abc_10991_new_n434
* NET   739 = abc_10991_new_n433
* NET   740 = abc_10991_new_n432
* NET   741 = abc_10991_new_n431
* NET   742 = abc_10991_new_n430
* NET   743 = abc_10991_new_n429
* NET   744 = abc_10991_new_n428
* NET   745 = abc_10991_new_n427
* NET   746 = abc_10991_new_n426
* NET   747 = abc_10991_new_n425
* NET   748 = abc_10991_new_n424
* NET   749 = abc_10991_new_n423
* NET   750 = abc_10991_new_n422
* NET   751 = abc_10991_new_n421
* NET   752 = abc_10991_new_n420
* NET   753 = abc_10991_new_n419
* NET   754 = abc_10991_new_n418
* NET   755 = abc_10991_new_n417
* NET   756 = abc_10991_new_n416
* NET   757 = abc_10991_new_n415
* NET   758 = abc_10991_new_n414
* NET   759 = abc_10991_new_n413
* NET   760 = abc_10991_new_n412
* NET   761 = abc_10991_new_n411
* NET   762 = abc_10991_new_n410
* NET   763 = abc_10991_new_n409
* NET   764 = abc_10991_new_n408
* NET   765 = abc_10991_new_n407
* NET   766 = abc_10991_new_n406
* NET   767 = abc_10991_new_n405
* NET   768 = abc_10991_new_n404
* NET   769 = abc_10991_new_n403
* NET   770 = abc_10991_new_n402
* NET   771 = abc_10991_new_n401
* NET   772 = abc_10991_new_n400
* NET   773 = abc_10991_new_n399
* NET   774 = abc_10991_new_n398
* NET   775 = abc_10991_new_n397
* NET   776 = abc_10991_new_n396
* NET   777 = abc_10991_new_n395
* NET   778 = abc_10991_new_n394
* NET   779 = abc_10991_new_n393
* NET   780 = abc_10991_new_n392
* NET   781 = abc_10991_new_n391
* NET   782 = abc_10991_new_n390
* NET   783 = abc_10991_new_n389
* NET   784 = abc_10991_new_n388
* NET   785 = abc_10991_new_n387
* NET   786 = abc_10991_new_n386
* NET   787 = abc_10991_new_n385
* NET   788 = abc_10991_new_n384
* NET   789 = abc_10991_new_n383
* NET   790 = abc_10991_new_n382
* NET   791 = abc_10991_new_n381
* NET   792 = abc_10991_new_n380
* NET   793 = abc_10991_new_n379
* NET   794 = abc_10991_new_n378
* NET   795 = abc_10991_new_n377
* NET   796 = abc_10991_new_n376
* NET   797 = abc_10991_new_n375
* NET   798 = abc_10991_new_n374
* NET   799 = abc_10991_new_n373
* NET   800 = abc_10991_new_n372
* NET   801 = abc_10991_new_n371
* NET   802 = abc_10991_new_n370
* NET   803 = abc_10991_new_n369
* NET   804 = abc_10991_new_n368
* NET   805 = abc_10991_new_n367
* NET   806 = abc_10991_new_n366
* NET   807 = abc_10991_new_n365
* NET   808 = abc_10991_new_n364
* NET   809 = abc_10991_new_n363
* NET   810 = abc_10991_new_n362
* NET   811 = abc_10991_new_n361
* NET   812 = abc_10991_new_n360
* NET   813 = abc_10991_new_n359
* NET   814 = abc_10991_new_n358
* NET   815 = abc_10991_new_n357
* NET   816 = abc_10991_new_n356
* NET   817 = abc_10991_new_n355
* NET   818 = abc_10991_new_n354
* NET   819 = abc_10991_new_n353
* NET   820 = abc_10991_new_n352
* NET   821 = abc_10991_new_n351
* NET   822 = abc_10991_new_n350
* NET   823 = abc_10991_new_n349
* NET   824 = abc_10991_new_n348
* NET   825 = abc_10991_new_n347
* NET   826 = abc_10991_new_n346
* NET   827 = abc_10991_new_n345
* NET   828 = abc_10991_new_n344
* NET   829 = abc_10991_new_n343
* NET   830 = abc_10991_new_n342
* NET   831 = abc_10991_new_n341
* NET   832 = abc_10991_new_n340
* NET   833 = abc_10991_new_n339
* NET   834 = abc_10991_new_n338
* NET   835 = abc_10991_new_n337
* NET   836 = abc_10991_new_n336
* NET   837 = abc_10991_new_n335
* NET   838 = abc_10991_new_n334
* NET   839 = abc_10991_new_n333
* NET   840 = abc_10991_new_n332
* NET   841 = abc_10991_new_n331
* NET   842 = abc_10991_new_n330
* NET   843 = abc_10991_new_n329
* NET   844 = abc_10991_new_n328
* NET   845 = abc_10991_new_n327
* NET   846 = abc_10991_new_n326
* NET   847 = abc_10991_new_n325
* NET   848 = abc_10991_new_n324
* NET   849 = abc_10991_new_n323
* NET   850 = abc_10991_new_n322
* NET   851 = abc_10991_new_n321
* NET   852 = abc_10991_new_n320
* NET   853 = abc_10991_new_n319
* NET   854 = abc_10991_new_n318
* NET   855 = abc_10991_new_n317
* NET   856 = abc_10991_new_n316
* NET   857 = abc_10991_new_n315
* NET   858 = abc_10991_new_n314
* NET   859 = abc_10991_new_n313
* NET   860 = abc_10991_new_n312
* NET   861 = abc_10991_new_n311
* NET   862 = abc_10991_new_n310
* NET   863 = abc_10991_new_n309
* NET   864 = abc_10991_new_n2208
* NET   865 = abc_10991_new_n2207
* NET   866 = abc_10991_new_n2206
* NET   867 = abc_10991_new_n2205
* NET   868 = abc_10991_new_n2204
* NET   869 = abc_10991_new_n2203
* NET   870 = abc_10991_new_n2200
* NET   871 = abc_10991_new_n2199
* NET   872 = abc_10991_new_n2197
* NET   873 = abc_10991_new_n2196
* NET   874 = abc_10991_new_n2195
* NET   875 = abc_10991_new_n2194
* NET   876 = abc_10991_new_n2193
* NET   877 = abc_10991_new_n2192
* NET   878 = abc_10991_new_n2191
* NET   879 = abc_10991_new_n2190
* NET   880 = abc_10991_new_n2189
* NET   881 = abc_10991_new_n2188
* NET   882 = abc_10991_new_n2187
* NET   883 = abc_10991_new_n2186
* NET   884 = abc_10991_new_n2185
* NET   885 = abc_10991_new_n2184
* NET   886 = abc_10991_new_n2183
* NET   887 = abc_10991_new_n2182
* NET   888 = abc_10991_new_n2181
* NET   889 = abc_10991_new_n2180
* NET   890 = abc_10991_new_n2179
* NET   891 = abc_10991_new_n2178
* NET   892 = abc_10991_new_n2177
* NET   893 = abc_10991_new_n2176
* NET   894 = abc_10991_new_n2175
* NET   895 = abc_10991_new_n2174
* NET   896 = abc_10991_new_n2173
* NET   897 = abc_10991_new_n2172
* NET   898 = abc_10991_new_n2170
* NET   899 = abc_10991_new_n2169
* NET   900 = abc_10991_new_n2168
* NET   901 = abc_10991_new_n2167
* NET   902 = abc_10991_new_n2166
* NET   903 = abc_10991_new_n2165
* NET   904 = abc_10991_new_n2164
* NET   905 = abc_10991_new_n2163
* NET   906 = abc_10991_new_n2162
* NET   907 = abc_10991_new_n2161
* NET   908 = abc_10991_new_n2160
* NET   909 = abc_10991_new_n2159
* NET   910 = abc_10991_new_n2158
* NET   911 = abc_10991_new_n2157
* NET   912 = abc_10991_new_n2156
* NET   913 = abc_10991_new_n2155
* NET   914 = abc_10991_new_n2154
* NET   915 = abc_10991_new_n2153
* NET   916 = abc_10991_new_n2152
* NET   917 = abc_10991_new_n2151
* NET   918 = abc_10991_new_n2150
* NET   919 = abc_10991_new_n2149
* NET   920 = abc_10991_new_n2148
* NET   921 = abc_10991_new_n2147
* NET   922 = abc_10991_new_n2146
* NET   923 = abc_10991_new_n2145
* NET   924 = abc_10991_new_n2144
* NET   925 = abc_10991_new_n2143
* NET   926 = abc_10991_new_n2142
* NET   927 = abc_10991_new_n2141
* NET   928 = abc_10991_new_n2140
* NET   929 = abc_10991_new_n2139
* NET   930 = abc_10991_new_n2138
* NET   931 = abc_10991_new_n2137
* NET   932 = abc_10991_new_n2135
* NET   933 = abc_10991_new_n2134
* NET   934 = abc_10991_new_n2133
* NET   935 = abc_10991_new_n2132
* NET   936 = abc_10991_new_n2131
* NET   937 = abc_10991_new_n2130
* NET   938 = abc_10991_new_n2129
* NET   939 = abc_10991_new_n2128
* NET   940 = abc_10991_new_n2127
* NET   941 = abc_10991_new_n2126
* NET   942 = abc_10991_new_n2125
* NET   943 = abc_10991_new_n2124
* NET   944 = abc_10991_new_n2123
* NET   945 = abc_10991_new_n2122
* NET   946 = abc_10991_new_n2121
* NET   947 = abc_10991_new_n2120
* NET   948 = abc_10991_new_n2119
* NET   949 = abc_10991_new_n2118
* NET   950 = abc_10991_new_n2117
* NET   951 = abc_10991_new_n2116
* NET   952 = abc_10991_new_n2115
* NET   953 = abc_10991_new_n2114
* NET   954 = abc_10991_new_n2113
* NET   955 = abc_10991_new_n2112
* NET   956 = abc_10991_new_n2111
* NET   957 = abc_10991_new_n2110
* NET   958 = abc_10991_new_n2109
* NET   959 = abc_10991_new_n2107
* NET   960 = abc_10991_new_n2106
* NET   961 = abc_10991_new_n2105
* NET   962 = abc_10991_new_n2104
* NET   963 = abc_10991_new_n2103
* NET   964 = abc_10991_new_n2102
* NET   965 = abc_10991_new_n2101
* NET   966 = abc_10991_new_n2100
* NET   967 = abc_10991_new_n2099
* NET   968 = abc_10991_new_n2098
* NET   969 = abc_10991_new_n2097
* NET   970 = abc_10991_new_n2096
* NET   971 = abc_10991_new_n2095
* NET   972 = abc_10991_new_n2094
* NET   973 = abc_10991_new_n2093
* NET   974 = abc_10991_new_n2092
* NET   975 = abc_10991_new_n2091
* NET   976 = abc_10991_new_n2090
* NET   977 = abc_10991_new_n2089
* NET   978 = abc_10991_new_n2088
* NET   979 = abc_10991_new_n2087
* NET   980 = abc_10991_new_n2086
* NET   981 = abc_10991_new_n2085
* NET   982 = abc_10991_new_n2084
* NET   983 = abc_10991_new_n2083
* NET   984 = abc_10991_new_n2082
* NET   985 = abc_10991_new_n2081
* NET   986 = abc_10991_new_n2080
* NET   987 = abc_10991_new_n2079
* NET   988 = abc_10991_new_n2078
* NET   989 = abc_10991_new_n2077
* NET   990 = abc_10991_new_n2076
* NET   991 = abc_10991_new_n2075
* NET   992 = abc_10991_new_n2074
* NET   993 = abc_10991_new_n2073
* NET   994 = abc_10991_new_n2072
* NET   995 = abc_10991_new_n2071
* NET   996 = abc_10991_new_n2069
* NET   997 = abc_10991_new_n2068
* NET   998 = abc_10991_new_n2067
* NET   999 = abc_10991_new_n2066
* NET  1000 = abc_10991_new_n2065
* NET  1001 = abc_10991_new_n2064
* NET  1002 = abc_10991_new_n2063
* NET  1003 = abc_10991_new_n2062
* NET  1004 = abc_10991_new_n2061
* NET  1005 = abc_10991_new_n2060
* NET  1006 = abc_10991_new_n2059
* NET  1007 = abc_10991_new_n2058
* NET  1008 = abc_10991_new_n2057
* NET  1009 = abc_10991_new_n2056
* NET  1010 = abc_10991_new_n2055
* NET  1011 = abc_10991_new_n2054
* NET  1012 = abc_10991_new_n2053
* NET  1013 = abc_10991_new_n2052
* NET  1014 = abc_10991_new_n2051
* NET  1015 = abc_10991_new_n2050
* NET  1016 = abc_10991_new_n2049
* NET  1017 = abc_10991_new_n2048
* NET  1018 = abc_10991_new_n2047
* NET  1019 = abc_10991_new_n2046
* NET  1020 = abc_10991_new_n2045
* NET  1021 = abc_10991_new_n2044
* NET  1022 = abc_10991_new_n2043
* NET  1023 = abc_10991_new_n2042
* NET  1024 = abc_10991_new_n2041
* NET  1025 = abc_10991_new_n2040
* NET  1026 = abc_10991_new_n2039
* NET  1027 = abc_10991_new_n2038
* NET  1028 = abc_10991_new_n2037
* NET  1029 = abc_10991_new_n2036
* NET  1030 = abc_10991_new_n2035
* NET  1031 = abc_10991_new_n2033
* NET  1032 = abc_10991_new_n2032
* NET  1033 = abc_10991_new_n2031
* NET  1034 = abc_10991_new_n2030
* NET  1035 = abc_10991_new_n2029
* NET  1036 = abc_10991_new_n2028
* NET  1037 = abc_10991_new_n2027
* NET  1038 = abc_10991_new_n2026
* NET  1039 = abc_10991_new_n2025
* NET  1040 = abc_10991_new_n2024
* NET  1041 = abc_10991_new_n2023
* NET  1042 = abc_10991_new_n2022
* NET  1043 = abc_10991_new_n2021
* NET  1044 = abc_10991_new_n2020
* NET  1045 = abc_10991_new_n2019
* NET  1046 = abc_10991_new_n2018
* NET  1047 = abc_10991_new_n2017
* NET  1048 = abc_10991_new_n2016
* NET  1049 = abc_10991_new_n2015
* NET  1050 = abc_10991_new_n2014
* NET  1051 = abc_10991_new_n2013
* NET  1052 = abc_10991_new_n2012
* NET  1053 = abc_10991_new_n2011
* NET  1054 = abc_10991_new_n2010
* NET  1055 = abc_10991_new_n2009
* NET  1056 = abc_10991_new_n2008
* NET  1057 = abc_10991_new_n2007
* NET  1058 = abc_10991_new_n2006
* NET  1059 = abc_10991_new_n2005
* NET  1060 = abc_10991_new_n2004
* NET  1061 = abc_10991_new_n2003
* NET  1062 = abc_10991_new_n2002
* NET  1063 = abc_10991_new_n2001
* NET  1064 = abc_10991_new_n2000
* NET  1065 = abc_10991_new_n1998
* NET  1066 = abc_10991_new_n1997
* NET  1067 = abc_10991_new_n1996
* NET  1068 = abc_10991_new_n1995
* NET  1069 = abc_10991_new_n1994
* NET  1070 = abc_10991_new_n1993
* NET  1071 = abc_10991_new_n1992
* NET  1072 = abc_10991_new_n1991
* NET  1073 = abc_10991_new_n1990
* NET  1074 = abc_10991_new_n1989
* NET  1075 = abc_10991_new_n1988
* NET  1076 = abc_10991_new_n1987
* NET  1077 = abc_10991_new_n1986
* NET  1078 = abc_10991_new_n1985
* NET  1079 = abc_10991_new_n1984
* NET  1080 = abc_10991_new_n1983
* NET  1081 = abc_10991_new_n1982
* NET  1082 = abc_10991_new_n1981
* NET  1083 = abc_10991_new_n1980
* NET  1084 = abc_10991_new_n1979
* NET  1085 = abc_10991_new_n1978
* NET  1086 = abc_10991_new_n1977
* NET  1087 = abc_10991_new_n1976
* NET  1088 = abc_10991_new_n1975
* NET  1089 = abc_10991_new_n1974
* NET  1090 = abc_10991_new_n1973
* NET  1091 = abc_10991_new_n1972
* NET  1092 = abc_10991_new_n1971
* NET  1093 = abc_10991_new_n1970
* NET  1094 = abc_10991_new_n1969
* NET  1095 = abc_10991_new_n1968
* NET  1096 = abc_10991_new_n1967
* NET  1097 = abc_10991_new_n1966
* NET  1098 = abc_10991_new_n1965
* NET  1099 = abc_10991_new_n1964
* NET  1100 = abc_10991_new_n1963
* NET  1101 = abc_10991_new_n1962
* NET  1102 = abc_10991_new_n1960
* NET  1103 = abc_10991_new_n1959
* NET  1104 = abc_10991_new_n1958
* NET  1105 = abc_10991_new_n1957
* NET  1106 = abc_10991_new_n1956
* NET  1107 = abc_10991_new_n1955
* NET  1108 = abc_10991_new_n1954
* NET  1109 = abc_10991_new_n1953
* NET  1110 = abc_10991_new_n1952
* NET  1111 = abc_10991_new_n1951
* NET  1112 = abc_10991_new_n1950
* NET  1113 = abc_10991_new_n1949
* NET  1114 = abc_10991_new_n1948
* NET  1115 = abc_10991_new_n1947
* NET  1116 = abc_10991_new_n1946
* NET  1117 = abc_10991_new_n1945
* NET  1118 = abc_10991_new_n1944
* NET  1119 = abc_10991_new_n1943
* NET  1120 = abc_10991_new_n1942
* NET  1121 = abc_10991_new_n1941
* NET  1122 = abc_10991_new_n1940
* NET  1123 = abc_10991_new_n1939
* NET  1124 = abc_10991_new_n1938
* NET  1125 = abc_10991_new_n1937
* NET  1126 = abc_10991_new_n1936
* NET  1127 = abc_10991_new_n1935
* NET  1128 = abc_10991_new_n1934
* NET  1129 = abc_10991_new_n1933
* NET  1130 = abc_10991_new_n1932
* NET  1131 = abc_10991_new_n1931
* NET  1132 = abc_10991_new_n1930
* NET  1133 = abc_10991_new_n1929
* NET  1134 = abc_10991_new_n1928
* NET  1135 = abc_10991_new_n1927
* NET  1136 = abc_10991_new_n1926
* NET  1137 = abc_10991_new_n1925
* NET  1138 = abc_10991_new_n1924
* NET  1139 = abc_10991_new_n1923
* NET  1140 = abc_10991_new_n1922
* NET  1141 = abc_10991_new_n1921
* NET  1142 = abc_10991_new_n1920
* NET  1143 = abc_10991_new_n1919
* NET  1144 = abc_10991_new_n1918
* NET  1145 = abc_10991_new_n1917
* NET  1146 = abc_10991_new_n1916
* NET  1147 = abc_10991_new_n1915
* NET  1148 = abc_10991_new_n1914
* NET  1149 = abc_10991_new_n1913
* NET  1150 = abc_10991_new_n1912
* NET  1151 = abc_10991_new_n1911
* NET  1152 = abc_10991_new_n1910
* NET  1153 = abc_10991_new_n1909
* NET  1154 = abc_10991_new_n1908
* NET  1155 = abc_10991_new_n1907
* NET  1156 = abc_10991_new_n1906
* NET  1157 = abc_10991_new_n1905
* NET  1158 = abc_10991_new_n1904
* NET  1159 = abc_10991_new_n1903
* NET  1160 = abc_10991_new_n1902
* NET  1161 = abc_10991_new_n1901
* NET  1162 = abc_10991_new_n1900
* NET  1163 = abc_10991_new_n1899
* NET  1164 = abc_10991_new_n1898
* NET  1165 = abc_10991_new_n1897
* NET  1166 = abc_10991_new_n1896
* NET  1167 = abc_10991_new_n1895
* NET  1168 = abc_10991_new_n1894
* NET  1169 = abc_10991_new_n1893
* NET  1170 = abc_10991_new_n1892
* NET  1171 = abc_10991_new_n1891
* NET  1172 = abc_10991_new_n1890
* NET  1173 = abc_10991_new_n1889
* NET  1174 = abc_10991_new_n1888
* NET  1175 = abc_10991_new_n1887
* NET  1176 = abc_10991_new_n1886
* NET  1177 = abc_10991_new_n1885
* NET  1178 = abc_10991_new_n1884
* NET  1179 = abc_10991_new_n1883
* NET  1180 = abc_10991_new_n1882
* NET  1181 = abc_10991_new_n1881
* NET  1182 = abc_10991_new_n1880
* NET  1183 = abc_10991_new_n1879
* NET  1184 = abc_10991_new_n1878
* NET  1185 = abc_10991_new_n1874
* NET  1186 = abc_10991_new_n1872
* NET  1187 = abc_10991_new_n1870
* NET  1188 = abc_10991_new_n1868
* NET  1189 = abc_10991_new_n1866
* NET  1190 = abc_10991_new_n1864
* NET  1191 = abc_10991_new_n1862
* NET  1192 = abc_10991_new_n1860
* NET  1193 = abc_10991_new_n1859
* NET  1194 = abc_10991_new_n1857
* NET  1195 = abc_10991_new_n1856
* NET  1196 = abc_10991_new_n1855
* NET  1197 = abc_10991_new_n1854
* NET  1198 = abc_10991_new_n1853
* NET  1199 = abc_10991_new_n1852
* NET  1200 = abc_10991_new_n1851
* NET  1201 = abc_10991_new_n1850
* NET  1202 = abc_10991_new_n1849
* NET  1203 = abc_10991_new_n1848
* NET  1204 = abc_10991_new_n1847
* NET  1205 = abc_10991_new_n1846
* NET  1206 = abc_10991_new_n1844
* NET  1207 = abc_10991_new_n1843
* NET  1208 = abc_10991_new_n1842
* NET  1209 = abc_10991_new_n1841
* NET  1210 = abc_10991_new_n1840
* NET  1211 = abc_10991_new_n1839
* NET  1212 = abc_10991_new_n1838
* NET  1213 = abc_10991_new_n1837
* NET  1214 = abc_10991_new_n1836
* NET  1215 = abc_10991_new_n1835
* NET  1216 = abc_10991_new_n1834
* NET  1217 = abc_10991_new_n1833
* NET  1218 = abc_10991_new_n1831
* NET  1219 = abc_10991_new_n1830
* NET  1220 = abc_10991_new_n1829
* NET  1221 = abc_10991_new_n1828
* NET  1222 = abc_10991_new_n1827
* NET  1223 = abc_10991_new_n1826
* NET  1224 = abc_10991_new_n1825
* NET  1225 = abc_10991_new_n1824
* NET  1226 = abc_10991_new_n1823
* NET  1227 = abc_10991_new_n1822
* NET  1228 = abc_10991_new_n1821
* NET  1229 = abc_10991_new_n1820
* NET  1230 = abc_10991_new_n1819
* NET  1231 = abc_10991_new_n1817
* NET  1232 = abc_10991_new_n1816
* NET  1233 = abc_10991_new_n1815
* NET  1234 = abc_10991_new_n1814
* NET  1235 = abc_10991_new_n1813
* NET  1236 = abc_10991_new_n1812
* NET  1237 = abc_10991_new_n1811
* NET  1238 = abc_10991_new_n1809
* NET  1239 = abc_10991_new_n1808
* NET  1240 = abc_10991_new_n1807
* NET  1241 = abc_10991_new_n1806
* NET  1242 = abc_10991_new_n1805
* NET  1243 = abc_10991_new_n1804
* NET  1244 = abc_10991_new_n1803
* NET  1245 = abc_10991_new_n1802
* NET  1246 = abc_10991_new_n1801
* NET  1247 = abc_10991_new_n1800
* NET  1248 = abc_10991_new_n1799
* NET  1249 = abc_10991_new_n1798
* NET  1250 = abc_10991_new_n1797
* NET  1251 = abc_10991_new_n1796
* NET  1252 = abc_10991_new_n1795
* NET  1253 = abc_10991_new_n1794
* NET  1254 = abc_10991_new_n1792
* NET  1255 = abc_10991_new_n1791
* NET  1256 = abc_10991_new_n1789
* NET  1257 = abc_10991_new_n1788
* NET  1258 = abc_10991_new_n1786
* NET  1259 = abc_10991_new_n1785
* NET  1260 = abc_10991_new_n1783
* NET  1261 = abc_10991_new_n1782
* NET  1262 = abc_10991_new_n1780
* NET  1263 = abc_10991_new_n1779
* NET  1264 = abc_10991_new_n1777
* NET  1265 = abc_10991_new_n1776
* NET  1266 = abc_10991_new_n1774
* NET  1267 = abc_10991_new_n1773
* NET  1268 = abc_10991_new_n1771
* NET  1269 = abc_10991_new_n1770
* NET  1270 = abc_10991_new_n1768
* NET  1271 = abc_10991_new_n1767
* NET  1272 = abc_10991_new_n1766
* NET  1273 = abc_10991_new_n1764
* NET  1274 = abc_10991_new_n1763
* NET  1275 = abc_10991_new_n1762
* NET  1276 = abc_10991_new_n1761
* NET  1277 = abc_10991_new_n1760
* NET  1278 = abc_10991_new_n1759
* NET  1279 = abc_10991_new_n1758
* NET  1280 = abc_10991_new_n1757
* NET  1281 = abc_10991_new_n1755
* NET  1282 = abc_10991_new_n1754
* NET  1283 = abc_10991_new_n1753
* NET  1284 = abc_10991_new_n1752
* NET  1285 = abc_10991_new_n1751
* NET  1286 = abc_10991_new_n1749
* NET  1287 = abc_10991_new_n1748
* NET  1288 = abc_10991_new_n1747
* NET  1289 = abc_10991_new_n1746
* NET  1290 = abc_10991_new_n1745
* NET  1291 = abc_10991_new_n1744
* NET  1292 = abc_10991_new_n1743
* NET  1293 = abc_10991_new_n1742
* NET  1294 = abc_10991_new_n1740
* NET  1295 = abc_10991_new_n1739
* NET  1296 = abc_10991_new_n1738
* NET  1297 = abc_10991_new_n1737
* NET  1298 = abc_10991_new_n1735
* NET  1299 = abc_10991_new_n1734
* NET  1300 = abc_10991_new_n1733
* NET  1301 = abc_10991_new_n1732
* NET  1302 = abc_10991_new_n1731
* NET  1303 = abc_10991_new_n1730
* NET  1304 = abc_10991_new_n1729
* NET  1305 = abc_10991_new_n1728
* NET  1306 = abc_10991_new_n1727
* NET  1307 = abc_10991_new_n1726
* NET  1308 = abc_10991_new_n1724
* NET  1309 = abc_10991_new_n1723
* NET  1310 = abc_10991_new_n1722
* NET  1311 = abc_10991_new_n1720
* NET  1312 = abc_10991_new_n1719
* NET  1313 = abc_10991_new_n1718
* NET  1314 = abc_10991_new_n1716
* NET  1315 = abc_10991_new_n1714
* NET  1316 = abc_10991_new_n1713
* NET  1317 = abc_10991_new_n1712
* NET  1318 = abc_10991_new_n1710
* NET  1319 = abc_10991_new_n1709
* NET  1320 = abc_10991_new_n1708
* NET  1321 = abc_10991_new_n1707
* NET  1322 = abc_10991_new_n1705
* NET  1323 = abc_10991_new_n1703
* NET  1324 = abc_10991_new_n1702
* NET  1325 = abc_10991_new_n1701
* NET  1326 = abc_10991_new_n1700
* NET  1327 = abc_10991_new_n1699
* NET  1328 = abc_10991_new_n1698
* NET  1329 = abc_10991_new_n1696
* NET  1330 = abc_10991_new_n1695
* NET  1331 = abc_10991_new_n1694
* NET  1332 = abc_10991_new_n1693
* NET  1333 = abc_10991_new_n1691
* NET  1334 = abc_10991_new_n1690
* NET  1335 = abc_10991_new_n1689
* NET  1336 = abc_10991_new_n1687
* NET  1337 = abc_10991_new_n1686
* NET  1338 = abc_10991_new_n1684
* NET  1339 = abc_10991_new_n1683
* NET  1340 = abc_10991_new_n1682
* NET  1341 = abc_10991_new_n1681
* NET  1342 = abc_10991_new_n1679
* NET  1343 = abc_10991_new_n1677
* NET  1344 = abc_10991_new_n1675
* NET  1345 = abc_10991_new_n1674
* NET  1346 = abc_10991_new_n1673
* NET  1347 = abc_10991_new_n1672
* NET  1348 = abc_10991_new_n1671
* NET  1349 = abc_10991_new_n1670
* NET  1350 = abc_10991_new_n1669
* NET  1351 = abc_10991_new_n1668
* NET  1352 = abc_10991_new_n1666
* NET  1353 = abc_10991_new_n1665
* NET  1354 = abc_10991_new_n1664
* NET  1355 = abc_10991_new_n1663
* NET  1356 = abc_10991_new_n1662
* NET  1357 = abc_10991_new_n1661
* NET  1358 = abc_10991_new_n1660
* NET  1359 = abc_10991_new_n1659
* NET  1360 = abc_10991_new_n1658
* NET  1361 = abc_10991_new_n1657
* NET  1362 = abc_10991_new_n1656
* NET  1363 = abc_10991_new_n1655
* NET  1364 = abc_10991_new_n1654
* NET  1365 = abc_10991_new_n1653
* NET  1366 = abc_10991_new_n1652
* NET  1367 = abc_10991_new_n1651
* NET  1368 = abc_10991_new_n1650
* NET  1369 = abc_10991_new_n1649
* NET  1370 = abc_10991_new_n1648
* NET  1371 = abc_10991_new_n1647
* NET  1372 = abc_10991_new_n1646
* NET  1373 = abc_10991_new_n1645
* NET  1374 = abc_10991_new_n1644
* NET  1375 = abc_10991_new_n1643
* NET  1376 = abc_10991_new_n1642
* NET  1377 = abc_10991_new_n1641
* NET  1378 = abc_10991_new_n1640
* NET  1379 = abc_10991_new_n1638
* NET  1380 = abc_10991_new_n1637
* NET  1381 = abc_10991_new_n1635
* NET  1382 = abc_10991_new_n1633
* NET  1383 = abc_10991_new_n1631
* NET  1384 = abc_10991_new_n1629
* NET  1385 = abc_10991_new_n1627
* NET  1386 = abc_10991_new_n1625
* NET  1387 = abc_10991_new_n1623
* NET  1388 = abc_10991_new_n1621
* NET  1389 = abc_10991_new_n1620
* NET  1390 = abc_10991_new_n1618
* NET  1391 = abc_10991_new_n1616
* NET  1392 = abc_10991_new_n1614
* NET  1393 = abc_10991_new_n1613
* NET  1394 = abc_10991_new_n1611
* NET  1395 = abc_10991_new_n1609
* NET  1396 = abc_10991_new_n1608
* NET  1397 = abc_10991_new_n1606
* NET  1398 = abc_10991_new_n1605
* NET  1399 = abc_10991_new_n1604
* NET  1400 = abc_10991_new_n1603
* NET  1401 = abc_10991_new_n1601
* NET  1402 = abc_10991_new_n1600
* NET  1403 = abc_10991_new_n1599
* NET  1404 = abc_10991_new_n1598
* NET  1405 = abc_10991_new_n1596
* NET  1406 = abc_10991_new_n1595
* NET  1407 = abc_10991_new_n1594
* NET  1408 = abc_10991_new_n1593
* NET  1409 = abc_10991_new_n1591
* NET  1410 = abc_10991_new_n1590
* NET  1411 = abc_10991_new_n1589
* NET  1412 = abc_10991_new_n1588
* NET  1413 = abc_10991_new_n1587
* NET  1414 = abc_10991_new_n1586
* NET  1415 = abc_10991_new_n1581
* NET  1416 = abc_10991_new_n1580
* NET  1417 = abc_10991_new_n1579
* NET  1418 = abc_10991_new_n1576
* NET  1419 = abc_10991_new_n1574
* NET  1420 = abc_10991_new_n1572
* NET  1421 = abc_10991_new_n1569
* NET  1422 = abc_10991_new_n1567
* NET  1423 = abc_10991_new_n1565
* NET  1424 = abc_10991_new_n1564
* NET  1425 = abc_10991_new_n1562
* NET  1426 = abc_10991_new_n1561
* NET  1427 = abc_10991_new_n1560
* NET  1428 = abc_10991_new_n1559
* NET  1429 = abc_10991_new_n1558
* NET  1430 = abc_10991_new_n1557
* NET  1431 = abc_10991_new_n1556
* NET  1432 = abc_10991_new_n1553
* NET  1433 = abc_10991_new_n1552
* NET  1434 = abc_10991_new_n1551
* NET  1435 = abc_10991_new_n1550
* NET  1436 = abc_10991_new_n1549
* NET  1437 = abc_10991_new_n1547
* NET  1438 = abc_10991_new_n1546
* NET  1439 = abc_10991_new_n1545
* NET  1440 = abc_10991_new_n1544
* NET  1441 = abc_10991_new_n1543
* NET  1442 = abc_10991_new_n1542
* NET  1443 = abc_10991_new_n1540
* NET  1444 = abc_10991_new_n1539
* NET  1445 = abc_10991_new_n1538
* NET  1446 = abc_10991_new_n1537
* NET  1447 = abc_10991_new_n1535
* NET  1448 = abc_10991_new_n1534
* NET  1449 = abc_10991_new_n1533
* NET  1450 = abc_10991_new_n1532
* NET  1451 = abc_10991_new_n1531
* NET  1452 = abc_10991_new_n1530
* NET  1453 = abc_10991_new_n1528
* NET  1454 = abc_10991_new_n1527
* NET  1455 = abc_10991_new_n1526
* NET  1456 = abc_10991_new_n1525
* NET  1457 = abc_10991_new_n1524
* NET  1458 = abc_10991_new_n1522
* NET  1459 = abc_10991_new_n1521
* NET  1460 = abc_10991_new_n1520
* NET  1461 = abc_10991_new_n1519
* NET  1462 = abc_10991_new_n1518
* NET  1463 = abc_10991_new_n1517
* NET  1464 = abc_10991_new_n1515
* NET  1465 = abc_10991_new_n1514
* NET  1466 = abc_10991_new_n1513
* NET  1467 = abc_10991_new_n1512
* NET  1468 = abc_10991_new_n1511
* NET  1469 = abc_10991_new_n1510
* NET  1470 = abc_10991_new_n1508
* NET  1471 = abc_10991_new_n1507
* NET  1472 = abc_10991_new_n1506
* NET  1473 = abc_10991_new_n1505
* NET  1474 = abc_10991_new_n1504
* NET  1475 = abc_10991_new_n1503
* NET  1476 = abc_10991_new_n1502
* NET  1477 = abc_10991_new_n1501
* NET  1478 = abc_10991_new_n1500
* NET  1479 = abc_10991_new_n1499
* NET  1480 = abc_10991_new_n1498
* NET  1481 = abc_10991_new_n1497
* NET  1482 = abc_10991_new_n1495
* NET  1483 = abc_10991_new_n1494
* NET  1484 = abc_10991_new_n1493
* NET  1485 = abc_10991_new_n1492
* NET  1486 = abc_10991_new_n1491
* NET  1487 = abc_10991_new_n1490
* NET  1488 = abc_10991_new_n1489
* NET  1489 = abc_10991_new_n1488
* NET  1490 = abc_10991_new_n1486
* NET  1491 = abc_10991_new_n1485
* NET  1492 = abc_10991_new_n1484
* NET  1493 = abc_10991_new_n1483
* NET  1494 = abc_10991_new_n1482
* NET  1495 = abc_10991_new_n1481
* NET  1496 = abc_10991_new_n1480
* NET  1497 = abc_10991_new_n1479
* NET  1498 = abc_10991_new_n1478
* NET  1499 = abc_10991_new_n1477
* NET  1500 = abc_10991_new_n1476
* NET  1501 = abc_10991_new_n1475
* NET  1502 = abc_10991_new_n1473
* NET  1503 = abc_10991_new_n1472
* NET  1504 = abc_10991_new_n1471
* NET  1505 = abc_10991_new_n1470
* NET  1506 = abc_10991_new_n1469
* NET  1507 = abc_10991_new_n1468
* NET  1508 = abc_10991_new_n1467
* NET  1509 = abc_10991_new_n1466
* NET  1510 = abc_10991_new_n1464
* NET  1511 = abc_10991_new_n1463
* NET  1512 = abc_10991_new_n1462
* NET  1513 = abc_10991_new_n1461
* NET  1514 = abc_10991_new_n1460
* NET  1515 = abc_10991_new_n1459
* NET  1516 = abc_10991_new_n1458
* NET  1517 = abc_10991_new_n1457
* NET  1518 = abc_10991_new_n1456
* NET  1519 = abc_10991_new_n1455
* NET  1520 = abc_10991_new_n1454
* NET  1521 = abc_10991_new_n1453
* NET  1522 = abc_10991_new_n1452
* NET  1523 = abc_10991_new_n1451
* NET  1524 = abc_10991_new_n1450
* NET  1525 = abc_10991_new_n1449
* NET  1526 = abc_10991_new_n1448
* NET  1527 = abc_10991_new_n1447
* NET  1528 = abc_10991_new_n1446
* NET  1529 = abc_10991_new_n1445
* NET  1530 = abc_10991_new_n1444
* NET  1531 = abc_10991_new_n1443
* NET  1532 = abc_10991_new_n1442
* NET  1533 = abc_10991_new_n1441
* NET  1534 = abc_10991_new_n1440
* NET  1535 = abc_10991_new_n1439
* NET  1536 = abc_10991_new_n1438
* NET  1537 = abc_10991_new_n1437
* NET  1538 = abc_10991_new_n1436
* NET  1539 = abc_10991_new_n1435
* NET  1540 = abc_10991_new_n1434
* NET  1541 = abc_10991_new_n1433
* NET  1542 = abc_10991_new_n1431
* NET  1543 = abc_10991_new_n1430
* NET  1544 = abc_10991_new_n1429
* NET  1545 = abc_10991_new_n1428
* NET  1546 = abc_10991_new_n1427
* NET  1547 = abc_10991_new_n1426
* NET  1548 = abc_10991_new_n1425
* NET  1549 = abc_10991_new_n1424
* NET  1550 = abc_10991_new_n1423
* NET  1551 = abc_10991_new_n1422
* NET  1552 = abc_10991_new_n1421
* NET  1553 = abc_10991_new_n1420
* NET  1554 = abc_10991_new_n1419
* NET  1555 = abc_10991_new_n1418
* NET  1556 = abc_10991_new_n1417
* NET  1557 = abc_10991_new_n1416
* NET  1558 = abc_10991_new_n1415
* NET  1559 = abc_10991_new_n1414
* NET  1560 = abc_10991_new_n1413
* NET  1561 = abc_10991_new_n1412
* NET  1562 = abc_10991_new_n1411
* NET  1563 = abc_10991_new_n1410
* NET  1564 = abc_10991_new_n1409
* NET  1565 = abc_10991_new_n1408
* NET  1566 = abc_10991_new_n1407
* NET  1567 = abc_10991_new_n1406
* NET  1568 = abc_10991_new_n1405
* NET  1569 = abc_10991_new_n1404
* NET  1570 = abc_10991_new_n1403
* NET  1571 = abc_10991_new_n1402
* NET  1572 = abc_10991_new_n1401
* NET  1573 = abc_10991_new_n1400
* NET  1574 = abc_10991_new_n1399
* NET  1575 = abc_10991_new_n1398
* NET  1576 = abc_10991_new_n1397
* NET  1577 = abc_10991_new_n1396
* NET  1578 = abc_10991_new_n1395
* NET  1579 = abc_10991_new_n1394
* NET  1580 = abc_10991_new_n1393
* NET  1581 = abc_10991_new_n1392
* NET  1582 = abc_10991_new_n1391
* NET  1583 = abc_10991_new_n1390
* NET  1584 = abc_10991_new_n1389
* NET  1585 = abc_10991_new_n1388
* NET  1586 = abc_10991_new_n1387
* NET  1587 = abc_10991_new_n1386
* NET  1588 = abc_10991_new_n1385
* NET  1589 = abc_10991_new_n1384
* NET  1590 = abc_10991_new_n1383
* NET  1591 = abc_10991_new_n1382
* NET  1592 = abc_10991_new_n1381
* NET  1593 = abc_10991_new_n1380
* NET  1594 = abc_10991_new_n1379
* NET  1595 = abc_10991_new_n1378
* NET  1596 = abc_10991_new_n1376
* NET  1597 = abc_10991_new_n1375
* NET  1598 = abc_10991_new_n1374
* NET  1599 = abc_10991_new_n1373
* NET  1600 = abc_10991_new_n1372
* NET  1601 = abc_10991_new_n1371
* NET  1602 = abc_10991_new_n1370
* NET  1603 = abc_10991_new_n1369
* NET  1604 = abc_10991_new_n1368
* NET  1605 = abc_10991_new_n1367
* NET  1606 = abc_10991_new_n1366
* NET  1607 = abc_10991_new_n1365
* NET  1608 = abc_10991_new_n1364
* NET  1609 = abc_10991_new_n1363
* NET  1610 = abc_10991_new_n1362
* NET  1611 = abc_10991_new_n1361
* NET  1612 = abc_10991_new_n1360
* NET  1613 = abc_10991_new_n1359
* NET  1614 = abc_10991_new_n1358
* NET  1615 = abc_10991_new_n1357
* NET  1616 = abc_10991_new_n1356
* NET  1617 = abc_10991_new_n1355
* NET  1618 = abc_10991_new_n1354
* NET  1619 = abc_10991_new_n1353
* NET  1620 = abc_10991_new_n1352
* NET  1621 = abc_10991_new_n1351
* NET  1622 = abc_10991_new_n1350
* NET  1623 = abc_10991_new_n1349
* NET  1624 = abc_10991_new_n1348
* NET  1625 = abc_10991_new_n1347
* NET  1626 = abc_10991_new_n1346
* NET  1627 = abc_10991_new_n1345
* NET  1628 = abc_10991_new_n1344
* NET  1629 = abc_10991_new_n1343
* NET  1630 = abc_10991_new_n1342
* NET  1631 = abc_10991_new_n1341
* NET  1632 = abc_10991_new_n1340
* NET  1633 = abc_10991_new_n1339
* NET  1634 = abc_10991_new_n1338
* NET  1635 = abc_10991_new_n1337
* NET  1636 = abc_10991_new_n1336
* NET  1637 = abc_10991_new_n1335
* NET  1638 = abc_10991_new_n1334
* NET  1639 = abc_10991_new_n1333
* NET  1640 = abc_10991_new_n1332
* NET  1641 = abc_10991_new_n1331
* NET  1642 = abc_10991_new_n1330
* NET  1643 = abc_10991_new_n1329
* NET  1644 = abc_10991_new_n1328
* NET  1645 = abc_10991_new_n1327
* NET  1646 = abc_10991_new_n1326
* NET  1647 = abc_10991_new_n1325
* NET  1648 = abc_10991_new_n1324
* NET  1649 = abc_10991_new_n1323
* NET  1650 = abc_10991_new_n1322
* NET  1651 = abc_10991_new_n1321
* NET  1652 = abc_10991_new_n1320
* NET  1653 = abc_10991_new_n1319
* NET  1654 = abc_10991_new_n1318
* NET  1655 = abc_10991_new_n1317
* NET  1656 = abc_10991_new_n1316
* NET  1657 = abc_10991_new_n1315
* NET  1658 = abc_10991_new_n1314
* NET  1659 = abc_10991_new_n1313
* NET  1660 = abc_10991_new_n1312
* NET  1661 = abc_10991_new_n1311
* NET  1662 = abc_10991_new_n1310
* NET  1663 = abc_10991_new_n1309
* NET  1664 = abc_10991_new_n1308
* NET  1665 = abc_10991_new_n1307
* NET  1666 = abc_10991_new_n1305
* NET  1667 = abc_10991_new_n1304
* NET  1668 = abc_10991_new_n1303
* NET  1669 = abc_10991_new_n1302
* NET  1670 = abc_10991_new_n1301
* NET  1671 = abc_10991_new_n1300
* NET  1672 = abc_10991_new_n1299
* NET  1673 = abc_10991_new_n1298
* NET  1674 = abc_10991_new_n1297
* NET  1675 = abc_10991_new_n1296
* NET  1676 = abc_10991_new_n1295
* NET  1677 = abc_10991_new_n1294
* NET  1678 = abc_10991_new_n1293
* NET  1679 = abc_10991_new_n1292
* NET  1680 = abc_10991_new_n1291
* NET  1681 = abc_10991_new_n1290
* NET  1682 = abc_10991_new_n1289
* NET  1683 = abc_10991_new_n1288
* NET  1684 = abc_10991_new_n1287
* NET  1685 = abc_10991_new_n1286
* NET  1686 = abc_10991_new_n1285
* NET  1687 = abc_10991_new_n1284
* NET  1688 = abc_10991_new_n1283
* NET  1689 = abc_10991_new_n1282
* NET  1690 = abc_10991_new_n1281
* NET  1691 = abc_10991_new_n1280
* NET  1692 = abc_10991_new_n1279
* NET  1693 = abc_10991_new_n1278
* NET  1694 = abc_10991_new_n1277
* NET  1695 = abc_10991_new_n1276
* NET  1696 = abc_10991_new_n1275
* NET  1697 = abc_10991_new_n1274
* NET  1698 = abc_10991_new_n1273
* NET  1699 = abc_10991_new_n1272
* NET  1700 = abc_10991_new_n1271
* NET  1701 = abc_10991_new_n1270
* NET  1702 = abc_10991_new_n1269
* NET  1703 = abc_10991_new_n1268
* NET  1704 = abc_10991_new_n1267
* NET  1705 = abc_10991_new_n1266
* NET  1706 = abc_10991_new_n1265
* NET  1707 = abc_10991_new_n1264
* NET  1708 = abc_10991_new_n1263
* NET  1709 = abc_10991_new_n1262
* NET  1710 = abc_10991_new_n1261
* NET  1711 = abc_10991_new_n1260
* NET  1712 = abc_10991_new_n1259
* NET  1713 = abc_10991_new_n1258
* NET  1714 = abc_10991_new_n1257
* NET  1715 = abc_10991_new_n1256
* NET  1716 = abc_10991_new_n1255
* NET  1717 = abc_10991_new_n1254
* NET  1718 = abc_10991_new_n1253
* NET  1719 = abc_10991_new_n1252
* NET  1720 = abc_10991_new_n1251
* NET  1721 = abc_10991_new_n1250
* NET  1722 = abc_10991_new_n1249
* NET  1723 = abc_10991_new_n1248
* NET  1724 = abc_10991_new_n1247
* NET  1725 = abc_10991_new_n1246
* NET  1726 = abc_10991_new_n1245
* NET  1727 = abc_10991_new_n1244
* NET  1728 = abc_10991_new_n1243
* NET  1729 = abc_10991_new_n1242
* NET  1730 = abc_10991_new_n1241
* NET  1731 = abc_10991_new_n1240
* NET  1732 = abc_10991_new_n1239
* NET  1733 = abc_10991_new_n1238
* NET  1734 = abc_10991_new_n1237
* NET  1735 = abc_10991_new_n1236
* NET  1736 = abc_10991_new_n1235
* NET  1737 = abc_10991_new_n1234
* NET  1738 = abc_10991_new_n1233
* NET  1739 = abc_10991_new_n1232
* NET  1740 = abc_10991_new_n1231
* NET  1741 = abc_10991_new_n1230
* NET  1742 = abc_10991_new_n1229
* NET  1743 = abc_10991_new_n1228
* NET  1744 = abc_10991_new_n1227
* NET  1745 = abc_10991_new_n1226
* NET  1746 = abc_10991_new_n1225
* NET  1747 = abc_10991_new_n1224
* NET  1748 = abc_10991_new_n1223
* NET  1749 = abc_10991_new_n1222
* NET  1750 = abc_10991_new_n1221
* NET  1751 = abc_10991_new_n1220
* NET  1752 = abc_10991_new_n1219
* NET  1753 = abc_10991_new_n1218
* NET  1754 = abc_10991_new_n1217
* NET  1755 = abc_10991_new_n1216
* NET  1756 = abc_10991_new_n1215
* NET  1757 = abc_10991_new_n1214
* NET  1758 = abc_10991_new_n1213
* NET  1759 = abc_10991_new_n1212
* NET  1760 = abc_10991_new_n1211
* NET  1761 = abc_10991_new_n1210
* NET  1762 = abc_10991_new_n1209
* NET  1763 = abc_10991_new_n1208
* NET  1764 = abc_10991_new_n1207
* NET  1765 = abc_10991_new_n1206
* NET  1766 = abc_10991_new_n1205
* NET  1767 = abc_10991_new_n1204
* NET  1768 = abc_10991_new_n1203
* NET  1769 = abc_10991_new_n1202
* NET  1770 = abc_10991_new_n1201
* NET  1771 = abc_10991_new_n1200
* NET  1772 = abc_10991_new_n1199
* NET  1773 = abc_10991_new_n1198
* NET  1774 = abc_10991_new_n1197
* NET  1775 = abc_10991_new_n1196
* NET  1776 = abc_10991_new_n1195
* NET  1777 = abc_10991_new_n1194
* NET  1778 = abc_10991_new_n1193
* NET  1779 = abc_10991_new_n1192
* NET  1780 = abc_10991_new_n1191
* NET  1781 = abc_10991_new_n1190
* NET  1782 = abc_10991_new_n1189
* NET  1783 = abc_10991_new_n1188
* NET  1784 = abc_10991_new_n1187
* NET  1785 = abc_10991_new_n1186
* NET  1786 = abc_10991_new_n1185
* NET  1787 = abc_10991_new_n1184
* NET  1788 = abc_10991_new_n1183
* NET  1789 = abc_10991_new_n1182
* NET  1790 = abc_10991_new_n1181
* NET  1791 = abc_10991_new_n1180
* NET  1792 = abc_10991_new_n1179
* NET  1793 = abc_10991_new_n1178
* NET  1794 = abc_10991_new_n1177
* NET  1795 = abc_10991_new_n1176
* NET  1796 = abc_10991_new_n1175
* NET  1797 = abc_10991_new_n1174
* NET  1798 = abc_10991_new_n1173
* NET  1799 = abc_10991_new_n1172
* NET  1800 = abc_10991_new_n1171
* NET  1801 = abc_10991_new_n1170
* NET  1802 = abc_10991_new_n1169
* NET  1803 = abc_10991_new_n1168
* NET  1804 = abc_10991_new_n1167
* NET  1805 = abc_10991_new_n1166
* NET  1806 = abc_10991_new_n1165
* NET  1807 = abc_10991_new_n1164
* NET  1808 = abc_10991_new_n1163
* NET  1809 = abc_10991_new_n1162
* NET  1810 = abc_10991_new_n1161
* NET  1811 = abc_10991_new_n1160
* NET  1812 = abc_10991_new_n1159
* NET  1813 = abc_10991_new_n1158
* NET  1814 = abc_10991_new_n1157
* NET  1815 = abc_10991_new_n1156
* NET  1816 = abc_10991_new_n1155
* NET  1817 = abc_10991_new_n1153
* NET  1818 = abc_10991_new_n1152
* NET  1819 = abc_10991_new_n1151
* NET  1820 = abc_10991_new_n1150
* NET  1821 = abc_10991_new_n1149
* NET  1822 = abc_10991_new_n1148
* NET  1823 = abc_10991_new_n1147
* NET  1824 = abc_10991_new_n1146
* NET  1825 = abc_10991_new_n1144
* NET  1826 = abc_10991_new_n1143
* NET  1827 = abc_10991_new_n1142
* NET  1828 = abc_10991_new_n1141
* NET  1829 = abc_10991_new_n1140
* NET  1830 = abc_10991_new_n1139
* NET  1831 = abc_10991_new_n1137
* NET  1832 = abc_10991_new_n1136
* NET  1833 = abc_10991_new_n1135
* NET  1834 = abc_10991_new_n1134
* NET  1835 = abc_10991_new_n1133
* NET  1836 = abc_10991_new_n1132
* NET  1837 = abc_10991_new_n1131
* NET  1838 = abc_10991_new_n1130
* NET  1839 = abc_10991_new_n1129
* NET  1840 = abc_10991_new_n1128
* NET  1841 = abc_10991_new_n1127
* NET  1842 = abc_10991_new_n1126
* NET  1843 = abc_10991_new_n1124
* NET  1844 = abc_10991_new_n1123
* NET  1845 = abc_10991_new_n1122
* NET  1846 = abc_10991_new_n1121
* NET  1847 = abc_10991_new_n1120
* NET  1848 = abc_10991_new_n1118
* NET  1849 = abc_10991_new_n1117
* NET  1850 = abc_10991_new_n1116
* NET  1851 = abc_10991_new_n1115
* NET  1852 = abc_10991_new_n1114
* NET  1853 = abc_10991_new_n1113
* NET  1854 = abc_10991_new_n1112
* NET  1855 = abc_10991_new_n1111
* NET  1856 = abc_10991_new_n1109
* NET  1857 = abc_10991_new_n1108
* NET  1858 = abc_10991_new_n1107
* NET  1859 = abc_10991_new_n1106
* NET  1860 = abc_10991_new_n1105
* NET  1861 = abc_10991_new_n1104
* NET  1862 = abc_10991_new_n1102
* NET  1863 = abc_10991_new_n1101
* NET  1864 = abc_10991_new_n1100
* NET  1865 = abc_10991_new_n1099
* NET  1866 = abc_10991_new_n1098
* NET  1867 = abc_10991_new_n1097
* NET  1868 = abc_10991_new_n1096
* NET  1869 = abc_10991_new_n1095
* NET  1870 = abc_10991_new_n1094
* NET  1871 = abc_10991_new_n1093
* NET  1872 = abc_10991_new_n1092
* NET  1873 = abc_10991_new_n1091
* NET  1874 = abc_10991_new_n1089
* NET  1875 = abc_10991_new_n1088
* NET  1876 = abc_10991_new_n1087
* NET  1877 = abc_10991_new_n1086
* NET  1878 = abc_10991_new_n1085
* NET  1879 = abc_10991_new_n1084
* NET  1880 = abc_10991_new_n1083
* NET  1881 = abc_10991_new_n1082
* NET  1882 = abc_10991_new_n1081
* NET  1883 = abc_10991_new_n1080
* NET  1884 = abc_10991_new_n1079
* NET  1885 = abc_10991_new_n1078
* NET  1886 = abc_10991_new_n1077
* NET  1887 = abc_10991_new_n1075
* NET  1888 = abc_10991_new_n1074
* NET  1889 = abc_10991_new_n1073
* NET  1890 = abc_10991_new_n1072
* NET  1891 = abc_10991_new_n1071
* NET  1892 = abc_10991_new_n1070
* NET  1893 = abc_10991_new_n1069
* NET  1894 = abc_10991_new_n1068
* NET  1895 = abc_10991_new_n1067
* NET  1896 = abc_10991_new_n1066
* NET  1897 = abc_10991_new_n1065
* NET  1898 = abc_10991_new_n1063
* NET  1899 = abc_10991_new_n1062
* NET  1900 = abc_10991_new_n1061
* NET  1901 = abc_10991_new_n1060
* NET  1902 = abc_10991_new_n1059
* NET  1903 = abc_10991_new_n1058
* NET  1904 = abc_10991_new_n1057
* NET  1905 = abc_10991_new_n1056
* NET  1906 = abc_10991_new_n1055
* NET  1907 = abc_10991_new_n1054
* NET  1908 = abc_10991_new_n1053
* NET  1909 = abc_10991_new_n1051
* NET  1910 = abc_10991_new_n1050
* NET  1911 = abc_10991_new_n1049
* NET  1912 = abc_10991_new_n1048
* NET  1913 = abc_10991_new_n1047
* NET  1914 = abc_10991_new_n1046
* NET  1915 = abc_10991_new_n1045
* NET  1916 = abc_10991_new_n1044
* NET  1917 = abc_10991_new_n1043
* NET  1918 = abc_10991_new_n1042
* NET  1919 = abc_10991_new_n1040
* NET  1920 = abc_10991_new_n1039
* NET  1921 = abc_10991_new_n1038
* NET  1922 = abc_10991_new_n1037
* NET  1923 = abc_10991_new_n1036
* NET  1924 = abc_10991_new_n1035
* NET  1925 = abc_10991_new_n1034
* NET  1926 = abc_10991_new_n1033
* NET  1927 = abc_10991_new_n1032
* NET  1928 = abc_10991_new_n1031
* NET  1929 = abc_10991_new_n1030
* NET  1930 = abc_10991_new_n1029
* NET  1931 = abc_10991_new_n1027
* NET  1932 = abc_10991_new_n1026
* NET  1933 = abc_10991_new_n1025
* NET  1934 = abc_10991_new_n1024
* NET  1935 = abc_10991_new_n1023
* NET  1936 = abc_10991_new_n1022
* NET  1937 = abc_10991_new_n1021
* NET  1938 = abc_10991_new_n1020
* NET  1939 = abc_10991_new_n1019
* NET  1940 = abc_10991_new_n1018
* NET  1941 = abc_10991_new_n1017
* NET  1942 = abc_10991_new_n1015
* NET  1943 = abc_10991_new_n1014
* NET  1944 = abc_10991_new_n1013
* NET  1945 = abc_10991_new_n1012
* NET  1946 = abc_10991_new_n1011
* NET  1947 = abc_10991_new_n1010
* NET  1948 = abc_10991_new_n1009
* NET  1949 = abc_10991_new_n1008
* NET  1950 = abc_10991_new_n1007
* NET  1951 = abc_10991_new_n1006
* NET  1952 = abc_10991_new_n1004
* NET  1953 = abc_10991_new_n1003
* NET  1954 = abc_10991_new_n1002
* NET  1955 = abc_10991_new_n1001
* NET  1956 = abc_10991_new_n1000
* NET  1957 = WE
* NET  1958 = RDY
* NET  1959 = NMI
* NET  1960 = MOS6502_write_back
* NET  1961 = MOS6502_store
* NET  1962 = MOS6502_state[5]
* NET  1963 = MOS6502_state[4]
* NET  1964 = MOS6502_state[3]
* NET  1965 = MOS6502_state[2]
* NET  1966 = MOS6502_state[1]
* NET  1967 = MOS6502_state[0]
* NET  1968 = MOS6502_src_reg[1]
* NET  1969 = MOS6502_src_reg[0]
* NET  1970 = MOS6502_shift_right
* NET  1971 = MOS6502_shift
* NET  1972 = MOS6502_sei
* NET  1973 = MOS6502_sed
* NET  1974 = MOS6502_sec
* NET  1975 = MOS6502_rotate
* NET  1976 = MOS6502_res
* NET  1977 = MOS6502_plp
* NET  1978 = MOS6502_php
* NET  1979 = MOS6502_op[3]
* NET  1980 = MOS6502_op[2]
* NET  1981 = MOS6502_op[1]
* NET  1982 = MOS6502_op[0]
* NET  1983 = MOS6502_load_reg
* NET  1984 = MOS6502_load_only
* NET  1985 = MOS6502_index_y
* NET  1986 = MOS6502_inc
* NET  1987 = MOS6502_dst_reg[1]
* NET  1988 = MOS6502_dst_reg[0]
* NET  1989 = MOS6502_cond_code[2]
* NET  1990 = MOS6502_cond_code[1]
* NET  1991 = MOS6502_cond_code[0]
* NET  1992 = MOS6502_compare
* NET  1993 = MOS6502_clv
* NET  1994 = MOS6502_cli
* NET  1995 = MOS6502_cld
* NET  1996 = MOS6502_clc
* NET  1997 = MOS6502_bit_ins
* NET  1998 = MOS6502_backwards
* NET  1999 = MOS6502_adj_bcd
* NET  2000 = MOS6502_adc_sbc
* NET  2001 = MOS6502_adc_bcd
* NET  2002 = MOS6502_Z
* NET  2003 = MOS6502_V
* NET  2004 = MOS6502_PC[9]
* NET  2005 = MOS6502_PC[8]
* NET  2006 = MOS6502_PC[7]
* NET  2007 = MOS6502_PC[6]
* NET  2008 = MOS6502_PC[5]
* NET  2009 = MOS6502_PC[4]
* NET  2010 = MOS6502_PC[3]
* NET  2011 = MOS6502_PC[2]
* NET  2012 = MOS6502_PC[15]
* NET  2013 = MOS6502_PC[14]
* NET  2014 = MOS6502_PC[13]
* NET  2015 = MOS6502_PC[12]
* NET  2016 = MOS6502_PC[11]
* NET  2017 = MOS6502_PC[10]
* NET  2018 = MOS6502_PC[1]
* NET  2019 = MOS6502_PC[0]
* NET  2020 = MOS6502_NMI_edge
* NET  2021 = MOS6502_NMI_1
* NET  2022 = MOS6502_N
* NET  2023 = MOS6502_IRHOLD_valid
* NET  2024 = MOS6502_IRHOLD[7]
* NET  2025 = MOS6502_IRHOLD[6]
* NET  2026 = MOS6502_IRHOLD[5]
* NET  2027 = MOS6502_IRHOLD[4]
* NET  2028 = MOS6502_IRHOLD[3]
* NET  2029 = MOS6502_IRHOLD[2]
* NET  2030 = MOS6502_IRHOLD[1]
* NET  2031 = MOS6502_IRHOLD[0]
* NET  2032 = MOS6502_I
* NET  2033 = MOS6502_D
* NET  2034 = MOS6502_C
* NET  2035 = MOS6502_AXYS_3_7
* NET  2036 = MOS6502_AXYS_3_6
* NET  2037 = MOS6502_AXYS_3_5
* NET  2038 = MOS6502_AXYS_3_4
* NET  2039 = MOS6502_AXYS_3_3
* NET  2040 = MOS6502_AXYS_3_2
* NET  2041 = MOS6502_AXYS_3_1
* NET  2042 = MOS6502_AXYS_3_0
* NET  2043 = MOS6502_AXYS_2_7
* NET  2044 = MOS6502_AXYS_2_6
* NET  2045 = MOS6502_AXYS_2_5
* NET  2046 = MOS6502_AXYS_2_4
* NET  2047 = MOS6502_AXYS_2_3
* NET  2048 = MOS6502_AXYS_2_2
* NET  2049 = MOS6502_AXYS_2_1
* NET  2050 = MOS6502_AXYS_2_0
* NET  2051 = MOS6502_AXYS_1_7
* NET  2052 = MOS6502_AXYS_1_6
* NET  2053 = MOS6502_AXYS_1_5
* NET  2054 = MOS6502_AXYS_1_4
* NET  2055 = MOS6502_AXYS_1_3
* NET  2056 = MOS6502_AXYS_1_2
* NET  2057 = MOS6502_AXYS_1_1
* NET  2058 = MOS6502_AXYS_1_0
* NET  2059 = MOS6502_AXYS_0_7
* NET  2060 = MOS6502_AXYS_0_6
* NET  2061 = MOS6502_AXYS_0_5
* NET  2062 = MOS6502_AXYS_0_4
* NET  2063 = MOS6502_AXYS_0_3
* NET  2064 = MOS6502_AXYS_0_2
* NET  2065 = MOS6502_AXYS_0_1
* NET  2066 = MOS6502_AXYS_0_0
* NET  2067 = MOS6502_ALU_OUT[7]
* NET  2068 = MOS6502_ALU_OUT[6]
* NET  2069 = MOS6502_ALU_OUT[5]
* NET  2070 = MOS6502_ALU_OUT[4]
* NET  2071 = MOS6502_ALU_OUT[3]
* NET  2072 = MOS6502_ALU_OUT[2]
* NET  2073 = MOS6502_ALU_OUT[1]
* NET  2074 = MOS6502_ALU_OUT[0]
* NET  2075 = MOS6502_ALU_N
* NET  2076 = MOS6502_ALU_HC
* NET  2077 = MOS6502_ALU_CO
* NET  2078 = MOS6502_ALU_BI7
* NET  2079 = MOS6502_ALU_AI7
* NET  2080 = MOS6502_ABL[7]
* NET  2081 = MOS6502_ABL[6]
* NET  2082 = MOS6502_ABL[5]
* NET  2083 = MOS6502_ABL[4]
* NET  2084 = MOS6502_ABL[3]
* NET  2085 = MOS6502_ABL[2]
* NET  2086 = MOS6502_ABL[1]
* NET  2087 = MOS6502_ABL[0]
* NET  2088 = MOS6502_ABH[7]
* NET  2089 = MOS6502_ABH[6]
* NET  2090 = MOS6502_ABH[5]
* NET  2091 = MOS6502_ABH[4]
* NET  2092 = MOS6502_ABH[3]
* NET  2093 = MOS6502_ABH[2]
* NET  2094 = MOS6502_ABH[1]
* NET  2095 = MOS6502_ABH[0]
* NET  2096 = IRQ
* NET  2097 = DO[7]
* NET  2098 = DO[6]
* NET  2099 = DO[5]
* NET  2100 = DO[4]
* NET  2101 = DO[3]
* NET  2102 = DO[2]
* NET  2103 = DO[1]
* NET  2104 = DO[0]
* NET  2105 = DI[7]
* NET  2106 = DI[6]
* NET  2107 = DI[5]
* NET  2108 = DI[4]
* NET  2109 = DI[3]
* NET  2110 = DI[2]
* NET  2111 = DI[1]
* NET  2112 = DI[0]
* NET  2113 = A[9]
* NET  2114 = A[8]
* NET  2115 = A[7]
* NET  2116 = A[6]
* NET  2117 = A[5]
* NET  2118 = A[4]
* NET  2119 = A[3]
* NET  2120 = A[2]
* NET  2121 = A[15]
* NET  2122 = A[14]
* NET  2123 = A[13]
* NET  2124 = A[12]
* NET  2125 = A[11]
* NET  2126 = A[10]
* NET  2127 = A[1]
* NET  2128 = A[0]

xfeed_264 1 0 decap_w0
xsubckt_2005_dff_x1 1 0 210 57 2092 dff_x1
xsubckt_1815_and21nor_x0 1 0 943 944 945 1119 and21nor_x0
xsubckt_1806_and3_x1 1 0 952 953 954 1181 and3_x1
xsubckt_1362_and4_x1 1 0 1348 1752 1804 1805 324 and4_x1
xsubckt_498_nand4_x0 1 0 387 671 673 677 2056 nand4_x0
xsubckt_444_nand3_x0 1 0 432 443 450 2092 nand3_x0
xsubckt_431_nand3_x0 1 0 442 444 448 449 nand3_x0
xsubckt_74_inv_x0 1 0 1967 789 inv_x0
xsubckt_659_or2_x1 1 0 242 243 246 or2_x1
xsubckt_985_nand3_x0 1 0 1677 299 751 842 nand3_x0
xfeed_265 1 0 decap_w0
xfeed_148 1 0 decap_w0
xsubckt_1803_and3_x1 1 0 955 1125 1129 2107 and3_x1
xsubckt_1597_or3_x1 1 0 1156 604 688 750 or3_x1
xsubckt_1447_and21nor_x0 1 0 151 1290 1281 1285 and21nor_x0
xsubckt_1425_or21nand_x0 1 0 1299 1412 1588 683 or21nand_x0
xsubckt_592_and3_x1 1 0 303 323 683 2087 and3_x1
xsubckt_541_or21nand_x0 1 0 349 2118 441 840 or21nand_x0
xsubckt_383_and3_x1 1 0 490 491 633 634 and3_x1
xsubckt_318_and3_x1 1 0 549 587 610 2017 and3_x1
xsubckt_991_nand3_x0 1 0 1671 327 717 746 nand3_x0
xsubckt_1160_and3_x1 1 0 1506 1507 1508 1509 and3_x1
xfeed_266 1 0 decap_w0
xsubckt_1983_dff_x1 1 0 189 46 2025 dff_x1
xsubckt_1936_dff_x1 1 0 91 74 2047 dff_x1
xsubckt_1686_nand2_x0 1 0 1068 1070 1076 nand2_x0
xsubckt_1517_nand3_x0 1 0 1223 1224 1225 1886 nand3_x0
xsubckt_1480_and3_x1 1 0 1256 466 702 771 and3_x1
xsubckt_550_nand3_x0 1 0 341 587 610 2008 nand3_x0
xsubckt_353_and3_x1 1 0 518 648 717 2089 and3_x1
xsubckt_731_nand2_x0 1 0 1919 1921 299 nand2_x0
xsubckt_740_or21nand_x0 1 0 1911 847 306 1913 or21nand_x0
xsubckt_777_mux2_x1 1 0 2112 2074 735 1877 mux2_x1
xsubckt_925_nand3_x0 1 0 1737 1739 1764 1816 nand3_x0
xsubckt_1122_nand3_x0 1 0 1542 1543 1741 1768 nand3_x0
xfeed_267 1 0 decap_w0
xsubckt_1650_or21nand_x0 1 0 1103 1106 1110 1158 or21nand_x0
xsubckt_1543_nand3_x0 1 0 1199 704 743 1971 nand3_x0
xsubckt_1313_mux2_x1 1 0 1877 1388 1389 110 mux2_x1
xsubckt_526_nand3_x0 1 0 362 443 450 836 nand3_x0
xsubckt_53_inv_x0 1 0 2106 810 inv_x0
xsubckt_778_or21nand_x0 1 0 1876 665 1880 1878 or21nand_x0
xsubckt_830_and2_x1 1 0 1830 2044 840 and2_x1
xsubckt_975_nand3_x0 1 0 1687 327 619 842 nand3_x0
xsubckt_1256_nand2_x0 1 0 1423 1875 669 nand2_x0
xfeed_260 1 0 tie
xspare_buffer_68 1 0 36 35 buf_x4
xsubckt_1778_and21nor_x0 1 0 979 2107 1147 524 and21nor_x0
xsubckt_1745_nand2_x0 1 0 1011 1012 1013 nand2_x0
xsubckt_1677_mux2_x1 1 0 1079 1084 1160 1077 mux2_x1
xsubckt_1335_and4_x1 1 0 1374 1375 1591 1757 1807 and4_x1
xsubckt_1288_or21nand_x0 1 0 158 1411 1405 1408 or21nand_x0
xsubckt_485_or21nand_x0 1 0 398 778 668 400 or21nand_x0
xsubckt_151_nand4_x0 1 0 712 715 717 786 1964 nand4_x0
xsubckt_34_inv_x0 1 0 2018 829 inv_x0
xsubckt_245_nand4_x0 1 0 618 732 788 1967 1963 nand4_x0
xsubckt_307_and4_x1 1 0 558 560 561 636 725 and4_x1
xsubckt_730_and2_x1 1 0 1920 1924 1932 and2_x1
xfeed_261 1 0 decap_w0
xspare_buffer_69 1 0 36 34 buf_x4
xsubckt_1869_nor2_x0 1 0 891 892 893 nor2_x0
xsubckt_1624_and2_x1 1 0 1129 1151 457 and2_x1
xsubckt_1414_and21nor_x0 1 0 1309 1373 1414 682 and21nor_x0
xsubckt_600_nand2_x0 1 0 296 327 2018 nand2_x0
xsubckt_336_and21nor_x0 1 0 533 602 607 850 and21nor_x0
xsubckt_120_and2_x1 1 0 743 841 1962 and2_x1
xsubckt_99_inv_x0 1 0 1993 764 inv_x0
xsubckt_24_inv_x0 1 0 2087 839 inv_x0
xsubckt_797_and2_x1 1 0 1859 1870 801 and2_x1
xsubckt_1071_nand3_x0 1 0 1593 1594 1693 1793 nand3_x0
xfeed_262 1 0 decap_w0
xsubckt_2025_dff_x1 1 0 176 61 2012 dff_x1
xsubckt_1875_nand2_x0 1 0 885 886 907 nand2_x0
xsubckt_1596_nand2_x0 1 0 1157 446 818 nand2_x0
xsubckt_1585_and3_x1 1 0 1168 1169 1171 701 and3_x1
xsubckt_1523_nor2_x0 1 0 184 1218 1220 nor2_x0
xsubckt_1457_nand2_x0 1 0 1272 466 702 nand2_x0
xsubckt_159_and3_x1 1 0 704 723 1966 789 and3_x1
xsubckt_192_and2_x1 1 0 671 672 687 and2_x1
xsubckt_822_and2_x1 1 0 1837 1838 1840 and2_x1
xsubckt_1026_or21nand_x0 1 0 1637 1752 1797 324 or21nand_x0
xsubckt_1255_or21nand_x0 1 0 1424 1882 668 840 or21nand_x0
xfeed_263 1 0 tie
xsubckt_1632_and21nor_x0 1 0 1121 1981 1183 1133 and21nor_x0
xsubckt_1290_and3_x1 1 0 1403 1756 1815 324 and3_x1
xsubckt_44_inv_x0 1 0 2046 819 inv_x0
xsubckt_647_and2_x1 1 0 253 254 643 and2_x1
xsubckt_1004_and4_x1 1 0 1659 1804 1806 1808 324 and4_x1
xsubckt_1079_or4_x1 1 0 1585 1586 1587 1599 1628 or4_x1
xsubckt_1232_or21nand_x0 1 0 2099 343 1484 1443 or21nand_x0
xfeed_141 1 0 decap_w0
xspare_buffer_64 1 0 49 39 buf_x4
xsubckt_1514_or21nand_x0 1 0 1226 785 663 758 or21nand_x0
xsubckt_445_and21nor_x0 1 0 210 432 433 14 and21nor_x0
xsubckt_718_nand3_x0 1 0 1931 1932 1933 299 nand3_x0
xsubckt_854_mux2_x1 1 0 2110 2029 2023 1808 mux2_x1
xfeed_140 1 0 decap_w0
xspare_buffer_65 1 0 49 38 buf_x4
xsubckt_1817_and2_x1 1 0 941 942 1160 and2_x1
xsubckt_1444_and2_x1 1 0 1283 1316 1806 and2_x1
xsubckt_1314_and2_x1 1 0 1387 2065 840 and2_x1
xsubckt_826_or21nand_x0 1 0 1833 665 1880 1842 or21nand_x0
xsubckt_1036_and3_x1 1 0 1627 327 704 740 and3_x1
xsubckt_1168_and3_x1 1 0 1499 1500 1537 1746 and3_x1
xfeed_143 1 0 tie
xspare_buffer_66 1 0 49 37 buf_x4
xsubckt_1409_nand3_x0 1 0 1313 682 1961 840 nand3_x0
xsubckt_1354_nand2_x0 1 0 1355 1591 1750 nand2_x0
xsubckt_482_and4_x1 1 0 401 671 673 677 2057 and4_x1
xsubckt_278_nand2_x0 1 0 585 609 2068 nand2_x0
xsubckt_842_nand3_x0 1 0 1819 737 740 862 nand3_x0
xsubckt_1109_and21nor_x0 1 0 1555 1764 1587 1556 and21nor_x0
xfeed_142 1 0 decap_w0
xspare_buffer_67 1 0 11 7 buf_x4
xsubckt_1962_dff_x1 1 0 156 47 1992 dff_x1
xsubckt_1917_dff_x1 1 0 96 74 2052 dff_x1
xsubckt_1636_and3_x1 1 0 1117 1121 1124 1130 and3_x1
xsubckt_1445_or21nand_x0 1 0 1282 1315 1590 1766 or21nand_x0
xsubckt_1404_and4_x1 1 0 1316 1753 1756 1797 324 and4_x1
xsubckt_532_or21nand_x0 1 0 357 776 668 359 or21nand_x0
xsubckt_451_and21nor_x0 1 0 208 428 429 14 and21nor_x0
xsubckt_132_and3_x1 1 0 731 732 1966 789 and3_x1
xsubckt_673_nand2_x0 1 0 230 327 2005 nand2_x0
xsubckt_868_and3_x1 1 0 1794 1795 1797 324 and3_x1
xsubckt_1064_and2_x1 1 0 1599 1600 1814 and2_x1
xfeed_268 1 0 decap_w0
xspare_buffer_60 1 0 49 42 buf_x4
xsubckt_1941_dff_x1 1 0 1959 37 2021 dff_x1
xsubckt_1899_and21nor_x0 1 0 864 865 872 830 and21nor_x0
xsubckt_1442_and3_x1 1 0 1285 682 782 840 and3_x1
xsubckt_593_and21nor_x0 1 0 302 2074 310 303 and21nor_x0
xsubckt_49_inv_x0 1 0 2110 814 inv_x0
xsubckt_319_and21nor_x0 1 0 548 622 627 814 and21nor_x0
xsubckt_719_nand2_x0 1 0 180 1931 1941 nand2_x0
xsubckt_1042_nand2_x0 1 0 1621 1760 1802 nand2_x0
xfeed_269 1 0 decap_w0
xfeed_144 1 0 tie
xspare_buffer_61 1 0 49 41 buf_x4
xsubckt_1729_nand3_x0 1 0 1027 717 746 2010 nand3_x0
xsubckt_1531_or3_x1 1 0 1210 1226 1997 807 or3_x1
xsubckt_1429_and3_x1 1 0 1296 1400 1640 1762 and3_x1
xsubckt_573_and2_x1 1 0 322 324 683 and2_x1
xsubckt_513_and4_x1 1 0 374 671 673 678 2063 and4_x1
xsubckt_478_and4_x1 1 0 405 671 673 678 2065 and4_x1
xsubckt_281_and2_x1 1 0 582 583 584 and2_x1
xsubckt_316_nor4_x0 1 0 550 551 553 554 555 nor4_x0
xsubckt_1014_and3_x1 1 0 1649 299 717 746 and3_x1
xsubckt_1061_and3_x1 1 0 1602 1808 1811 324 and3_x1
xsubckt_1251_nand3_x0 1 0 1427 655 743 2110 nand3_x0
xfeed_147 1 0 decap_w0
xspare_buffer_62 1 0 49 40 buf_x4
xsubckt_1943_dff_x1 1 0 155 38 1991 dff_x1
xsubckt_1840_and21nor_x0 1 0 919 926 928 1131 and21nor_x0
xsubckt_1786_nand3_x0 1 0 971 973 1017 1019 nand3_x0
xsubckt_1681_and2_x1 1 0 1073 1178 1182 and2_x1
xsubckt_1394_nand2_x0 1 0 1323 1324 1327 nand2_x0
xsubckt_425_and21nor_x0 1 0 448 746 740 606 and21nor_x0
xsubckt_69_inv_x0 1 0 2068 794 inv_x0
xsubckt_317_nand2_x0 1 0 2113 550 556 nand2_x0
xsubckt_1067_nand3_x0 1 0 1596 1598 1603 1611 nand3_x0
xfeed_146 1 0 tie
xspare_buffer_63 1 0 11 8 buf_x4
xsubckt_1614_and21nor_x0 1 0 1139 2112 1147 562 and21nor_x0
xsubckt_1519_nand2_x0 1 0 1221 1222 607 nand2_x0
xsubckt_1378_nand3_x0 1 0 1336 1591 1750 1766 nand3_x0
xsubckt_633_nand2_x0 1 0 265 266 299 nand2_x0
xsubckt_411_and3_x1 1 0 462 486 631 632 and3_x1
xsubckt_279_or21nand_x0 1 0 584 593 600 2081 or21nand_x0
xsubckt_1161_nor3_x0 1 0 1505 1548 1563 1742 nor3_x0
xsubckt_1249_mux2_x1 1 0 801 800 1430 1429 mux2_x1
xspare_feed_109 1 0 tie
xsubckt_1996_dff_x1 1 0 203 61 2085 dff_x1
xsubckt_1909_dff_x1 1 0 104 72 2060 dff_x1
xsubckt_1838_and2_x1 1 0 921 922 1072 and2_x1
xsubckt_1604_nand2_x0 1 0 1149 1151 637 nand2_x0
xsubckt_1482_and3_x1 1 0 1255 466 702 770 and3_x1
xsubckt_636_and21nor_x0 1 0 263 306 598 824 and21nor_x0
xsubckt_438_or21nand_x0 1 0 436 442 451 2113 or21nand_x0
xsubckt_676_nand2_x0 1 0 227 599 2074 nand2_x0
xsubckt_759_nand2_x0 1 0 1894 599 2067 nand2_x0
xsubckt_870_nor2_x0 1 0 1792 1961 2077 nor2_x0
xsubckt_927_nand3_x0 1 0 1735 327 711 717 nand3_x0
xsubckt_1224_nand4_x0 1 0 1449 717 737 797 826 nand4_x0
xspare_feed_108 1 0 decap_w0
xsubckt_1700_and21nor_x0 1 0 1055 1059 1061 1131 and21nor_x0
xsubckt_1563_and2_x1 1 0 1186 2052 840 and2_x1
xsubckt_432_and2_x1 1 0 441 443 450 and2_x1
xsubckt_238_nand3_x0 1 0 625 715 717 732 nand3_x0
xsubckt_732_or21nand_x0 1 0 179 1919 1920 1930 or21nand_x0
xsubckt_735_nand3_x0 1 0 1916 323 683 2090 nand3_x0
xsubckt_765_nand4_x0 1 0 1888 1890 1901 1911 1922 nand4_x0
xsubckt_780_nand3_x0 1 0 1874 1877 1881 666 nand3_x0
xsubckt_1994_dff_x1 1 0 205 58 2087 dff_x1
xsubckt_1372_and3_x1 1 0 1341 1373 1756 1796 and3_x1
xsubckt_1303_or21nand_x0 1 0 159 1406 1398 1394 or21nand_x0
xsubckt_565_nand3_x0 1 0 329 443 450 861 nand3_x0
xsubckt_407_nand2_x0 1 0 466 630 743 nand2_x0
xsubckt_398_and2_x1 1 0 475 592 607 and2_x1
xsubckt_65_inv_x0 1 0 2033 798 inv_x0
xsubckt_171_nand4_x0 1 0 692 717 732 1966 789 nand4_x0
xsubckt_263_nand2_x0 1 0 600 602 607 nand2_x0
xsubckt_943_nand3_x0 1 0 1719 299 737 740 nand3_x0
xsubckt_1199_or4_x1 1 0 1470 1471 1472 1476 1480 or4_x1
xsubckt_1244_nor4_x0 1 0 1432 1433 1434 1435 1436 nor4_x0
xsubckt_1678_mux2_x1 1 0 1078 1083 1160 1076 mux2_x1
xsubckt_1507_nand3_x0 1 0 1232 655 743 813 nand3_x0
xsubckt_419_or21nand_x0 1 0 454 619 456 455 or21nand_x0
xsubckt_208_and3_x1 1 0 655 715 1965 787 and3_x1
xsubckt_163_and4_x1 1 0 700 702 728 741 749 and4_x1
xsubckt_197_and21nor_x0 1 0 666 671 673 677 and21nor_x0
xsubckt_1015_nand2_x0 1 0 1648 1649 1650 nand2_x0
xsubckt_1073_and3_x1 1 0 1591 1803 1806 324 and3_x1
xsubckt_1626_and4_x1 1 0 1127 1128 603 727 749 and4_x1
xsubckt_1546_or21nand_x0 1 0 1196 654 1200 1197 or21nand_x0
xsubckt_1287_nand2_x0 1 0 1405 1407 1750 nand2_x0
xsubckt_487_nand3_x0 1 0 396 587 610 2018 nand3_x0
xsubckt_387_or21nand_x0 1 0 486 743 740 489 or21nand_x0
xsubckt_756_nand2_x0 1 0 1897 327 2012 nand2_x0
xsubckt_761_and21nor_x0 1 0 1892 2105 461 1893 and21nor_x0
xsubckt_859_mux2_x1 1 0 2111 2030 2023 1803 mux2_x1
xsubckt_892_and4_x1 1 0 1770 1771 1772 1774 1775 and4_x1
xsubckt_1238_and21nor_x0 1 0 1437 659 1485 1438 and21nor_x0
xspare_feed_59 1 0 tie
xsubckt_1887_and2_x1 1 0 873 874 876 and2_x1
xsubckt_1559_and2_x1 1 0 1188 2054 840 and2_x1
xsubckt_252_and3_x1 1 0 611 612 614 690 and3_x1
xsubckt_744_nand2_x0 1 0 1908 327 2013 nand2_x0
xsubckt_791_mux2_x1 1 0 2111 1865 735 1864 mux2_x1
xsubckt_882_nand3_x0 1 0 1780 740 747 787 nand3_x0
xspare_feed_58 1 0 tie
xsubckt_1801_or21nand_x0 1 0 957 989 966 961 or21nand_x0
xsubckt_1316_and2_x1 1 0 1386 2064 840 and2_x1
xsubckt_590_or21nand_x0 1 0 305 307 310 321 or21nand_x0
xsubckt_395_and2_x1 1 0 478 692 718 and2_x1
xsubckt_355_or2_x1 1 0 516 518 519 or2_x1
xsubckt_143_nand4_x0 1 0 720 752 1964 841 1962 nand4_x0
xsubckt_179_nand3_x0 1 0 684 723 752 842 nand3_x0
xsubckt_918_nand4_x0 1 0 1744 1791 299 624 740 nand4_x0
xsubckt_1139_nand4_x0 1 0 1526 711 717 1958 840 nand4_x0
xspare_feed_101 1 0 tie
xspare_feed_57 1 0 tie
xsubckt_1653_and21nor_x0 1 0 1101 1159 1105 1110 and21nor_x0
xsubckt_1556_mux2_x1 1 0 1856 1190 1193 100 mux2_x1
xsubckt_547_and2_x1 1 0 344 345 346 and2_x1
xsubckt_100_inv_x0 1 0 1973 763 inv_x0
xspare_feed_100 1 0 tie
xspare_feed_56 1 0 tie
xsubckt_1884_nand3_x0 1 0 876 878 883 894 nand3_x0
xsubckt_95_inv_x0 1 0 2030 768 inv_x0
xsubckt_28_inv_x0 1 0 2083 835 inv_x0
xsubckt_304_nand3_x0 1 0 561 648 717 2095 nand3_x0
xsubckt_763_nand2_x0 1 0 1890 1892 1896 nand2_x0
xsubckt_1049_or3_x1 1 0 1614 326 693 841 or3_x1
xspare_feed_103 1 0 tie
xspare_feed_55 1 0 tie
xsubckt_1846_mux2_x1 1 0 915 918 948 913 mux2_x1
xsubckt_1808_and21nor_x0 1 0 950 2106 1147 518 and21nor_x0
xsubckt_1658_nand3_x0 1 0 1096 1125 1129 2111 nand3_x0
xsubckt_1510_mux2_x1 1 0 862 805 1252 1230 mux2_x1
xsubckt_1450_and2_x1 1 0 1278 1279 1629 and2_x1
xsubckt_1358_nor2_x0 1 0 146 1356 1378 nor2_x0
xsubckt_612_or21nand_x0 1 0 285 305 599 2011 or21nand_x0
xsubckt_450_or21nand_x0 1 0 428 442 451 2123 or21nand_x0
xsubckt_50_inv_x0 1 0 2109 813 inv_x0
xsubckt_265_nand4_x0 1 0 598 715 717 1965 787 nand4_x0
xsubckt_682_nexor2_x0 1 0 224 232 221 nexor2_x0
xsubckt_798_nexor2_x0 1 0 1871 801 1858 nexor2_x0
xsubckt_803_or21nand_x0 1 0 1854 1867 1859 1860 or21nand_x0
xsubckt_804_nexor2_x0 1 0 1869 799 1853 nexor2_x0
xsubckt_1018_and2_x1 1 0 1645 1646 1647 and2_x1
xsubckt_1143_nand4_x0 1 0 1522 327 699 841 1962 nand4_x0
xspare_feed_102 1 0 decap_w0
xspare_feed_54 1 0 tie
xsubckt_1849_or21nand_x0 1 0 910 862 1148 508 or21nand_x0
xsubckt_1449_and21nor_x0 1 0 1279 1376 1802 682 and21nor_x0
xsubckt_1390_and4_x1 1 0 1327 752 1964 841 842 and4_x1
xsubckt_17_inv_x0 1 0 2089 846 inv_x0
xsubckt_867_nor3_x0 1 0 1795 1805 1808 1811 nor3_x0
xsubckt_931_nand3_x0 1 0 1731 327 655 743 nand3_x0
xsubckt_944_nand3_x0 1 0 1718 327 714 740 nand3_x0
xsubckt_1035_and4_x1 1 0 1628 1630 1762 1807 1813 and4_x1
xsubckt_1181_and4_x1 1 0 1487 639 643 656 729 and4_x1
xspare_feed_105 1 0 decap_w0
xspare_feed_53 1 0 tie
xsubckt_1905_dff_x1 1 0 108 68 2064 dff_x1
xsubckt_1511_or2_x1 1 0 1229 1430 2067 or2_x1
xsubckt_549_nand3_x0 1 0 342 344 347 348 nand3_x0
xsubckt_507_and2_x1 1 0 378 379 382 and2_x1
xsubckt_141_and4_x1 1 0 722 723 752 841 1962 and4_x1
xsubckt_67_inv_x0 1 0 2070 796 inv_x0
xsubckt_298_nand2_x0 1 0 566 567 568 nand2_x0
xsubckt_841_nand2_x0 1 0 1820 1821 735 nand2_x0
xsubckt_1065_nand3_x0 1 0 1598 1600 1764 1814 nand3_x0
xspare_feed_104 1 0 tie
xspare_feed_52 1 0 tie
xsubckt_324_or4_x1 1 0 543 544 546 547 548 or4_x1
xsubckt_308_nand3_x0 1 0 557 587 610 2005 nand3_x0
xsubckt_739_and2_x1 1 0 1912 1913 1917 and2_x1
xsubckt_806_nand2_x0 1 0 1851 1852 735 nand2_x0
xsubckt_831_nand4_x0 1 0 1829 2001 1999 2068 2077 nand4_x0
xspare_feed_107 1 0 tie
xspare_feed_51 1 0 tie
xsubckt_1609_and2_x1 1 0 1144 1145 1152 and2_x1
xsubckt_1469_nor3_x0 1 0 193 1264 1265 10 nor3_x0
xsubckt_1400_or21nand_x0 1 0 1319 1320 1321 683 or21nand_x0
xsubckt_1398_and3_x1 1 0 1321 1373 1400 1756 and3_x1
xsubckt_437_nand3_x0 1 0 437 443 450 2094 nand3_x0
xsubckt_380_and3_x1 1 0 493 494 496 500 and3_x1
xsubckt_253_and4_x1 1 0 610 611 613 620 636 and4_x1
xsubckt_292_nand2_x0 1 0 572 574 575 nand2_x0
xsubckt_977_and3_x1 1 0 1685 1686 1687 1688 and3_x1
xsubckt_983_nand3_x0 1 0 1679 327 642 743 nand3_x0
xspare_feed_106 1 0 tie
xspare_feed_50 1 0 tie
xsubckt_1940_dff_x1 1 0 87 72 2043 dff_x1
xsubckt_1892_or21nand_x0 1 0 128 875 870 871 or21nand_x0
xsubckt_1809_or21nand_x0 1 0 949 794 1150 950 or21nand_x0
xsubckt_1734_nexor2_x0 1 0 1024 1178 1022 nexor2_x0
xsubckt_1391_or21nand_x0 1 0 1326 1754 1347 1327 or21nand_x0
xsubckt_377_and2_x1 1 0 496 497 498 and2_x1
xsubckt_367_or21nand_x0 1 0 506 739 647 689 or21nand_x0
xsubckt_359_nand3_x0 1 0 513 587 610 2012 nand3_x0
xsubckt_118_nand4_x0 1 0 745 1965 787 788 1967 nand4_x0
xsubckt_75_inv_x0 1 0 1966 788 inv_x0
xsubckt_1166_and3_x1 1 0 1501 1646 1647 1688 and3_x1
xfeed_163 1 0 decap_w0
xsubckt_1952_dff_x1 1 0 158 46 1994 dff_x1
xsubckt_1759_nexor2_x0 1 0 998 1029 997 nexor2_x0
xsubckt_1750_mux2_x1 1 0 1008 1015 1161 1006 mux2_x1
xsubckt_1741_nand2_x0 1 0 1015 1017 1019 nand2_x0
xsubckt_1697_and3_x1 1 0 1058 1059 1061 1181 and3_x1
xsubckt_1403_nand3_x0 1 0 1317 682 1984 840 nand3_x0
xsubckt_934_nand3_x0 1 0 1728 327 635 1963 nand3_x0
xsubckt_1148_and2_x1 1 0 1517 1518 1520 and2_x1
xsubckt_1239_nand2_x0 1 0 2098 1437 1440 nand2_x0
xfeed_162 1 0 decap_w0
xsubckt_1888_nexor2_x0 1 0 873 897 872 nexor2_x0
xsubckt_1566_mux2_x1 1 0 1817 1185 1193 95 mux2_x1
xsubckt_1483_and21nor_x0 1 0 1254 466 702 2105 and21nor_x0
xsubckt_1413_and2_x1 1 0 1310 1613 1799 and2_x1
xsubckt_121_nand2_x0 1 0 742 841 1962 nand2_x0
xsubckt_15_inv_x0 1 0 2090 848 inv_x0
xsubckt_891_nand2_x0 1 0 1771 299 722 nand2_x0
xsubckt_1094_and21nor_x0 1 0 1570 743 731 635 and21nor_x0
xsubckt_1212_and21nor_x0 1 0 1459 1473 607 801 and21nor_x0
xfeed_161 1 0 decap_w0
xsubckt_2021_dff_x1 1 0 180 71 2016 dff_x1
xsubckt_1861_nexor2_x0 1 0 900 930 898 nexor2_x0
xsubckt_1348_or4_x1 1 0 1361 1362 1367 1369 1370 or4_x1
xsubckt_1327_mux2_x1 1 0 1817 1381 1389 103 mux2_x1
xsubckt_503_nand3_x0 1 0 382 587 610 2011 nand3_x0
xsubckt_330_nand3_x0 1 0 538 648 717 2092 nand3_x0
xsubckt_714_and2_x1 1 0 1935 1936 1940 and2_x1
xsubckt_1215_and21nor_x0 1 0 1457 639 656 825 and21nor_x0
xfeed_160 1 0 decap_w0
xsubckt_1896_or21nand_x0 1 0 867 896 877 874 or21nand_x0
xsubckt_1679_and2_x1 1 0 1075 1077 1091 and2_x1
xsubckt_1294_and3_x1 1 0 1400 1752 1797 324 and3_x1
xsubckt_35_inv_x0 1 0 1976 828 inv_x0
xsubckt_721_nand2_x0 1 0 1929 305 2015 nand2_x0
xsubckt_1019_nand3_x0 1 0 1644 327 648 717 nand3_x0
xsubckt_1188_and21nor_x0 1 0 1481 419 417 1484 and21nor_x0
xsubckt_1261_or21nand_x0 1 0 84 777 1424 1421 or21nand_x0
xfeed_189 1 0 decap_w0
xfeed_167 1 0 decap_w0
xsubckt_2001_dff_x1 1 0 198 58 2080 dff_x1
xsubckt_1785_or21nand_x0 1 0 972 985 987 1132 or21nand_x0
xsubckt_1767_and21nor_x0 1 0 990 1030 999 1004 and21nor_x0
xsubckt_1459_and3_x1 1 0 1270 682 2023 840 and3_x1
xsubckt_548_and3_x1 1 0 343 344 347 348 and3_x1
xsubckt_534_nand3_x0 1 0 355 587 610 2009 nand3_x0
xsubckt_492_nand2_x0 1 0 391 392 396 nand2_x0
xsubckt_85_inv_x0 1 0 2041 778 inv_x0
xsubckt_216_nand4_x0 1 0 647 1965 787 1966 789 nand4_x0
xsubckt_289_nand4_x0 1 0 575 671 673 678 2059 nand4_x0
xsubckt_959_nand4_x0 1 0 1703 327 715 717 732 nand4_x0
xsubckt_1102_nand3_x0 1 0 1562 299 714 743 nand3_x0
xfeed_188 1 0 decap_w0
xfeed_166 1 0 decap_w0
xsubckt_626_nand2_x0 1 0 272 273 643 nand2_x0
xsubckt_117_and4_x1 1 0 746 1965 787 788 1967 and4_x1
xsubckt_933_nand3_x0 1 0 1729 299 648 740 nand3_x0
xsubckt_946_nand3_x0 1 0 1716 327 714 743 nand3_x0
xsubckt_1044_and2_x1 1 0 1619 1620 1622 and2_x1
xfeed_165 1 0 decap_w0
xfeed_99 1 0 decap_w0
xsubckt_1822_and3_x1 1 0 936 937 940 946 and3_x1
xsubckt_1646_nand2_x0 1 0 1107 1111 1181 nand2_x0
xsubckt_1599_nor3_x0 1 0 1154 1155 1156 1272 nor3_x0
xsubckt_640_or2_x1 1 0 259 260 263 or2_x1
xsubckt_559_nand2_x0 1 0 333 334 840 nand2_x0
xsubckt_381_nand3_x0 1 0 492 494 496 500 nand3_x0
xsubckt_61_inv_x0 1 0 2073 802 inv_x0
xsubckt_678_and21nor_x0 1 0 225 2112 461 226 and21nor_x0
xsubckt_951_and3_x1 1 0 1711 1715 1716 1717 and3_x1
xsubckt_976_nand3_x0 1 0 1686 299 698 842 nand3_x0
xfeed_164 1 0 decap_w0
xfeed_98 1 0 tie
xsubckt_368_and2_x1 1 0 505 607 645 and2_x1
xsubckt_93_inv_x0 1 0 2024 770 inv_x0
xfeed_185 1 0 decap_w0
xfeed_97 1 0 tie
xsubckt_1945_dff_x1 1 0 153 43 1989 dff_x1
xsubckt_1727_or21nand_x0 1 0 1029 1064 1035 1038 or21nand_x0
xsubckt_1705_nand2_x0 1 0 1050 1052 1118 nand2_x0
xsubckt_1524_or2_x1 1 0 1217 1430 2073 or2_x1
xsubckt_173_nand4_x0 1 0 690 715 732 1963 842 nand4_x0
xsubckt_646_nand3_x0 1 0 254 323 683 2082 nand3_x0
xsubckt_751_nand2_x0 1 0 1901 1903 1907 nand2_x0
xsubckt_824_nexor2_x0 1 0 1837 2069 1835 nexor2_x0
xfeed_96 1 0 decap_w0
xsubckt_1329_nand3_x0 1 0 1379 1636 1659 1695 nand3_x0
xsubckt_589_and21nor_x0 1 0 306 308 311 322 and21nor_x0
xsubckt_453_or21nand_x0 1 0 426 442 451 2122 or21nand_x0
xsubckt_913_and4_x1 1 0 1749 1752 1798 1816 324 and4_x1
xsubckt_919_and2_x1 1 0 1743 1744 1745 and2_x1
xsubckt_1138_and2_x1 1 0 1527 1528 1529 and2_x1
xsubckt_1260_nand3_x0 1 0 1421 1856 1881 669 nand3_x0
xfeed_187 1 0 decap_w0
xfeed_169 1 0 tie
xfeed_95 1 0 tie
xsubckt_1685_and2_x1 1 0 1069 1070 1076 and2_x1
xsubckt_465_or21nand_x0 1 0 416 781 668 420 or21nand_x0
xsubckt_436_and21nor_x0 1 0 213 438 439 12 and21nor_x0
xsubckt_116_and2_x1 1 0 747 788 1967 and2_x1
xsubckt_204_nand3_x0 1 0 659 660 664 667 nand3_x0
xsubckt_667_or21nand_x0 1 0 235 793 311 236 or21nand_x0
xfeed_186 1 0 decap_w0
xfeed_168 1 0 decap_w0
xsubckt_1722_mux2_x1 1 0 1057 1037 1041 1033 mux2_x1
xsubckt_1513_and21nor_x0 1 0 1227 682 1230 1228 and21nor_x0
xsubckt_1379_nand2_x0 1 0 134 1336 1337 nand2_x0
xsubckt_1364_or21nand_x0 1 0 1346 1756 1347 1590 or21nand_x0
xsubckt_1292_nand2_x0 1 0 1401 1403 1750 nand2_x0
xsubckt_554_and21nor_x0 1 0 337 2069 609 338 and21nor_x0
xsubckt_365_nor4_x0 1 0 507 509 510 511 512 nor4_x0
xsubckt_958_nand4_x0 1 0 1704 327 711 1963 842 nand4_x0
xfeed_181 1 0 tie
xfeed_93 1 0 decap_w0
xsubckt_1424_and21nor_x0 1 0 1300 682 783 8 and21nor_x0
xsubckt_144_and3_x1 1 0 719 752 1963 842 and3_x1
xsubckt_185_and4_x1 1 0 678 679 685 700 706 and4_x1
xsubckt_210_nand2_x0 1 0 653 655 743 nand2_x0
xsubckt_264_and4_x1 1 0 599 715 717 1965 787 and4_x1
xsubckt_666_and2_x1 1 0 236 237 643 and2_x1
xsubckt_811_and2_x1 1 0 1847 2046 840 and2_x1
xfeed_180 1 0 decap_w0
xfeed_92 1 0 decap_w0
xsubckt_1810_and21nor_x0 1 0 948 659 1153 949 and21nor_x0
xsubckt_1549_and2_x1 1 0 197 1194 1196 and2_x1
xsubckt_1388_and21nor_x0 1 0 135 1331 1330 1329 and21nor_x0
xsubckt_1337_nand2_x0 1 0 1372 1373 1400 nand2_x0
xsubckt_399_and4_x1 1 0 474 717 732 788 1967 and4_x1
xsubckt_901_and21nor_x0 1 0 1761 1804 1806 323 and21nor_x0
xfeed_91 1 0 tie
xsubckt_1346_and4_x1 1 0 1363 1753 1757 1797 324 and4_x1
xsubckt_158_nand3_x0 1 0 705 707 708 720 nand3_x0
xsubckt_1126_nand3_x0 1 0 1539 299 655 743 nand3_x0
xfeed_182 1 0 decap_w0
xfeed_90 1 0 decap_w0
xsubckt_1904_dff_x1 1 0 109 67 2065 dff_x1
xsubckt_1842_nand3_x0 1 0 917 926 928 1121 nand3_x0
xsubckt_1830_and3_x1 1 0 929 717 746 2007 and3_x1
xsubckt_1526_and3_x1 1 0 1215 1216 1217 653 and3_x1
xsubckt_583_and3_x1 1 0 312 313 318 321 and3_x1
xsubckt_510_or21nand_x0 1 0 376 2120 441 840 or21nand_x0
xsubckt_369_nor4_x0 1 0 504 506 646 734 736 nor4_x0
xsubckt_39_inv_x0 1 0 2009 824 inv_x0
xsubckt_0_inv_x0 1 0 2007 863 inv_x0
xsubckt_222_nand4_x0 1 0 641 786 1964 788 1967 nand4_x0
xsubckt_241_and4_x1 1 0 622 623 625 631 632 and4_x1
xsubckt_260_nand2_x0 1 0 603 624 743 nand2_x0
xsubckt_1175_and3_x1 1 0 1492 1520 1737 1740 and3_x1
xspare_feed_39 1 0 tie
xsubckt_2030_dff_x1 1 0 123 52 2073 dff_x1
xsubckt_1536_and21nor_x0 1 0 166 1208 1207 1206 and21nor_x0
xsubckt_401_and21nor_x0 1 0 472 740 704 474 and21nor_x0
xsubckt_152_and4_x1 1 0 711 1965 1964 1966 1967 and4_x1
xsubckt_108_inv_x0 1 0 2075 755 inv_x0
xsubckt_184_and21nor_x0 1 0 679 687 680 681 and21nor_x0
xsubckt_246_and4_x1 1 0 617 696 732 788 1967 and4_x1
xsubckt_1272_and2_x1 1 0 1415 1417 840 and2_x1
xsubckt_2015_dff_x1 1 0 172 70 2008 dff_x1
xsubckt_1732_and2_x1 1 0 1024 1025 1027 and2_x1
xsubckt_1669_nand2_x0 1 0 1085 1087 1118 nand2_x0
xsubckt_1539_mux2_x1 1 0 804 1204 791 1203 mux2_x1
xsubckt_1435_nand3_x0 1 0 1291 1292 1316 1762 nand3_x0
xsubckt_370_nor4_x0 1 0 503 506 703 734 736 nor4_x0
xsubckt_73_inv_x0 1 0 1970 790 inv_x0
xsubckt_170_nand4_x0 1 0 693 732 1966 789 842 nand4_x0
xsubckt_2032_dff_x1 1 0 121 52 2071 dff_x1
xsubckt_1497_or21nand_x0 1 0 1241 445 760 2003 or21nand_x0
xsubckt_1490_nexor2_x0 1 0 1249 1250 1248 nexor2_x0
xsubckt_326_and3_x1 1 0 542 587 610 2016 and3_x1
xsubckt_1098_and2_x1 1 0 1566 1567 299 and2_x1
xsubckt_1116_nand2_x0 1 0 1548 1549 1550 nand2_x0
xsubckt_1163_nand2_x0 1 0 1503 1611 1631 nand2_x0
xsubckt_1220_or21nand_x0 1 0 2101 371 1484 1453 or21nand_x0
xsubckt_1665_or21nand_x0 1 0 1089 1097 1099 1132 or21nand_x0
xsubckt_1610_and3_x1 1 0 1143 1145 1152 1161 and3_x1
xsubckt_607_and2_x1 1 0 289 290 301 and2_x1
xsubckt_578_xor2_x0 1 0 2077 1998 317 xor2_x0
xsubckt_97_inv_x0 1 0 2028 766 inv_x0
xsubckt_182_and4_x1 1 0 681 717 723 752 1988 and4_x1
xsubckt_1992_dff_x1 1 0 162 35 1998 dff_x1
xsubckt_1790_mux2_x1 1 0 968 974 1161 967 mux2_x1
xsubckt_1613_or21nand_x0 1 0 1140 418 416 1153 or21nand_x0
xsubckt_1499_nand2_x0 1 0 1239 1240 1242 nand2_x0
xsubckt_406_and2_x1 1 0 467 468 493 and2_x1
xsubckt_183_and2_x1 1 0 680 682 1969 and2_x1
xsubckt_217_and2_x1 1 0 646 648 841 and2_x1
xsubckt_262_and2_x1 1 0 601 602 607 and2_x1
xsubckt_711_nand2_x0 1 0 1938 599 2071 nand2_x0
xsubckt_1982_dff_x1 1 0 190 66 2026 dff_x1
xsubckt_1937_dff_x1 1 0 90 71 2046 dff_x1
xsubckt_1874_nand2_x0 1 0 886 887 1118 nand2_x0
xsubckt_1827_mux2_x1 1 0 933 2069 830 119 mux2_x1
xsubckt_1371_or21nand_x0 1 0 143 1765 1350 1342 or21nand_x0
xsubckt_341_nand2_x0 1 0 2124 529 535 nand2_x0
xsubckt_2_inv_x0 1 0 2080 861 inv_x0
xsubckt_1170_and2_x1 1 0 1497 1638 1730 and2_x1
xfeed_208 1 0 decap_w0
xsubckt_1793_and2_x1 1 0 964 980 1072 and2_x1
xsubckt_1682_nand2_x0 1 0 1072 1178 1182 nand2_x0
xsubckt_542_nor2_x0 1 0 201 349 350 nor2_x0
xsubckt_538_and2_x1 1 0 351 352 355 and2_x1
xsubckt_469_nand2_x0 1 0 412 588 2112 nand2_x0
xsubckt_1009_or2_x1 1 0 1654 1655 1662 or2_x1
xsubckt_1056_nand3_x0 1 0 1607 327 731 743 nand3_x0
xsubckt_1080_nor2_x0 1 0 1584 1585 1593 nor2_x0
xsubckt_1100_or2_x1 1 0 1564 326 718 or2_x1
xsubckt_1152_and3_x1 1 0 1513 1536 1552 1555 and3_x1
xfeed_209 1 0 decap_w0
xsubckt_2000_dff_x1 1 0 199 61 2081 dff_x1
xsubckt_1647_and21nor_x0 1 0 1106 1142 1113 1108 and21nor_x0
xsubckt_1588_and21nor_x0 1 0 1165 743 648 615 and21nor_x0
xsubckt_80_inv_x0 1 0 1969 783 inv_x0
xfeed_206 1 0 decap_w0
xspare_feed_31 1 0 tie
xsubckt_350_nand3_x0 1 0 521 587 610 2013 nand3_x0
xsubckt_1103_nand2_x0 1 0 1561 327 722 nand2_x0
xfeed_207 1 0 tie
xspare_feed_30 1 0 tie
xsubckt_1699_nexor2_x0 1 0 1058 1177 1056 nexor2_x0
xsubckt_1659_and2_x1 1 0 1095 1096 1098 and2_x1
xsubckt_372_or21nand_x0 1 0 501 754 748 719 or21nand_x0
xsubckt_954_or3_x1 1 0 1708 298 693 841 or3_x1
xfeed_204 1 0 decap_w0
xspare_feed_33 1 0 tie
xsubckt_1903_dff_x1 1 0 110 73 2066 dff_x1
xsubckt_1710_nor2_x0 1 0 1045 1046 1047 nor2_x0
xsubckt_1702_nand3_x0 1 0 1053 1059 1061 1121 nand3_x0
xsubckt_1602_and3_x1 1 0 1151 614 652 656 and3_x1
xsubckt_460_and4_x1 1 0 421 671 673 678 2066 and4_x1
xsubckt_36_inv_x0 1 0 2011 827 inv_x0
xsubckt_674_nand2_x0 1 0 229 305 2005 nand2_x0
xsubckt_723_nand3_x0 1 0 1927 323 683 2091 nand3_x0
xsubckt_828_nand3_x0 1 0 1831 1834 1881 666 nand3_x0
xsubckt_1088_and21nor_x0 1 0 1576 1577 1582 1601 and21nor_x0
xsubckt_1202_and21nor_x0 1 0 1468 639 656 829 and21nor_x0
xfeed_205 1 0 tie
xsubckt_1797_mux2_x1 1 0 981 964 967 960 mux2_x1
xsubckt_1643_and3_x1 1 0 1110 1111 1113 1142 and3_x1
xsubckt_1535_or21nand_x0 1 0 1206 1212 607 840 or21nand_x0
xsubckt_442_and21nor_x0 1 0 211 434 435 14 and21nor_x0
xsubckt_175_nand3_x0 1 0 688 689 690 694 nand3_x0
xsubckt_855_and3_x1 1 0 1807 1809 1811 324 and3_x1
xsubckt_909_mux2_x1 1 0 810 771 2023 1753 mux2_x1
xsubckt_929_and3_x1 1 0 1733 1734 1737 1740 and3_x1
xsubckt_994_and3_x1 1 0 1668 1669 1681 1690 and3_x1
xfeed_202 1 0 decap_w0
xspare_feed_35 1 0 tie
xsubckt_1548_and2_x1 1 0 1194 1195 840 and2_x1
xsubckt_1525_nand2_x0 1 0 1216 682 807 nand2_x0
xsubckt_1495_or21nand_x0 1 0 1243 757 1248 683 or21nand_x0
xsubckt_405_and3_x1 1 0 468 473 504 607 and3_x1
xsubckt_180_and3_x1 1 0 683 717 723 752 and3_x1
xsubckt_207_nand2_x0 1 0 656 714 740 nand2_x0
xsubckt_214_and3_x1 1 0 649 652 656 709 and3_x1
xsubckt_1147_and3_x1 1 0 1518 1519 1549 1550 and3_x1
xfeed_203 1 0 tie
xspare_feed_34 1 0 tie
xsubckt_1959_dff_x1 1 0 143 44 1979 dff_x1
xsubckt_1898_and21nor_x0 1 0 865 898 932 994 and21nor_x0
xsubckt_1582_or21nand_x0 1 0 1171 1172 1174 446 or21nand_x0
xsubckt_1476_and21nor_x0 1 0 1259 466 702 2107 and21nor_x0
xsubckt_552_or21nand_x0 1 0 339 593 600 2082 or21nand_x0
xsubckt_974_and21nor_x0 1 0 1688 617 327 1689 and21nor_x0
xfeed_200 1 0 decap_w0
xspare_feed_37 1 0 tie
xsubckt_1839_nand2_x0 1 0 920 922 1072 nand2_x0
xsubckt_1804_or3_x1 1 0 954 955 956 1177 or3_x1
xsubckt_390_nor3_x0 1 0 483 484 492 502 nor3_x0
xsubckt_127_and2_x1 1 0 736 737 740 and2_x1
xsubckt_790_and2_x1 1 0 1865 1866 1867 and2_x1
xfeed_201 1 0 decap_w0
xsubckt_1966_dff_x1 1 0 150 39 1986 dff_x1
xsubckt_1913_dff_x1 1 0 100 72 2056 dff_x1
xsubckt_1373_and3_x1 1 0 1340 1591 1630 1807 and3_x1
xsubckt_576_and21nor_x0 1 0 319 746 717 713 and21nor_x0
xfeed_286 1 0 tie
xspare_feed_26 1 0 tie
xsubckt_1882_nand2_x0 1 0 878 879 1072 nand2_x0
xsubckt_1701_or21nand_x0 1 0 1054 1060 1062 1132 or21nand_x0
xsubckt_157_and3_x1 1 0 706 707 708 720 and3_x1
xsubckt_833_nexor2_x0 1 0 1841 794 1827 nexor2_x0
xsubckt_1240_and21nor_x0 1 0 1436 735 749 843 and21nor_x0
xfeed_287 1 0 tie
xspare_feed_27 1 0 tie
xsubckt_1739_and21nor_x0 1 0 1017 2070 1149 1018 and21nor_x0
xsubckt_1641_and3_x1 1 0 1112 1124 1130 1181 and3_x1
xsubckt_1286_nand3_x0 1 0 1406 1757 1815 324 nand3_x0
xsubckt_528_and2_x1 1 0 202 361 363 and2_x1
xsubckt_276_and4_x1 1 0 587 589 594 601 725 and4_x1
xsubckt_978_nand4_x0 1 0 1684 699 717 1958 840 nand4_x0
xsubckt_996_and3_x1 1 0 1666 1667 1741 1768 and3_x1
xsubckt_1234_and21nor_x0 1 0 1441 735 749 845 and21nor_x0
xsubckt_1241_and21nor_x0 1 0 1435 639 656 859 and21nor_x0
xfeed_284 1 0 tie
xfeed_239 1 0 decap_w0
xspare_feed_99 1 0 decap_w0
xspare_feed_24 1 0 tie
xsubckt_1873_mux2_x1 1 0 1132 1121 891 887 mux2_x1
xsubckt_1637_or21nand_x0 1 0 1116 1123 1117 1118 or21nand_x0
xsubckt_167_and2_x1 1 0 696 1963 1962 and2_x1
xsubckt_190_nand3_x0 1 0 673 676 700 706 nand3_x0
xsubckt_869_or21nand_x0 1 0 1793 1794 1800 1813 or21nand_x0
xsubckt_1029_and2_x1 1 0 1634 1636 1695 and2_x1
xsubckt_1174_and3_x1 1 0 1493 1494 1501 1527 and3_x1
xfeed_285 1 0 tie
xfeed_238 1 0 decap_w0
xspare_feed_98 1 0 tie
xsubckt_2004_dff_x1 1 0 211 57 2093 dff_x1
xsubckt_1640_nand3_x0 1 0 1113 1115 1122 1160 nand3_x0
xsubckt_1518_nand3_x0 1 0 1222 655 743 2105 nand3_x0
xsubckt_1446_nor3_x0 1 0 1281 1282 1284 1374 nor3_x0
xsubckt_618_and2_x1 1 0 279 280 285 and2_x1
xsubckt_84_inv_x0 1 0 2001 779 inv_x0
xsubckt_680_or21nand_x0 1 0 223 858 306 225 or21nand_x0
xsubckt_795_and2_x1 1 0 1861 2048 840 and2_x1
xsubckt_809_and2_x1 1 0 1848 1849 1851 and2_x1
xsubckt_1087_nand2_x0 1 0 1577 1579 1762 nand2_x0
xfeed_282 1 0 tie
xspare_feed_22 1 0 tie
xsubckt_1956_dff_x1 1 0 146 44 1982 dff_x1
xsubckt_1754_mux2_x1 1 0 1022 1177 1182 1002 mux2_x1
xsubckt_1648_or21nand_x0 1 0 1105 1143 1114 1107 or21nand_x0
xsubckt_1430_or4_x1 1 0 1295 1296 1297 1374 8 or4_x1
xsubckt_423_or21nand_x0 1 0 450 458 463 482 or21nand_x0
xsubckt_294_and21nor_x0 1 0 570 573 577 725 and21nor_x0
xsubckt_1271_nand2_x0 1 0 1416 713 2020 nand2_x0
xfeed_283 1 0 tie
xsubckt_1995_dff_x1 1 0 204 61 2086 dff_x1
xsubckt_1897_nexor2_x0 1 0 867 868 866 nexor2_x0
xsubckt_1784_and21nor_x0 1 0 973 984 986 1131 and21nor_x0
xsubckt_1458_and21nor_x0 1 0 1271 466 702 10 and21nor_x0
xsubckt_567_nor2_x0 1 0 198 328 330 nor2_x0
xsubckt_677_nand4_x0 1 0 226 227 228 561 643 nand4_x0
xsubckt_745_nand2_x0 1 0 1907 305 2013 nand2_x0
xsubckt_1196_nand3_x0 1 0 1473 731 743 803 nand3_x0
xsubckt_1201_and21nor_x0 1 0 1469 403 399 1484 and21nor_x0
xfeed_280 1 0 decap_w0
xspare_feed_20 1 0 tie
xsubckt_1918_dff_x1 1 0 95 73 2051 dff_x1
xsubckt_146_nor2_x0 1 0 717 1963 1962 nor2_x0
xsubckt_689_and21nor_x0 1 0 215 2111 461 216 and21nor_x0
xsubckt_874_nand4_x0 1 0 1788 1790 715 717 732 nand4_x0
xsubckt_894_and21nor_x0 1 0 1768 299 1776 1769 and21nor_x0
xfeed_281 1 0 decap_w0
xsubckt_1993_dff_x1 1 0 163 67 1999 dff_x1
xsubckt_1663_nand2_x0 1 0 1091 1094 1181 nand2_x0
xsubckt_835_mux2_x1 1 0 2106 1826 735 1825 mux2_x1
xsubckt_1140_nand4_x0 1 0 1525 327 699 1963 842 nand4_x0
xfeed_233 1 0 decap_w0
xspare_feed_93 1 0 decap_w0
xsubckt_1895_or21nand_x0 1 0 868 1136 1141 1161 or21nand_x0
xsubckt_1807_nand3_x0 1 0 951 953 954 1181 nand3_x0
xsubckt_1707_mux2_x1 1 0 1050 1055 1079 1048 mux2_x1
xsubckt_1698_nexor2_x0 1 0 1058 1178 1057 nexor2_x0
xsubckt_1464_and21nor_x0 1 0 1267 466 702 2111 and21nor_x0
xsubckt_461_nand4_x0 1 0 420 671 673 678 2066 nand4_x0
xsubckt_394_or2_x1 1 0 479 480 492 or2_x1
xsubckt_122_nand2_x0 1 0 741 743 746 nand2_x0
xsubckt_1072_and4_x1 1 0 1592 1806 1809 1811 324 and4_x1
xsubckt_1111_nand3_x0 1 0 1553 1789 299 626 nand3_x0
xsubckt_1164_nand3_x0 1 0 1502 1504 1523 1540 nand3_x0
xfeed_232 1 0 decap_w0
xspare_feed_92 1 0 tie
xsubckt_2037_dff_x1 1 0 129 32 2079 dff_x1
xsubckt_1889_mux2_x1 1 0 872 2067 830 117 mux2_x1
xsubckt_1616_and21nor_x0 1 0 1137 2074 1149 1138 and21nor_x0
xsubckt_1501_and2_x1 1 0 167 1238 840 and2_x1
xsubckt_1494_nor2_x0 1 0 1244 1245 1246 nor2_x0
xsubckt_530_nand4_x0 1 0 359 671 673 678 2062 nand4_x0
xsubckt_462_and21nor_x0 1 0 419 2050 666 423 and21nor_x0
xsubckt_410_and2_x1 1 0 463 464 479 and2_x1
xsubckt_37_inv_x0 1 0 2020 826 inv_x0
xsubckt_284_inv_x0 1 0 580 2116 inv_x0
xsubckt_681_nand3_x0 1 0 222 223 234 241 nand3_x0
xsubckt_807_nand3_x0 1 0 1850 737 740 813 nand3_x0
xsubckt_843_and2_x1 1 0 1818 1819 1881 and2_x1
xsubckt_923_and3_x1 1 0 1739 1808 1812 324 and3_x1
xsubckt_1124_and3_x1 1 0 1541 327 719 754 and3_x1
xfeed_231 1 0 decap_w0
xspare_feed_91 1 0 tie
xsubckt_2029_dff_x1 1 0 124 56 2074 dff_x1
xsubckt_1777_nand3_x0 1 0 980 982 983 1181 nand3_x0
xsubckt_443_or21nand_x0 1 0 433 442 451 2125 or21nand_x0
xfeed_230 1 0 decap_w0
xspare_feed_90 1 0 decap_w0
xsubckt_1757_nand2_x0 1 0 999 1001 1006 nand2_x0
xsubckt_1498_nand2_x0 1 0 1240 1241 682 nand2_x0
xsubckt_1491_or2_x1 1 0 1247 1977 2003 or2_x1
xsubckt_1416_and21nor_x0 1 0 149 1310 1309 1308 and21nor_x0
xsubckt_364_nand3_x0 1 0 508 648 717 2088 nand3_x0
xsubckt_22_inv_x0 1 0 1963 841 inv_x0
xsubckt_283_and2_x1 1 0 580 581 658 and2_x1
xsubckt_953_and2_x1 1 0 1709 1710 1711 and2_x1
xfeed_237 1 0 decap_w0
xsubckt_1938_dff_x1 1 0 89 67 2045 dff_x1
xsubckt_1527_nor4_x0 1 0 1214 2067 2068 2069 2070 nor4_x0
xsubckt_597_nand2_x0 1 0 298 1958 840 nand2_x0
xsubckt_70_inv_x0 1 0 2067 793 inv_x0
xsubckt_272_and3_x1 1 0 591 711 841 1962 and3_x1
xsubckt_705_and2_x1 1 0 1943 1945 1953 and2_x1
xsubckt_1003_nand3_x0 1 0 1660 1806 1808 324 nand3_x0
xsubckt_1070_and2_x1 1 0 1594 1595 1621 and2_x1
xsubckt_1110_nand2_x0 1 0 1554 327 596 nand2_x0
xsubckt_1222_and21nor_x0 1 0 1451 735 749 849 and21nor_x0
xfeed_236 1 0 decap_w0
xspare_feed_96 1 0 decap_w0
xsubckt_1973_dff_x1 1 0 152 42 1988 dff_x1
xsubckt_1683_mux2_x1 1 0 1093 1177 1182 1071 mux2_x1
xsubckt_1340_and3_x1 1 0 1369 1375 1659 1811 and3_x1
xsubckt_448_and21nor_x0 1 0 209 430 431 14 and21nor_x0
xsubckt_374_nand2_x0 1 0 499 699 716 nand2_x0
xsubckt_769_nand4_x0 1 0 1885 717 723 752 791 nand4_x0
xsubckt_898_and2_x1 1 0 1764 299 683 and2_x1
xfeed_288 1 0 tie
xfeed_235 1 0 decap_w0
xspare_feed_95 1 0 tie
xspare_feed_28 1 0 tie
xsubckt_1823_nand3_x0 1 0 935 937 940 946 nand3_x0
xsubckt_1516_nand2_x0 1 0 1224 1226 2075 nand2_x0
xsubckt_1479_and21nor_x0 1 0 1257 466 702 2106 and21nor_x0
xsubckt_551_nand2_x0 1 0 340 588 2107 nand2_x0
xsubckt_362_and21nor_x0 1 0 510 602 607 844 and21nor_x0
xsubckt_334_nand3_x0 1 0 535 587 610 2015 nand3_x0
xsubckt_249_nand2_x0 1 0 614 711 717 nand2_x0
xsubckt_950_nand3_x0 1 0 1712 1715 1718 1719 nand3_x0
xfeed_234 1 0 decap_w0
xspare_feed_94 1 0 tie
xspare_feed_29 1 0 tie
xsubckt_1382_or21nand_x0 1 0 1333 683 1992 840 or21nand_x0
xsubckt_1281_nand2_x0 1 0 1410 682 840 nand2_x0
xsubckt_88_inv_x0 1 0 2037 775 inv_x0
xsubckt_13_inv_x0 1 0 2091 850 inv_x0
xsubckt_162_and2_x1 1 0 701 702 741 and2_x1
xsubckt_239_and3_x1 1 0 624 752 1965 787 and3_x1
xsubckt_267_and4_x1 1 0 596 717 752 1965 787 and4_x1
xsubckt_712_nand4_x0 1 0 1937 1938 1939 538 643 nand4_x0
xsubckt_957_nand3_x0 1 0 1705 299 704 740 nand3_x0
xspare_buffer_42 1 0 62 56 buf_x4
xsubckt_1473_and21nor_x0 1 0 1261 466 702 2108 and21nor_x0
xsubckt_522_and21nor_x0 1 0 365 2071 609 366 and21nor_x0
xsubckt_404_and4_x1 1 0 469 470 476 477 500 and4_x1
xsubckt_215_and4_x1 1 0 648 1965 787 1966 789 and4_x1
xsubckt_1176_and3_x1 1 0 1491 1492 1691 1692 and3_x1
xspare_buffer_43 1 0 16 14 buf_x4
xspare_buffer_3 1 0 23 22 buf_x4
xsubckt_1812_nand2_x0 1 0 946 948 1161 nand2_x0
xsubckt_1718_and2_x1 1 0 1037 1056 1181 and2_x1
xsubckt_1506_or21nand_x0 1 0 1233 1234 1236 653 or21nand_x0
xsubckt_497_nor2_x0 1 0 204 388 390 nor2_x0
xsubckt_417_or21nand_x0 1 0 456 469 467 457 or21nand_x0
xsubckt_392_nand2_x0 1 0 481 630 742 nand2_x0
xsubckt_156_and21nor_x0 1 0 707 740 737 710 and21nor_x0
xsubckt_1053_nand3_x0 1 0 1610 299 642 717 nand3_x0
xfeed_59 1 0 decap_w0
xspare_buffer_40 1 0 62 58 buf_x4
xspare_buffer_0 1 0 77 76 buf_x4
xsubckt_1800_and21nor_x0 1 0 958 988 965 962 and21nor_x0
xsubckt_628_and2_x1 1 0 270 271 274 and2_x1
xsubckt_564_nor2_x0 1 0 330 441 2115 nor2_x0
xsubckt_403_and3_x1 1 0 470 471 475 603 and3_x1
xsubckt_110_and4_x1 1 0 753 786 1964 789 841 and4_x1
xsubckt_789_nand3_x0 1 0 1866 1868 1870 802 nand3_x0
xsubckt_815_nand3_x0 1 0 1843 1846 1881 666 nand3_x0
xsubckt_845_mux2_x1 1 0 1817 1824 1879 87 mux2_x1
xsubckt_1189_and21nor_x0 1 0 1480 639 656 832 and21nor_x0
xfeed_58 1 0 tie
xspare_buffer_41 1 0 62 57 buf_x4
xsubckt_1792_or2_x1 1 0 965 967 981 or2_x1
xsubckt_378_and21nor_x0 1 0 495 737 717 731 and21nor_x0
xsubckt_134_nand2_x0 1 0 729 731 743 nand2_x0
xsubckt_860_and3_x1 1 0 1802 1804 1805 324 and3_x1
xsubckt_903_and21nor_x0 1 0 1759 1809 1812 323 and21nor_x0
xsubckt_1055_and2_x1 1 0 1608 1609 1610 and2_x1
xspare_buffer_46 1 0 62 53 buf_x4
xsubckt_2034_dff_x1 1 0 119 55 2069 dff_x1
xsubckt_1866_nand4_x0 1 0 894 1161 1163 1166 1168 nand4_x0
xsubckt_1761_mux2_x1 1 0 996 2071 830 121 mux2_x1
xsubckt_1760_nexor2_x0 1 0 998 1030 996 nexor2_x0
xsubckt_1489_nexor2_x0 1 0 2075 2077 1249 nexor2_x0
xsubckt_1411_nand2_x0 1 0 1311 1363 1766 nand2_x0
xsubckt_575_nand2_x0 1 0 320 717 746 nand2_x0
xsubckt_441_or21nand_x0 1 0 434 442 451 2126 or21nand_x0
xsubckt_218_nand2_x0 1 0 645 648 841 nand2_x0
xsubckt_1125_and21nor_x0 1 0 1540 1658 1639 1541 and21nor_x0
xspare_buffer_47 1 0 16 13 buf_x4
xspare_buffer_7 1 0 22 21 buf_x4
xsubckt_2020_dff_x1 1 0 181 71 2017 dff_x1
xsubckt_1612_and21nor_x0 1 0 1141 419 417 1154 and21nor_x0
xsubckt_1492_nand2_x0 1 0 1246 1247 764 nand2_x0
xsubckt_466_and21nor_x0 1 0 415 417 419 725 and21nor_x0
xsubckt_664_and21nor_x0 1 0 238 306 598 859 and21nor_x0
xsubckt_717_nand3_x0 1 0 1932 1934 1944 1954 nand3_x0
xsubckt_960_or2_x1 1 0 1702 298 692 or2_x1
xspare_buffer_44 1 0 62 55 buf_x4
xspare_buffer_4 1 0 76 75 buf_x4
xsubckt_1921_dff_x1 1 0 114 26 1965 dff_x1
xsubckt_533_or21nand_x0 1 0 356 357 358 724 or21nand_x0
xsubckt_76_inv_x0 1 0 1964 787 inv_x0
xsubckt_255_and2_x1 1 0 608 704 743 and2_x1
xsubckt_708_nand2_x0 1 0 1941 327 2016 nand2_x0
xsubckt_1242_and21nor_x0 1 0 1434 1473 607 793 and21nor_x0
xspare_buffer_45 1 0 62 54 buf_x4
xsubckt_1957_dff_x1 1 0 145 38 1981 dff_x1
xsubckt_1426_or4_x1 1 0 1298 1299 1302 1307 1366 or4_x1
xsubckt_1353_nor4_x0 1 0 1356 1357 1361 1364 682 nor4_x0
xsubckt_499_nand4_x0 1 0 386 671 673 678 2064 nand4_x0
xsubckt_196_nand2_x0 1 0 667 669 2036 nand2_x0
xsubckt_1005_and3_x1 1 0 1658 1659 1764 1811 and3_x1
xsubckt_1221_or21nand_x0 1 0 1452 358 357 1485 or21nand_x0
xfeed_53 1 0 decap_w0
xsubckt_1886_or21nand_x0 1 0 874 895 884 879 or21nand_x0
xsubckt_1486_nand2_x0 1 0 1252 446 1997 nand2_x0
xsubckt_557_inv_x0 1 0 335 2117 inv_x0
xsubckt_421_nor4_x0 1 0 452 453 461 650 710 nor4_x0
xsubckt_402_and2_x1 1 0 471 472 645 and2_x1
xsubckt_56_inv_x0 1 0 2002 807 inv_x0
xsubckt_187_and2_x1 1 0 676 682 1968 and2_x1
xsubckt_277_nand3_x0 1 0 586 587 610 2007 nand3_x0
xsubckt_306_or21nand_x0 1 0 559 621 628 2112 or21nand_x0
xsubckt_644_and2_x1 1 0 256 327 2008 and2_x1
xsubckt_837_and2_x1 1 0 1824 840 2043 and2_x1
xsubckt_949_nand3_x0 1 0 1713 1714 1716 1717 nand3_x0
xsubckt_1190_and3_x1 1 0 1479 731 743 1978 and3_x1
xfeed_52 1 0 decap_w0
xsubckt_2002_dff_x1 1 0 213 56 2095 dff_x1
xsubckt_1883_and3_x1 1 0 877 878 883 894 and3_x1
xsubckt_1708_and21nor_x0 1 0 1047 1151 637 799 and21nor_x0
xsubckt_1674_and21nor_x0 1 0 1080 2072 1149 1081 and21nor_x0
xsubckt_1545_and2_x1 1 0 1197 1198 1199 and2_x1
xsubckt_545_nand4_x0 1 0 346 671 673 678 2061 nand4_x0
xsubckt_480_and21nor_x0 1 0 403 2049 666 405 and21nor_x0
xsubckt_435_or21nand_x0 1 0 438 442 451 2114 or21nand_x0
xsubckt_303_and3_x1 1 0 562 648 717 2095 and3_x1
xsubckt_986_nand3_x0 1 0 1676 327 642 740 nand3_x0
xsubckt_1112_and2_x1 1 0 1552 1553 1554 and2_x1
xfeed_51 1 0 tie
xspare_buffer_48 1 0 62 52 buf_x4
xspare_buffer_8 1 0 76 62 buf_x4
xsubckt_1671_mux2_x1 1 0 1085 1090 1144 1083 mux2_x1
xsubckt_1423_nand3_x0 1 0 1301 1303 1306 1365 nand3_x0
xsubckt_128_nand2_x0 1 0 735 737 740 nand2_x0
xsubckt_111_nor2_x0 1 0 752 1966 1967 nor2_x0
xsubckt_87_inv_x0 1 0 2038 776 inv_x0
xsubckt_229_nand4_x0 1 0 634 715 1965 787 842 nand4_x0
xsubckt_257_and4_x1 1 0 606 715 732 841 1962 and4_x1
xsubckt_685_nand2_x0 1 0 219 305 2004 nand2_x0
xsubckt_876_nand2_x0 1 0 1786 1787 1788 nand2_x0
xfeed_50 1 0 tie
xspare_buffer_49 1 0 62 51 buf_x4
xsubckt_1855_and2_x1 1 0 904 905 920 and2_x1
xsubckt_1805_or21nand_x0 1 0 953 955 956 1177 or21nand_x0
xsubckt_1742_and21nor_x0 1 0 1014 1025 1027 1131 and21nor_x0
xsubckt_1564_mux2_x1 1 0 1825 1186 1193 96 mux2_x1
xsubckt_1311_nand4_x0 1 0 1389 1881 671 673 678 nand4_x0
xsubckt_467_nand3_x0 1 0 414 587 610 2019 nand3_x0
xsubckt_251_mux2_x1 1 0 618 697 842 612 mux2_x1
xsubckt_665_nand3_x0 1 0 237 323 683 2080 nand3_x0
xsubckt_1150_and2_x1 1 0 1515 1516 1597 and2_x1
xfeed_57 1 0 decap_w0
xsubckt_1802_and3_x1 1 0 956 717 746 2008 and3_x1
xsubckt_1680_nand2_x0 1 0 1074 1077 1091 nand2_x0
xsubckt_1477_and3_x1 1 0 1258 466 702 772 and3_x1
xsubckt_129_and2_x1 1 0 734 737 743 and2_x1
xsubckt_226_and2_x1 1 0 637 638 644 and2_x1
xsubckt_643_or21nand_x0 1 0 173 257 258 264 or21nand_x0
xsubckt_802_and2_x1 1 0 1855 2047 840 and2_x1
xsubckt_877_and2_x1 1 0 1785 473 590 and2_x1
xsubckt_1217_and21nor_x0 1 0 1455 1478 643 798 and21nor_x0
xfeed_56 1 0 decap_w0
xsubckt_1946_dff_x1 1 0 141 42 1977 dff_x1
xsubckt_133_nand3_x0 1 0 730 732 1966 789 nand3_x0
xsubckt_103_inv_x0 1 0 1997 760 inv_x0
xsubckt_161_nand2_x0 1 0 702 704 740 nand2_x0
xsubckt_233_and3_x1 1 0 630 732 788 1967 and3_x1
xsubckt_762_and2_x1 1 0 1891 1892 1896 and2_x1
xsubckt_883_nand3_x0 1 0 1779 1780 486 607 nand3_x0
xsubckt_1269_mux2_x1 1 0 2035 1817 1424 79 mux2_x1
xfeed_55 1 0 decap_w0
xsubckt_1998_dff_x1 1 0 201 58 2083 dff_x1
xsubckt_1907_dff_x1 1 0 106 73 2062 dff_x1
xsubckt_1387_or21nand_x0 1 0 1329 683 1971 840 or21nand_x0
xsubckt_515_and21nor_x0 1 0 372 2039 669 374 and21nor_x0
xsubckt_495_nand3_x0 1 0 389 443 450 838 nand3_x0
xsubckt_119_nand2_x0 1 0 744 746 841 nand2_x0
xsubckt_176_and4_x1 1 0 687 689 690 692 694 and4_x1
xsubckt_230_nand2_x0 1 0 633 642 695 nand2_x0
xsubckt_663_nand2_x0 1 0 239 327 2006 nand2_x0
xsubckt_968_and21nor_x0 1 0 1694 1798 1816 323 and21nor_x0
xsubckt_1229_or2_x1 1 0 1445 1475 795 or2_x1
xfeed_54 1 0 decap_w0
xsubckt_1939_dff_x1 1 0 88 74 2044 dff_x1
xsubckt_1851_and2_x1 1 0 908 909 911 and2_x1
xsubckt_517_nand3_x0 1 0 370 372 373 375 nand3_x0
xsubckt_716_or21nand_x0 1 0 1933 1953 1945 1935 or21nand_x0
xsubckt_935_and2_x1 1 0 1727 1728 1729 and2_x1
xsubckt_940_and2_x1 1 0 1722 1723 1733 and2_x1
xsubckt_1154_and2_x1 1 0 1511 1512 1615 and2_x1
xdiode_7 1 0 737 diode_w1
xspare_feed_75 1 0 tie
xsubckt_1893_mux2_x1 1 0 907 2079 830 129 mux2_x1
xsubckt_1865_and4_x1 1 0 895 1161 1163 1166 1168 and4_x1
xsubckt_1796_nand2_x0 1 0 961 963 967 nand2_x0
xsubckt_1789_or21nand_x0 1 0 968 1016 969 971 or21nand_x0
xsubckt_1455_or21nand_x0 1 0 1273 683 1983 840 or21nand_x0
xsubckt_1443_and4_x1 1 0 1284 1375 1755 1762 1807 and4_x1
xsubckt_474_and21nor_x0 1 0 408 450 443 2128 and21nor_x0
xsubckt_27_inv_x0 1 0 2084 836 inv_x0
xsubckt_908_nand2_x0 1 0 1754 1756 324 nand2_x0
xsubckt_1198_and21nor_x0 1 0 1471 735 749 858 and21nor_x0
xdiode_6 1 0 324 diode_w1
xspare_feed_74 1 0 tie
xsubckt_223_and2_x1 1 0 640 642 717 and2_x1
xdiode_5 1 0 324 diode_w1
xfeed_248 1 0 tie
xspare_feed_77 1 0 tie
xsubckt_1969_dff_x1 1 0 131 37 1961 dff_x1
xsubckt_1668_and21nor_x0 1 0 1086 1088 1089 1119 and21nor_x0
xsubckt_1629_nand3_x0 1 0 1124 1125 1129 2112 nand3_x0
xsubckt_1472_nor3_x0 1 0 192 1262 1263 10 nor3_x0
xsubckt_472_nand2_x0 1 0 409 410 414 nand2_x0
xsubckt_455_nand3_x0 1 0 425 443 450 2088 nand3_x0
xsubckt_385_and4_x1 1 0 488 723 788 1967 841 and4_x1
xsubckt_840_nexor2_x0 1 0 1822 1823 1821 nexor2_x0
xsubckt_856_mux2_x1 1 0 816 769 2023 1806 mux2_x1
xdiode_4 1 0 324 diode_w1
xfeed_249 1 0 decap_w0
xsubckt_1953_dff_x1 1 0 136 47 1972 dff_x1
xsubckt_1532_nand3_x0 1 0 1209 1210 1211 1886 nand3_x0
xsubckt_323_and21nor_x0 1 0 544 602 607 854 and21nor_x0
xsubckt_320_and2_x1 1 0 547 593 2072 and2_x1
xsubckt_885_nor3_x0 1 0 1777 1778 1779 1786 nor3_x0
xsubckt_1187_or2_x1 1 0 1957 1482 1484 or2_x1
xsubckt_1227_nand2_x0 1 0 2100 1447 1452 nand2_x0
xdiode_3 1 0 299 diode_w1
xspare_feed_71 1 0 tie
xsubckt_1949_dff_x1 1 0 138 47 1974 dff_x1
xsubckt_1763_nand2_x0 1 0 994 446 2001 nand2_x0
xsubckt_1725_mux2_x1 1 0 1032 2072 830 122 mux2_x1
xsubckt_620_nand3_x0 1 0 277 278 290 301 nand3_x0
xsubckt_337_and3_x1 1 0 532 648 717 2091 and3_x1
xsubckt_269_and3_x1 1 0 594 595 597 598 and3_x1
xsubckt_273_nand3_x0 1 0 590 711 841 1962 nand3_x0
xsubckt_741_and2_x1 1 0 1910 1912 1921 and2_x1
xsubckt_938_nand3_x0 1 0 1724 1725 648 717 nand3_x0
xdiode_2 1 0 299 diode_w1
xspare_feed_70 1 0 tie
xsubckt_1924_dff_x1 1 0 111 26 1962 dff_x1
xsubckt_1611_nand3_x0 1 0 1142 1145 1152 1161 nand3_x0
xsubckt_1296_nand4_x0 1 0 1398 1400 1762 1807 683 nand4_x0
xsubckt_1285_and3_x1 1 0 1407 1757 1815 324 and3_x1
xsubckt_234_nand3_x0 1 0 629 732 788 1967 nand3_x0
xsubckt_692_and2_x1 1 0 1955 214 222 and2_x1
xsubckt_734_nand2_x0 1 0 1917 305 2014 nand2_x0
xsubckt_768_and4_x1 1 0 1886 717 723 752 791 and4_x1
xsubckt_771_or2_x1 1 0 1883 1885 785 or2_x1
xsubckt_781_nand2_x0 1 0 94 1874 1876 nand2_x0
xsubckt_1231_and4_x1 1 0 1443 1444 1445 1446 1477 and4_x1
xdiode_1 1 0 683 diode_w1
xfeed_129 1 0 tie
xspare_feed_73 1 0 tie
xsubckt_1987_dff_x1 1 0 196 48 2033 dff_x1
xsubckt_1932_dff_x1 1 0 79 73 2035 dff_x1
xsubckt_1848_or21nand_x0 1 0 911 576 572 1153 or21nand_x0
xsubckt_1703_nand2_x0 1 0 1052 1053 1054 nand2_x0
xsubckt_1574_and3_x1 1 0 1179 648 717 1998 and3_x1
xsubckt_1410_and2_x1 1 0 1312 1660 1801 and2_x1
xsubckt_634_or21nand_x0 1 0 174 265 268 275 or21nand_x0
xsubckt_418_or3_x1 1 0 455 480 492 640 or3_x1
xsubckt_199_nand2_x0 1 0 664 666 2044 nand2_x0
xsubckt_227_and3_x1 1 0 636 637 649 720 and3_x1
xsubckt_722_nand2_x0 1 0 1928 599 2070 nand2_x0
xsubckt_757_nand2_x0 1 0 1896 305 2012 nand2_x0
xsubckt_829_nand2_x0 1 0 89 1831 1833 nand2_x0
xsubckt_922_nand4_x0 1 0 1740 327 711 841 1962 nand4_x0
xsubckt_956_and2_x1 1 0 1706 1707 1708 and2_x1
xsubckt_1156_or3_x1 1 0 113 1510 1530 1557 or3_x1
xdiode_0 1 0 683 diode_w1
xfeed_128 1 0 decap_w0
xspare_feed_72 1 0 tie
xsubckt_2035_dff_x1 1 0 118 35 2068 dff_x1
xsubckt_1863_and21nor_x0 1 0 897 930 901 904 and21nor_x0
xsubckt_1818_nand2_x0 1 0 940 942 1160 nand2_x0
xsubckt_1336_and4_x1 1 0 1373 1803 1806 1808 324 and4_x1
xsubckt_363_and3_x1 1 0 509 648 717 2088 and3_x1
xsubckt_243_and2_x1 1 0 620 622 627 and2_x1
xsubckt_971_nand3_x0 1 0 1691 327 630 743 nand3_x0
xsubckt_1129_and2_x1 1 0 1536 1537 1540 and2_x1
xfeed_242 1 0 decap_w0
xfeed_127 1 0 decap_w0
xsubckt_1989_dff_x1 1 0 184 45 2022 dff_x1
xsubckt_1696_nand3_x0 1 0 1059 1125 1129 2110 nand3_x0
xsubckt_1623_nand3_x0 1 0 1130 717 746 2019 nand3_x0
xsubckt_456_or21nand_x0 1 0 424 442 451 2121 or21nand_x0
xsubckt_683_or21nand_x0 1 0 169 298 221 230 or21nand_x0
xfeed_243 1 0 tie
xfeed_126 1 0 tie
xsubckt_107_inv_x0 1 0 1960 756 inv_x0
xsubckt_189_and3_x1 1 0 674 676 700 706 and3_x1
xsubckt_280_nand2_x0 1 0 583 588 2106 nand2_x0
xsubckt_282_and3_x1 1 0 581 582 585 586 and3_x1
xsubckt_924_nand3_x0 1 0 1738 1808 1812 324 nand3_x0
xsubckt_952_and3_x1 1 0 1710 1714 1718 1719 and3_x1
xfeed_240 1 0 decap_w0
xfeed_125 1 0 decap_w0
xsubckt_1439_nand2_x0 1 0 1287 1693 1766 nand2_x0
xsubckt_296_or21nand_x0 1 0 568 593 600 2080 or21nand_x0
xsubckt_704_nand2_x0 1 0 1944 1946 1950 nand2_x0
xsubckt_937_and3_x1 1 0 1725 317 1958 840 and3_x1
xfeed_241 1 0 tie
xfeed_124 1 0 decap_w0
xsubckt_1944_dff_x1 1 0 154 43 1990 dff_x1
xsubckt_574_nand2_x0 1 0 321 324 683 nand2_x0
xsubckt_459_nand4_x0 1 0 422 671 673 677 2058 nand4_x0
xsubckt_452_nand3_x0 1 0 427 443 450 2089 nand3_x0
xsubckt_219_nand2_x0 1 0 644 648 743 nand2_x0
xsubckt_286_nand2_x0 1 0 578 666 2043 nand2_x0
xsubckt_312_and21nor_x0 1 0 554 602 607 856 and21nor_x0
xsubckt_796_nand4_x0 1 0 1860 2001 2076 1999 2072 nand4_x0
xsubckt_827_and2_x1 1 0 1832 1834 1881 and2_x1
xsubckt_1010_mux2_x1 1 0 2034 2002 1990 1653 mux2_x1
xsubckt_1206_or4_x1 1 0 1464 1465 1466 1467 1468 or4_x1
xfeed_246 1 0 decap_w0
xspare_feed_79 1 0 tie
xsubckt_440_nand3_x0 1 0 435 443 450 2093 nand3_x0
xsubckt_228_and4_x1 1 0 635 715 1965 787 842 and4_x1
xsubckt_836_mux2_x1 1 0 1825 1830 1879 88 mux2_x1
xsubckt_888_or2_x1 1 0 1774 298 718 or2_x1
xsubckt_1137_nand3_x0 1 0 1528 327 696 699 nand3_x0
xfeed_247 1 0 tie
xfeed_122 1 0 decap_w0
xspare_feed_78 1 0 tie
xsubckt_2011_dff_x1 1 0 182 71 2018 dff_x1
xsubckt_1466_nor3_x0 1 0 194 1266 1267 10 nor3_x0
xsubckt_638_and2_x1 1 0 261 262 643 and2_x1
xsubckt_608_nand2_x0 1 0 288 290 301 nand2_x0
xsubckt_585_nand4_x0 1 0 310 486 613 631 632 nand4_x0
xsubckt_433_nand2_x0 1 0 440 443 450 nand2_x0
xsubckt_202_nand4_x0 1 0 661 671 673 678 2060 nand4_x0
xdiode_9 1 0 840 diode_w1
xfeed_244 1 0 decap_w0
xfeed_121 1 0 decap_w0
xsubckt_454_and21nor_x0 1 0 207 426 427 14 and21nor_x0
xsubckt_102_inv_x0 1 0 1996 761 inv_x0
xsubckt_258_nand4_x0 1 0 605 715 732 841 1962 nand4_x0
xsubckt_675_nand3_x0 1 0 228 323 683 2095 nand3_x0
xsubckt_955_nand2_x0 1 0 1707 327 691 nand2_x0
xsubckt_1226_nor4_x0 1 0 1447 1448 1450 1451 1479 nor4_x0
xdiode_8 1 0 740 diode_w1
xfeed_245 1 0 decap_w0
xfeed_120 1 0 decap_w0
xsubckt_1885_and21nor_x0 1 0 875 894 883 880 and21nor_x0
xsubckt_1791_nor2_x0 1 0 966 967 981 nor2_x0
xsubckt_1675_and2_x1 1 0 1079 1080 1082 and2_x1
xsubckt_1560_mux2_x1 1 0 1846 1188 1193 98 mux2_x1
xsubckt_1467_and21nor_x0 1 0 1265 466 702 2110 and21nor_x0
xsubckt_1460_or2_x1 1 0 187 1270 1271 or2_x1
xsubckt_619_nand2_x0 1 0 278 280 285 nand2_x0
xsubckt_62_inv_x0 1 0 2072 801 inv_x0
xsubckt_305_and21nor_x0 1 0 560 2074 593 563 and21nor_x0
xsubckt_794_nand2_x0 1 0 93 1862 1872 nand2_x0
xsubckt_893_nand2_x0 1 0 1769 1770 1773 nand2_x0
xsubckt_1193_and21nor_x0 1 0 1476 1478 643 817 and21nor_x0
xsubckt_1978_dff_x1 1 0 194 48 2030 dff_x1
xsubckt_1508_and2_x1 1 0 1231 1232 840 and2_x1
xsubckt_546_nand4_x0 1 0 345 671 673 677 2053 nand4_x0
xsubckt_531_or21nand_x0 1 0 358 819 665 360 or21nand_x0
xsubckt_188_nand2_x0 1 0 675 682 1968 nand2_x0
xsubckt_997_inv_x0 1 0 1666 116 inv_x0
xsubckt_1107_or21nand_x0 1 0 1557 682 1572 1558 or21nand_x0
xspare_feed_1 1 0 tie
xsubckt_1831_nand3_x0 1 0 928 717 746 2007 nand3_x0
xsubckt_1475_nor3_x0 1 0 191 1260 1261 18 nor3_x0
xsubckt_1349_and4_x1 1 0 1360 1798 1804 1805 324 and4_x1
xsubckt_375_and2_x1 1 0 498 499 684 and2_x1
xsubckt_967_or21nand_x0 1 0 1695 1797 1815 324 or21nand_x0
xsubckt_1214_nand2_x0 1 0 2102 1458 1463 nand2_x0
xsubckt_1273_and2_x1 1 0 185 1415 1416 and2_x1
xfeed_28 1 0 decap_w0
xsubckt_1691_and21nor_x0 1 0 1064 1100 1074 1069 and21nor_x0
xsubckt_1554_mux2_x1 1 0 1864 1191 1193 101 mux2_x1
xsubckt_1471_and3_x1 1 0 1262 466 702 766 and3_x1
xsubckt_595_and3_x1 1 0 300 302 304 312 and3_x1
xsubckt_446_nand3_x0 1 0 431 443 450 2091 nand3_x0
xsubckt_384_and3_x1 1 0 489 723 788 1967 and3_x1
xsubckt_987_nand3_x0 1 0 1675 299 719 754 nand3_x0
xsubckt_1248_nand4_x0 1 0 1430 717 723 752 1977 nand4_x0
xfeed_29 1 0 tie
xspare_feed_3 1 0 tie
xsubckt_2031_dff_x1 1 0 122 56 2072 dff_x1
xsubckt_1858_nand2_x0 1 0 901 906 922 nand2_x0
xsubckt_1716_and2_x1 1 0 1039 1040 1056 and2_x1
xsubckt_1433_nand3_x0 1 0 1293 682 784 840 nand3_x0
xsubckt_458_and4_x1 1 0 423 671 673 677 2058 and4_x1
xspare_feed_4 1 0 tie
xsubckt_1872_nand3_x0 1 0 888 889 909 911 nand3_x0
xsubckt_1853_mux2_x1 1 0 908 913 1160 906 mux2_x1
xsubckt_1625_and2_x1 1 0 1128 605 684 and2_x1
xsubckt_1591_nand3_x0 1 0 1162 1163 1166 1168 nand3_x0
xsubckt_1406_or21nand_x0 1 0 148 1765 1315 1317 or21nand_x0
xsubckt_1396_nand2_x0 1 0 1322 1328 757 nand2_x0
xsubckt_1361_nand4_x0 1 0 1349 1352 1355 1358 1379 nand4_x0
xsubckt_571_and21nor_x0 1 0 324 2096 800 2020 and21nor_x0
xsubckt_347_nand3_x0 1 0 523 648 717 2090 nand3_x0
xsubckt_979_nand2_x0 1 0 1683 327 474 nand2_x0
xsubckt_1083_nand3_x0 1 0 1581 1695 1751 1754 nand3_x0
xspare_feed_5 1 0 tie
xsubckt_1832_and3_x1 1 0 927 1125 1129 2106 and3_x1
xsubckt_581_and3_x1 1 0 314 447 487 634 and3_x1
xsubckt_60_inv_x0 1 0 1978 803 inv_x0
xsubckt_174_nand4_x0 1 0 689 717 723 1966 789 nand4_x0
xsubckt_213_nand2_x0 1 0 650 652 656 nand2_x0
xsubckt_266_nand2_x0 1 0 597 740 746 nand2_x0
xsubckt_916_and21nor_x0 1 0 1746 1748 1758 1767 and21nor_x0
xsubckt_1105_or2_x1 1 0 1559 1560 1566 or2_x1
xspare_feed_6 1 0 tie
xsubckt_601_or21nand_x0 1 0 295 305 599 2018 or21nand_x0
xsubckt_569_or2_x1 1 0 326 1958 3 or2_x1
xsubckt_137_or21nand_x0 1 0 726 746 731 743 or21nand_x0
xsubckt_236_nand4_x0 1 0 627 732 788 1967 842 nand4_x0
xsubckt_271_or2_x1 1 0 592 693 841 or2_x1
xsubckt_291_and2_x1 1 0 573 574 575 and2_x1
xsubckt_848_and2_x1 1 0 1814 1815 324 and2_x1
xsubckt_941_and2_x1 1 0 1721 327 606 and2_x1
xsubckt_1155_and2_x1 1 0 1510 1511 1666 and2_x1
xspare_feed_7 1 0 tie
xsubckt_1948_dff_x1 1 0 160 46 1996 dff_x1
xsubckt_1470_and21nor_x0 1 0 1263 466 702 2109 and21nor_x0
xsubckt_625_nand3_x0 1 0 273 323 683 2084 nand3_x0
xsubckt_621_nexor2_x0 1 0 279 288 276 nexor2_x0
xsubckt_594_and21nor_x0 1 0 301 302 304 312 and21nor_x0
xsubckt_477_nor2_x0 1 0 205 406 408 nor2_x0
xsubckt_412_nand3_x0 1 0 461 486 631 632 nand3_x0
xsubckt_774_or21nand_x0 1 0 1880 1884 705 840 or21nand_x0
xsubckt_948_nand3_x0 1 0 1714 299 717 737 nand3_x0
xsubckt_962_and2_x1 1 0 1700 1701 1706 and2_x1
xfeed_22 1 0 decap_w0
xsubckt_2012_dff_x1 1 0 175 69 2011 dff_x1
xsubckt_1661_nexor2_x0 1 0 1095 1178 1093 nexor2_x0
xsubckt_1617_or21nand_x0 1 0 1136 804 1150 1139 or21nand_x0
xsubckt_1583_and21nor_x0 1 0 1170 1986 1173 1175 and21nor_x0
xsubckt_475_nand3_x0 1 0 407 443 450 839 nand3_x0
xsubckt_463_or21nand_x0 1 0 418 822 665 422 or21nand_x0
xsubckt_654_nand2_x0 1 0 247 327 2007 nand2_x0
xsubckt_661_or21nand_x0 1 0 240 242 249 299 or21nand_x0
xsubckt_679_and2_x1 1 0 224 225 229 and2_x1
xsubckt_1185_nand4_x0 1 0 1483 1785 595 597 618 nand4_x0
xfeed_23 1 0 decap_w0
xspare_feed_9 1 0 tie
xsubckt_2024_dff_x1 1 0 177 61 2013 dff_x1
xsubckt_1780_and21nor_x0 1 0 977 2069 1149 978 and21nor_x0
xsubckt_1706_mux2_x1 1 0 1051 1054 1079 1049 mux2_x1
xsubckt_1380_and3_x1 1 0 1335 1348 1757 1797 and3_x1
xsubckt_42_inv_x0 1 0 2049 821 inv_x0
xsubckt_221_and4_x1 1 0 642 786 1964 788 1967 and4_x1
xsubckt_242_nand4_x0 1 0 621 623 625 631 632 nand4_x0
xsubckt_873_or3_x1 1 0 1789 1960 1961 2077 or3_x1
xsubckt_992_nand4_x0 1 0 1670 1760 1762 1764 1814 nand4_x0
xsubckt_1205_and21nor_x0 1 0 1465 1473 607 802 and21nor_x0
xsubckt_1274_and3_x1 1 0 155 1756 324 840 and3_x1
xfeed_20 1 0 decap_w0
xsubckt_1326_and2_x1 1 0 1381 840 2059 and2_x1
xsubckt_527_and2_x1 1 0 361 362 840 and2_x1
xsubckt_1011_mux2_x1 1 0 2022 2003 1990 1652 mux2_x1
xsubckt_1264_or21nand_x0 1 0 82 776 1424 1420 or21nand_x0
xfeed_21 1 0 decap_w0
xsubckt_1854_mux2_x1 1 0 907 912 1160 905 mux2_x1
xsubckt_1529_and2_x1 1 0 1212 1213 1214 and2_x1
xsubckt_1417_and4_x1 1 0 1307 1363 1762 1807 1815 and4_x1
xsubckt_1347_and4_x1 1 0 1362 1363 1762 1807 1813 and4_x1
xsubckt_1306_or21nand_x0 1 0 160 1411 1392 1393 or21nand_x0
xsubckt_1298_or21nand_x0 1 0 137 1402 1398 1397 or21nand_x0
xsubckt_4_inv_x0 1 0 2006 859 inv_x0
xsubckt_866_nand2_x0 1 0 1796 1797 324 nand2_x0
xsubckt_1085_or21nand_x0 1 0 1579 1694 1635 1580 or21nand_x0
xsubckt_1099_nand3_x0 1 0 1565 299 714 740 nand3_x0
xsubckt_1197_and21nor_x0 1 0 1472 1473 607 804 and21nor_x0
xfeed_26 1 0 decap_w0
xsubckt_1974_dff_x1 1 0 151 42 1987 dff_x1
xsubckt_1693_and3_x1 1 0 1062 717 746 2011 and3_x1
xsubckt_112_and4_x1 1 0 751 752 786 1964 841 and4_x1
xsubckt_16_inv_x0 1 0 2014 847 inv_x0
xsubckt_177_nand4_x0 1 0 686 689 690 692 694 nand4_x0
xsubckt_310_nand3_x0 1 0 556 587 610 2004 nand3_x0
xsubckt_748_nand4_x0 1 0 1904 1905 1906 517 643 nand4_x0
xsubckt_921_and2_x1 1 0 1741 1743 1746 and2_x1
xsubckt_1267_nand3_x0 1 0 1418 1825 1881 669 nand3_x0
xfeed_27 1 0 decap_w0
xsubckt_1676_nand2_x0 1 0 1078 1080 1082 nand2_x0
xsubckt_209_and2_x1 1 0 654 655 743 and2_x1
xsubckt_1057_nand3_x0 1 0 1606 299 630 743 nand3_x0
xsubckt_1068_or4_x1 1 0 115 1596 1616 1642 1697 or4_x1
xsubckt_1223_and21nor_x0 1 0 1450 639 656 824 and21nor_x0
xfeed_24 1 0 decap_w0
xsubckt_1383_nor2_x0 1 0 156 1333 1334 nor2_x0
xsubckt_632_nand4_x0 1 0 266 269 278 290 301 nand4_x0
xsubckt_47_inv_x0 1 0 2112 816 inv_x0
xsubckt_256_nand2_x0 1 0 607 704 743 nand2_x0
xsubckt_911_nand2_x0 1 0 1751 1752 324 nand2_x0
xsubckt_1022_and3_x1 1 0 1641 327 737 743 and3_x1
xfeed_25 1 0 decap_w0
xsubckt_1782_and21nor_x0 1 0 975 342 1153 976 and21nor_x0
xsubckt_1385_nand3_x0 1 0 1331 1591 1796 1807 nand3_x0
xsubckt_606_nand2_x0 1 0 290 291 295 nand2_x0
xsubckt_572_or21nand_x0 1 0 323 797 2032 826 or21nand_x0
xsubckt_539_nand3_x0 1 0 2118 351 354 356 nand3_x0
xsubckt_130_nand2_x0 1 0 733 737 743 nand2_x0
xsubckt_26_inv_x0 1 0 2085 837 inv_x0
xsubckt_648_or21nand_x0 1 0 252 795 311 253 or21nand_x0
xsubckt_1006_nand3_x0 1 0 1657 1659 1764 1811 nand3_x0
xsubckt_1063_and21nor_x0 1 0 1600 1801 1809 1810 and21nor_x0
xfeed_17 1 0 decap_w0
xsubckt_1981_dff_x1 1 0 191 66 2027 dff_x1
xsubckt_1934_dff_x1 1 0 93 69 2049 dff_x1
xsubckt_424_and2_x1 1 0 449 616 690 and2_x1
xsubckt_248_and2_x1 1 0 615 711 717 and2_x1
xsubckt_250_nand2_x0 1 0 613 648 717 nand2_x0
xsubckt_863_nand2_x0 1 0 1799 1802 1807 nand2_x0
xsubckt_889_nand2_x0 1 0 1773 327 446 nand2_x0
xsubckt_989_and4_x1 1 0 1673 1674 1675 1676 1677 and4_x1
xsubckt_1058_or2_x1 1 0 1605 326 692 or2_x1
xfeed_16 1 0 decap_w0
xsubckt_1692_or21nand_x0 1 0 1063 1101 1075 1068 or21nand_x0
xsubckt_1319_mux2_x1 1 0 1848 1385 1389 107 mux2_x1
xsubckt_6_inv_x0 1 0 2095 857 inv_x0
xfeed_15 1 0 decap_w0
xsubckt_2007_dff_x1 1 0 208 56 2090 dff_x1
xsubckt_1835_or21nand_x0 1 0 924 927 929 1177 or21nand_x0
xsubckt_537_and21nor_x0 1 0 352 2070 609 353 and21nor_x0
xsubckt_519_or21nand_x0 1 0 368 593 600 2084 or21nand_x0
xsubckt_72_inv_x0 1 0 1977 791 inv_x0
xsubckt_1101_nand2_x0 1 0 1563 1564 1565 nand2_x0
xfeed_14 1 0 decap_w0
xsubckt_1412_or21nand_x0 1 0 131 1311 1312 1313 or21nand_x0
xsubckt_1405_nand4_x0 1 0 1315 1753 1756 1797 324 nand4_x0
xsubckt_1253_and2_x1 1 0 1425 1426 1427 and2_x1
xsubckt_1280_nand3_x0 1 0 1411 1762 1807 683 nand3_x0
xfeed_13 1 0 tie
xsubckt_1891_or21nand_x0 1 0 870 880 1073 1958 or21nand_x0
xsubckt_1819_and21nor_x0 1 0 939 940 946 952 and21nor_x0
xsubckt_1441_and2_x1 1 0 152 1286 1293 and2_x1
xsubckt_1352_nand2_x0 1 0 1357 1360 1754 nand2_x0
xsubckt_1342_nor3_x0 1 0 1367 1368 1399 1761 nor3_x0
xsubckt_566_nand2_x0 1 0 328 329 840 nand2_x0
xsubckt_536_and2_x1 1 0 353 588 2108 and2_x1
xsubckt_131_nor2_x0 1 0 732 1965 1964 nor2_x0
xsubckt_290_nand2_x0 1 0 574 669 2035 nand2_x0
xsubckt_849_nand2_x0 1 0 1813 1815 324 nand2_x0
xsubckt_1183_and3_x1 1 0 1485 1487 1489 607 and3_x1
xsubckt_1266_or21nand_x0 1 0 81 775 1424 1419 or21nand_x0
xfeed_12 1 0 decap_w0
xsubckt_1878_or3_x1 1 0 882 892 893 1177 or3_x1
xsubckt_1876_and3_x1 1 0 884 885 888 1160 and3_x1
xsubckt_1871_and2_x1 1 0 889 890 1132 and2_x1
xsubckt_1775_or21nand_x0 1 0 982 985 987 1177 or21nand_x0
xsubckt_1454_and3_x1 1 0 1274 1275 1276 1278 and3_x1
xsubckt_584_and4_x1 1 0 311 486 613 631 632 and4_x1
xsubckt_344_and2_x1 1 0 526 593 2069 and2_x1
xsubckt_709_nand2_x0 1 0 1940 305 2016 nand2_x0
xsubckt_783_or21nand_x0 1 0 1872 665 1880 1873 or21nand_x0
xsubckt_861_nand3_x0 1 0 1801 1804 1805 324 nand3_x0
xsubckt_982_nand3_x0 1 0 1680 299 751 1962 nand3_x0
xsubckt_1172_and4_x1 1 0 1495 1561 1562 1716 1717 and4_x1
xsubckt_1954_dff_x1 1 0 157 46 1993 dff_x1
xsubckt_1534_and21nor_x0 1 0 1207 1209 1215 608 and21nor_x0
xsubckt_1496_or2_x1 1 0 1242 1243 1244 or2_x1
xsubckt_361_and2_x1 1 0 511 593 2067 and2_x1
xsubckt_124_nand2_x0 1 0 739 1963 842 nand2_x0
xsubckt_10_inv_x0 1 0 2017 853 inv_x0
xsubckt_645_and21nor_x0 1 0 255 306 598 823 and21nor_x0
xsubckt_793_nand2_x0 1 0 1862 1863 666 nand2_x0
xsubckt_1186_and2_x1 1 0 1482 1483 1961 and2_x1
xfeed_10 1 0 tie
xsubckt_1877_nand3_x0 1 0 883 885 888 1160 nand3_x0
xsubckt_1768_and21nor_x0 1 0 989 996 993 990 and21nor_x0
xsubckt_1504_or21nand_x0 1 0 1235 2071 791 762 or21nand_x0
xsubckt_1370_nand3_x0 1 0 1342 682 1979 840 nand3_x0
xsubckt_622_or21nand_x0 1 0 175 298 276 286 or21nand_x0
xsubckt_352_and21nor_x0 1 0 519 602 607 846 and21nor_x0
xsubckt_342_nand3_x0 1 0 528 587 610 2014 nand3_x0
xsubckt_688_nand4_x0 1 0 216 217 218 552 643 nand4_x0
xsubckt_1024_and2_x1 1 0 1639 1749 1755 and2_x1
xsubckt_1210_and21nor_x0 1 0 1461 639 656 827 and21nor_x0
xsubckt_1758_mux2_x1 1 0 1021 1002 1006 998 mux2_x1
xsubckt_1502_or2_x1 1 0 1237 1973 1977 or2_x1
xsubckt_637_nand3_x0 1 0 262 323 683 2083 nand3_x0
xsubckt_92_inv_x0 1 0 2025 771 inv_x0
xsubckt_702_and21nor_x0 1 0 1946 2110 461 1947 and21nor_x0
xsubckt_1033_and3_x1 1 0 1630 1756 1798 324 and3_x1
xsubckt_1118_and3_x1 1 0 1546 1547 1670 1671 and3_x1
xsubckt_1850_and21nor_x0 1 0 909 2067 1149 910 and21nor_x0
xsubckt_1393_or21nand_x0 1 0 1324 1798 323 2033 or21nand_x0
xsubckt_413_nand4_x0 1 0 460 717 786 1964 1967 nand4_x0
xsubckt_1180_nand2_x0 1 0 1488 735 749 nand2_x0
xsubckt_1265_nand2_x0 1 0 1419 1832 669 nand2_x0
xsubckt_1961_dff_x1 1 0 134 44 1970 dff_x1
xsubckt_1914_dff_x1 1 0 99 74 2055 dff_x1
xsubckt_1736_nand2_x0 1 0 1020 1023 1181 nand2_x0
xsubckt_1555_and2_x1 1 0 1190 2056 840 and2_x1
xsubckt_1440_or3_x1 1 0 1286 1287 1288 1289 or3_x1
xsubckt_1395_and4_x1 1 0 165 1323 1325 1326 840 and4_x1
xsubckt_1339_and2_x1 1 0 1370 1400 1802 and2_x1
xsubckt_653_or2_x1 1 0 172 248 256 or2_x1
xsubckt_737_nand4_x0 1 0 1914 1915 1916 523 643 nand4_x0
xsubckt_1173_and2_x1 1 0 1494 1495 1496 and2_x1
xsubckt_1847_mux2_x1 1 0 914 919 948 912 mux2_x1
xsubckt_468_or21nand_x0 1 0 413 593 600 2087 or21nand_x0
xsubckt_428_nand4_x0 1 0 445 717 723 788 1967 nand4_x0
xsubckt_1078_and3_x1 1 0 1586 1659 1749 1811 and3_x1
xsubckt_1203_and21nor_x0 1 0 1467 735 749 855 and21nor_x0
xsubckt_1263_nand2_x0 1 0 1420 1844 669 nand2_x0
xsubckt_1770_and3_x1 1 0 987 717 746 2009 and3_x1
xsubckt_1321_mux2_x1 1 0 1846 1384 1389 106 mux2_x1
xsubckt_295_nand3_x0 1 0 569 587 610 2006 nand3_x0
xsubckt_786_and3_x1 1 0 1869 779 780 1999 and3_x1
xsubckt_852_nand2_x0 1 0 1810 1811 324 nand2_x0
xsubckt_930_nand3_x0 1 0 1732 299 648 743 nand3_x0
xsubckt_945_nand3_x0 1 0 1717 299 737 743 nand3_x0
xsubckt_1179_and2_x1 1 0 1489 735 749 and2_x1
xsubckt_1852_nand2_x0 1 0 907 909 911 nand2_x0
xsubckt_1798_nexor2_x0 1 0 960 989 959 nexor2_x0
xsubckt_1638_or21nand_x0 1 0 1115 1141 1136 1116 or21nand_x0
xsubckt_1520_and21nor_x0 1 0 1220 1227 1223 1221 and21nor_x0
xsubckt_1401_nand2_x0 1 0 1318 682 1986 nand2_x0
xsubckt_1351_nand2_x0 1 0 1358 1359 1360 nand2_x0
xsubckt_471_and21nor_x0 1 0 410 2074 609 411 and21nor_x0
xsubckt_936_nand2_x0 1 0 1726 327 599 nand2_x0
xfeed_19 1 0 decap_w0
xsubckt_1505_and3_x1 1 0 1234 1235 683 763 and3_x1
xsubckt_502_or21nand_x0 1 0 383 384 385 724 or21nand_x0
xsubckt_670_nand2_x0 1 0 232 234 241 nand2_x0
xsubckt_713_and21nor_x0 1 0 1936 2109 461 1937 and21nor_x0
xsubckt_1278_and2_x1 1 0 1413 1414 1756 and2_x1
xfeed_18 1 0 decap_w0
xsubckt_1975_dff_x1 1 0 147 42 1983 dff_x1
xsubckt_1737_or21nand_x0 1 0 1019 358 357 1153 or21nand_x0
xsubckt_1386_and21nor_x0 1 0 1330 1373 1796 682 and21nor_x0
xsubckt_614_nand3_x0 1 0 283 284 717 737 nand3_x0
xsubckt_529_nand4_x0 1 0 360 671 673 677 2054 nand4_x0
xsubckt_1060_and2_x1 1 0 1603 1604 1608 and2_x1
xfeed_211 1 0 decap_w0
xfeed_156 1 0 decap_w0
xspare_buffer_19 1 0 22 6 buf_x4
xsubckt_1627_and4_x1 1 0 1126 472 643 645 729 and4_x1
xsubckt_1392_nand2_x0 1 0 1325 1328 779 nand2_x0
xsubckt_38_inv_x0 1 0 2010 825 inv_x0
xsubckt_1_inv_x0 1 0 2105 862 inv_x0
xsubckt_698_nand2_x0 1 0 1950 305 2017 nand2_x0
xsubckt_710_nand3_x0 1 0 1939 323 683 2092 nand3_x0
xfeed_210 1 0 decap_w0
xfeed_157 1 0 tie
xsubckt_1977_dff_x1 1 0 195 46 2031 dff_x1
xsubckt_1751_mux2_x1 1 0 1007 1016 1161 1005 mux2_x1
xsubckt_1642_nexor2_x0 1 0 1112 1177 1111 nexor2_x0
xsubckt_20_inv_x0 1 0 2012 843 inv_x0
xsubckt_1075_and2_x1 1 0 1589 1591 1807 and2_x1
xfeed_213 1 0 tie
xfeed_154 1 0 decap_w0
xsubckt_2018_dff_x1 1 0 169 65 2005 dff_x1
xsubckt_1695_and3_x1 1 0 1060 1125 1129 2110 and3_x1
xsubckt_1684_mux2_x1 1 0 1094 1178 1182 1070 mux2_x1
xsubckt_1620_and3_x1 1 0 1133 1134 445 602 and3_x1
xsubckt_775_nand2_x0 1 0 1879 1881 666 nand2_x0
xsubckt_1207_or2_x1 1 0 2103 1464 1469 or2_x1
xfeed_212 1 0 decap_w0
xfeed_155 1 0 decap_w0
xsubckt_1811_and2_x1 1 0 947 948 1161 and2_x1
xsubckt_1542_mux2_x1 1 0 817 1201 1202 1200 mux2_x1
xsubckt_1312_and2_x1 1 0 1388 2066 840 and2_x1
xsubckt_40_inv_x0 1 0 2008 823 inv_x0
xsubckt_178_nand2_x0 1 0 685 686 1985 nand2_x0
xsubckt_767_or21nand_x0 1 0 176 1887 1889 1897 or21nand_x0
xsubckt_1247_and21nor_x0 1 0 1431 2032 792 1972 and21nor_x0
xfeed_215 1 0 decap_w0
xfeed_152 1 0 tie
xsubckt_1572_nand2_x0 1 0 1181 1183 1979 nand2_x0
xsubckt_1330_or21nand_x0 1 0 161 1765 1379 1380 or21nand_x0
xsubckt_311_and21nor_x0 1 0 555 622 627 815 and21nor_x0
xsubckt_1037_and21nor_x0 1 0 1626 1764 1628 1627 and21nor_x0
xsubckt_1045_and2_x1 1 0 1618 1619 1626 and2_x1
xsubckt_1194_or21nand_x0 1 0 1475 704 731 743 or21nand_x0
xfeed_214 1 0 decap_w0
xfeed_153 1 0 decap_w0
xsubckt_1968_dff_x1 1 0 130 37 1960 dff_x1
xsubckt_1755_mux2_x1 1 0 1023 1178 1182 1001 mux2_x1
xsubckt_1488_nexor2_x0 1 0 2079 2078 1250 nexor2_x0
xsubckt_563_and21nor_x0 1 0 199 580 440 331 and21nor_x0
xsubckt_521_nand2_x0 1 0 366 367 368 nand2_x0
xsubckt_488_or21nand_x0 1 0 395 593 600 2086 or21nand_x0
xsubckt_697_nand2_x0 1 0 1951 327 2017 nand2_x0
xsubckt_1038_nand2_x0 1 0 1625 299 606 nand2_x0
xsubckt_1113_nand2_x0 1 0 1551 1552 1555 nand2_x0
xfeed_217 1 0 decap_w0
xsubckt_476_nand2_x0 1 0 406 407 840 nand2_x0
xsubckt_473_or2_x1 1 0 2128 409 415 or2_x1
xsubckt_205_nand2_x0 1 0 658 659 724 nand2_x0
xfeed_216 1 0 decap_w0
xfeed_151 1 0 decap_w0
xsubckt_1833_nand3_x0 1 0 926 1125 1129 2106 nand3_x0
xsubckt_1753_nand2_x0 1 0 1003 1005 1020 nand2_x0
xsubckt_1456_and21nor_x0 1 0 147 1280 1274 1273 and21nor_x0
xsubckt_1317_mux2_x1 1 0 1856 1386 1389 108 mux2_x1
xsubckt_1283_or21nand_x0 1 0 157 1412 1411 1409 or21nand_x0
xsubckt_580_nand3_x0 1 0 315 316 648 717 nand3_x0
xsubckt_113_and2_x1 1 0 750 751 842 and2_x1
xsubckt_31_inv_x0 1 0 2019 832 inv_x0
xsubckt_8_inv_x0 1 0 2004 855 inv_x0
xsubckt_669_and2_x1 1 0 233 234 241 and2_x1
xsubckt_727_or21nand_x0 1 0 1923 849 306 1925 or21nand_x0
xsubckt_752_or21nand_x0 1 0 1900 1921 1912 1902 or21nand_x0
xsubckt_782_and2_x1 1 0 1873 2049 840 and2_x1
xsubckt_905_mux2_x1 1 0 811 772 2023 1757 mux2_x1
xfeed_219 1 0 decap_w0
xspare_buffer_11 1 0 22 16 buf_x4
xsubckt_2038_dff_x1 1 0 128 32 2078 dff_x1
xsubckt_1714_mux2_x1 1 0 1043 1049 1160 1041 mux2_x1
xsubckt_1639_and3_x1 1 0 1114 1115 1122 1160 and3_x1
xsubckt_1341_and21nor_x0 1 0 1368 1812 1816 323 and21nor_x0
xsubckt_470_nand2_x0 1 0 411 412 413 nand2_x0
xsubckt_430_and3_x1 1 0 443 444 448 449 and3_x1
xsubckt_325_or2_x1 1 0 2126 543 549 or2_x1
xsubckt_125_and2_x1 1 0 738 1966 789 and2_x1
xsubckt_81_inv_x0 1 0 1987 782 inv_x0
xsubckt_792_and2_x1 1 0 1863 1864 1881 and2_x1
xsubckt_966_nand2_x0 1 0 1696 1762 1807 nand2_x0
xsubckt_1077_or21nand_x0 1 0 1587 1696 1695 1588 or21nand_x0
xfeed_218 1 0 decap_w0
xsubckt_1856_nand2_x0 1 0 903 905 920 nand2_x0
xsubckt_1690_mux2_x1 1 0 1066 2073 830 123 mux2_x1
xsubckt_1418_nand4_x0 1 0 1306 1363 1762 1807 1815 nand4_x0
xsubckt_1331_or21nand_x0 1 0 1378 683 1982 840 or21nand_x0
xsubckt_427_and4_x1 1 0 446 717 723 788 1967 and4_x1
xsubckt_400_nand4_x0 1 0 473 717 732 788 1967 nand4_x0
xsubckt_155_and2_x1 1 0 708 712 718 and2_x1
xsubckt_138_and3_x1 1 0 725 726 727 749 and3_x1
xsubckt_297_nand2_x0 1 0 567 588 2105 nand2_x0
xsubckt_947_nand2_x0 1 0 1715 327 713 nand2_x0
xsubckt_1972_dff_x1 1 0 132 46 1968 dff_x1
xsubckt_1879_or21nand_x0 1 0 881 892 893 1177 or21nand_x0
xsubckt_1721_nand2_x0 1 0 1034 1036 1041 nand2_x0
xsubckt_577_and3_x1 1 0 318 319 631 692 and3_x1
xsubckt_338_nand3_x0 1 0 531 648 717 2091 nand3_x0
xsubckt_123_and2_x1 1 0 740 1963 842 and2_x1
xsubckt_172_and4_x1 1 0 691 715 732 1963 842 and4_x1
xsubckt_808_and2_x1 1 0 1849 1850 1881 and2_x1
xsubckt_1149_and3_x1 1 0 1516 1517 1524 1527 and3_x1
xspare_buffer_12 1 0 76 49 buf_x4
xsubckt_464_and21nor_x0 1 0 417 2042 669 421 and21nor_x0
xsubckt_738_and21nor_x0 1 0 1913 2107 461 1914 and21nor_x0
xsubckt_1225_or21nand_x0 1 0 1448 796 1475 1449 or21nand_x0
xspare_buffer_82 1 0 36 24 buf_x4
xspare_buffer_15 1 0 22 11 buf_x4
xsubckt_2016_dff_x1 1 0 171 69 2007 dff_x1
xsubckt_1720_and2_x1 1 0 1035 1036 1041 and2_x1
xsubckt_1600_or3_x1 1 0 1153 1155 1156 1272 or3_x1
xsubckt_1552_mux2_x1 1 0 1877 1192 1193 102 mux2_x1
xsubckt_1374_or21nand_x0 1 0 1339 1340 1341 683 or21nand_x0
xsubckt_1301_or21nand_x0 1 0 138 1411 1395 1396 or21nand_x0
xsubckt_153_and3_x1 1 0 710 711 1963 842 and3_x1
xsubckt_165_and2_x1 1 0 698 699 1963 and2_x1
xsubckt_686_nand3_x0 1 0 218 323 683 2094 nand3_x0
xsubckt_875_nand3_x0 1 0 1787 1792 624 740 nand3_x0
xsubckt_1082_or21nand_x0 1 0 1582 1591 1802 1816 or21nand_x0
xsubckt_1208_or21nand_x0 1 0 1463 385 384 1485 or21nand_x0
xspare_buffer_83 1 0 6 2 buf_x4
xsubckt_1318_and2_x1 1 0 1385 2063 840 and2_x1
xsubckt_349_nand2_x0 1 0 2123 522 528 nand2_x0
xsubckt_55_inv_x0 1 0 1979 808 inv_x0
xsubckt_851_mux2_x1 1 0 2109 2028 2023 1811 mux2_x1
xfeed_158 1 0 decap_w0
xspare_buffer_80 1 0 36 26 buf_x4
xsubckt_1747_nand2_x0 1 0 1009 1011 1118 nand2_x0
xsubckt_1438_and4_x1 1 0 1288 1363 1591 1807 1815 and4_x1
xsubckt_1368_nand3_x0 1 0 1343 682 1980 840 nand3_x0
xsubckt_1322_and2_x1 1 0 1383 2061 840 and2_x1
xsubckt_596_and2_x1 1 0 299 1958 840 and2_x1
xsubckt_523_and2_x1 1 0 364 365 369 and2_x1
xsubckt_90_inv_x0 1 0 1959 773 inv_x0
xsubckt_766_nand2_x0 1 0 1887 1888 299 nand2_x0
xsubckt_1213_nor4_x0 1 0 1458 1459 1460 1461 1462 nor4_x0
xfeed_159 1 0 decap_w0
xspare_buffer_81 1 0 36 25 buf_x4
xspare_buffer_16 1 0 76 36 buf_x4
xsubckt_1672_or21nand_x0 1 0 1082 385 384 1153 or21nand_x0
xsubckt_1607_or21nand_x0 1 0 1146 815 1148 552 or21nand_x0
xsubckt_1580_nor2_x0 1 0 1173 1975 1971 nor2_x0
xdiode_12 1 0 840 diode_w1
xfeed_71 1 0 decap_w0
xsubckt_2023_dff_x1 1 0 178 61 2014 dff_x1
xsubckt_1744_nand3_x0 1 0 1012 1025 1027 1121 nand3_x0
xsubckt_1731_nand3_x0 1 0 1025 1125 1129 2109 nand3_x0
xsubckt_1594_and3_x1 1 0 1159 1160 1162 1176 and3_x1
xsubckt_1463_nor3_x0 1 0 195 1268 1269 10 nor3_x0
xsubckt_1367_and21nor_x0 1 0 145 1344 1349 1351 and21nor_x0
xsubckt_629_nand2_x0 1 0 269 271 274 nand2_x0
xsubckt_562_nand2_x0 1 0 331 332 840 nand2_x0
xsubckt_493_or2_x1 1 0 2127 391 397 or2_x1
xsubckt_351_and21nor_x0 1 0 520 622 627 810 and21nor_x0
xsubckt_1132_nor2_x0 1 0 1533 1534 1672 nor2_x0
xsubckt_1159_and4_x1 1 0 1507 1728 1729 1774 1775 and4_x1
xsubckt_1257_or21nand_x0 1 0 86 781 1424 1423 or21nand_x0
xdiode_13 1 0 840 diode_w1
xfeed_70 1 0 tie
xsubckt_1942_dff_x1 1 0 185 38 2020 dff_x1
xsubckt_1651_and2_x1 1 0 1102 1103 1104 and2_x1
xsubckt_1630_and21nor_x0 1 0 1123 1124 1130 1131 and21nor_x0
xsubckt_1593_nand2_x0 1 0 1160 1183 1970 nand2_x0
xsubckt_1484_nor3_x0 1 0 188 1254 1255 10 nor3_x0
xsubckt_543_nand2_x0 1 0 348 669 2037 nand2_x0
xsubckt_439_and21nor_x0 1 0 212 436 437 14 and21nor_x0
xsubckt_357_nor3_x0 1 0 514 515 516 520 nor3_x0
xsubckt_160_and2_x1 1 0 703 704 740 and2_x1
xsubckt_779_and2_x1 1 0 1875 1877 1881 and2_x1
xsubckt_884_and21nor_x0 1 0 1778 1784 1785 1960 and21nor_x0
xsubckt_1095_and4_x1 1 0 1569 1570 1571 445 603 and4_x1
xdiode_10 1 0 840 diode_w1
xfeed_73 1 0 tie
xsubckt_1950_dff_x1 1 0 159 47 1995 dff_x1
xsubckt_1813_or21nand_x0 1 0 945 955 956 1132 or21nand_x0
xsubckt_1310_or21nand_x0 1 0 142 1581 1411 1390 or21nand_x0
xsubckt_605_and21nor_x0 1 0 291 2073 310 292 and21nor_x0
xsubckt_902_or21nand_x0 1 0 1760 1808 1811 324 or21nand_x0
xsubckt_1008_or21nand_x0 1 0 1655 1747 1657 1656 or21nand_x0
xdiode_11 1 0 840 diode_w1
xfeed_72 1 0 decap_w0
xsubckt_382_and2_x1 1 0 491 629 712 and2_x1
xsubckt_671_or21nand_x0 1 0 231 234 241 299 or21nand_x0
xsubckt_690_and2_x1 1 0 214 215 219 and2_x1
xsubckt_695_nand2_x0 1 0 1952 1953 299 nand2_x0
xsubckt_926_or2_x1 1 0 1736 298 689 or2_x1
xdiode_16 1 0 327 diode_w1
xfeed_75 1 0 tie
xspare_feed_112 1 0 tie
xspare_feed_48 1 0 tie
xsubckt_1985_dff_x1 1 0 187 48 2023 dff_x1
xsubckt_1930_dff_x1 1 0 81 66 2037 dff_x1
xsubckt_1771_nand3_x0 1 0 986 717 746 2009 nand3_x0
xsubckt_1485_and2_x1 1 0 1253 446 1997 and2_x1
xsubckt_1478_nor3_x0 1 0 190 1258 1259 18 nor3_x0
xsubckt_610_or21nand_x0 1 0 182 287 289 296 or21nand_x0
xsubckt_588_nand2_x0 1 0 307 309 598 nand2_x0
xsubckt_356_and2_x1 1 0 515 593 2068 and2_x1
xsubckt_104_inv_x0 1 0 1982 759 inv_x0
xsubckt_225_or21nand_x0 1 0 638 737 642 717 or21nand_x0
xsubckt_660_and4_x1 1 0 241 242 251 259 267 and4_x1
xsubckt_787_nand3_x0 1 0 1868 779 780 1999 nand3_x0
xsubckt_1165_or3_x1 1 0 112 1502 1503 1654 or3_x1
xdiode_17 1 0 327 diode_w1
xfeed_74 1 0 decap_w0
xspare_feed_113 1 0 tie
xspare_feed_49 1 0 tie
xsubckt_1826_nexor2_x0 1 0 934 957 932 nexor2_x0
xsubckt_1605_and21nor_x0 1 0 1148 746 717 606 and21nor_x0
xsubckt_1422_or2_x1 1 0 1302 1304 1305 or2_x1
xsubckt_1344_nand4_x0 1 0 1365 1377 1762 1807 1813 nand4_x0
xsubckt_630_and2_x1 1 0 268 270 277 and2_x1
xsubckt_484_and21nor_x0 1 0 399 2041 669 401 and21nor_x0
xsubckt_429_and2_x1 1 0 444 445 447 and2_x1
xsubckt_77_inv_x0 1 0 1965 786 inv_x0
xsubckt_268_nand4_x0 1 0 595 717 752 1965 787 nand4_x0
xsubckt_928_and2_x1 1 0 1734 1735 1736 and2_x1
xsubckt_995_and2_x1 1 0 1667 1668 1698 and2_x1
xdiode_14 1 0 682 diode_w1
xfeed_77 1 0 decap_w0
xspare_feed_110 1 0 tie
xsubckt_1859_mux2_x1 1 0 923 921 905 900 mux2_x1
xsubckt_1655_and3_x1 1 0 1099 717 746 2018 and3_x1
xsubckt_1540_and4_x1 1 0 1202 717 723 752 756 and4_x1
xsubckt_693_and4_x1 1 0 1954 1956 223 234 241 and4_x1
xsubckt_696_or21nand_x0 1 0 168 1952 1955 220 or21nand_x0
xsubckt_1117_and4_x1 1 0 1547 1549 1550 1704 1705 and4_x1
xsubckt_1162_and4_x1 1 0 1504 1505 1506 1626 1685 and4_x1
xsubckt_1268_or21nand_x0 1 0 80 774 1424 1418 or21nand_x0
xdiode_15 1 0 682 diode_w1
xfeed_76 1 0 decap_w0
xspare_feed_111 1 0 decap_w0
xsubckt_1644_nand3_x0 1 0 1109 1111 1113 1142 nand3_x0
xsubckt_1621_nor2_x0 1 0 1132 1133 1135 nor2_x0
xsubckt_1357_nand2_x0 1 0 1352 1591 1637 nand2_x0
xsubckt_579_nexor2_x0 1 0 2077 1998 316 nexor2_x0
xsubckt_853_mux2_x1 1 0 814 767 2023 1809 mux2_x1
xsubckt_1151_nand2_x0 1 0 1514 1576 1764 nand2_x0
xsubckt_1236_and21nor_x0 1 0 1439 1478 643 806 and21nor_x0
xsubckt_1243_and21nor_x0 1 0 1433 1478 643 805 and21nor_x0
xfeed_79 1 0 tie
xspare_feed_44 1 0 tie
xsubckt_1428_and3_x1 1 0 1297 1363 1591 1759 and3_x1
xsubckt_1402_and21nor_x0 1 0 150 1318 1319 8 and21nor_x0
xsubckt_500_or21nand_x0 1 0 385 820 665 387 or21nand_x0
xsubckt_409_or21nand_x0 1 0 464 469 467 465 or21nand_x0
xsubckt_1052_and2_x1 1 0 1611 1612 1614 and2_x1
xsubckt_1114_nand2_x0 1 0 1550 299 691 nand2_x0
xfeed_78 1 0 decap_w0
xspare_feed_45 1 0 tie
xsubckt_1991_dff_x1 1 0 197 43 2034 dff_x1
xsubckt_1660_nexor2_x0 1 0 1095 1177 1094 nexor2_x0
xsubckt_1576_or4_x1 1 0 1177 1179 1180 1486 1488 or4_x1
xsubckt_1365_and2_x1 1 0 1345 1346 1796 and2_x1
xsubckt_1308_or21nand_x0 1 0 141 1633 1411 1391 or21nand_x0
xsubckt_613_nand2_x0 1 0 284 2020 828 nand2_x0
xsubckt_51_inv_x0 1 0 2108 812 inv_x0
xsubckt_684_nand2_x0 1 0 220 327 2004 nand2_x0
xsubckt_821_nand3_x0 1 0 1838 779 1999 831 nand3_x0
xsubckt_846_mux2_x1 1 0 812 765 2023 1816 mux2_x1
xsubckt_899_nand2_x0 1 0 1763 299 683 nand2_x0
xdiode_18 1 0 717 diode_w1
xspare_feed_46 1 0 tie
xsubckt_1711_or2_x1 1 0 1044 1046 1047 or2_x1
xsubckt_1689_nexor2_x0 1 0 1067 1100 1065 nexor2_x0
xsubckt_1448_or21nand_x0 1 0 1280 1283 1332 1813 or21nand_x0
xsubckt_43_inv_x0 1 0 2048 820 inv_x0
xsubckt_300_nand2_x0 1 0 564 565 569 nand2_x0
xsubckt_1000_or21nand_x0 1 0 1663 739 641 712 or21nand_x0
xsubckt_1178_nand2_x0 1 0 111 1490 1498 nand2_x0
xdiode_19 1 0 717 diode_w1
xspare_feed_47 1 0 tie
xsubckt_1988_dff_x1 1 0 186 44 2032 dff_x1
xsubckt_1752_and2_x1 1 0 1004 1005 1020 and2_x1
xsubckt_1622_or2_x1 1 0 1131 1133 1135 or2_x1
xsubckt_328_and2_x1 1 0 540 593 2071 and2_x1
xsubckt_136_or21nand_x0 1 0 727 743 740 737 or21nand_x0
xsubckt_48_inv_x0 1 0 2111 815 inv_x0
xsubckt_220_nand2_x0 1 0 643 717 737 nand2_x0
xsubckt_799_nexor2_x0 1 0 1858 1867 1857 nexor2_x0
xsubckt_805_nexor2_x0 1 0 1853 1854 1852 nexor2_x0
xsubckt_886_or21nand_x0 1 0 1776 682 1793 1777 or21nand_x0
xsubckt_1028_nand3_x0 1 0 1635 1753 1756 324 nand3_x0
xspare_feed_40 1 0 tie
xsubckt_1967_dff_x1 1 0 148 44 1984 dff_x1
xsubckt_1912_dff_x1 1 0 101 68 2057 dff_x1
xsubckt_1795_and2_x1 1 0 962 963 967 and2_x1
xsubckt_23_inv_x0 1 0 4 840 inv_x0
xsubckt_772_and4_x1 1 0 1882 1883 707 708 720 and4_x1
xspare_feed_41 1 0 tie
xsubckt_1719_nand2_x0 1 0 1036 1056 1181 nand2_x0
xsubckt_1282_nand3_x0 1 0 1409 682 1993 840 nand3_x0
xsubckt_145_nand4_x0 1 0 718 723 752 1963 842 nand4_x0
xsubckt_46_inv_x0 1 0 2034 817 inv_x0
xsubckt_753_nand3_x0 1 0 1899 1901 1911 1922 nand3_x0
xspare_feed_42 1 0 tie
xsubckt_1965_dff_x1 1 0 164 48 2000 dff_x1
xsubckt_1910_dff_x1 1 0 103 73 2059 dff_x1
xsubckt_1570_nand2_x0 1 0 1183 445 602 nand2_x0
xsubckt_1436_and2_x1 1 0 1290 1291 1365 and2_x1
xsubckt_616_nand2_x0 1 0 281 282 283 nand2_x0
xsubckt_331_and21nor_x0 1 0 537 602 607 852 and21nor_x0
xsubckt_54_inv_x0 1 0 1980 809 inv_x0
xsubckt_301_or2_x1 1 0 2115 564 570 or2_x1
xsubckt_839_nexor2_x0 1 0 1839 793 1822 nexor2_x0
xsubckt_964_and3_x1 1 0 1698 1699 1720 1722 and3_x1
xsubckt_1237_or3_x1 1 0 1438 1439 1441 1442 or3_x1
xsubckt_1262_mux2_x1 1 0 2039 1848 1424 83 mux2_x1
xspare_feed_43 1 0 tie
xsubckt_2017_dff_x1 1 0 170 69 2006 dff_x1
xsubckt_1814_or3_x1 1 0 944 955 956 1120 or3_x1
xsubckt_1756_and2_x1 1 0 1000 1001 1006 and2_x1
xsubckt_1218_and21nor_x0 1 0 1454 1473 607 799 and21nor_x0
xfeed_170 1 0 decap_w0
xfeed_105 1 0 decap_w0
xspare_buffer_33 1 0 75 64 buf_x4
xsubckt_1927_dff_x1 1 0 84 66 2040 dff_x1
xsubckt_1738_or21nand_x0 1 0 1018 812 1148 531 or21nand_x0
xsubckt_89_inv_x0 1 0 2036 774 inv_x0
xsubckt_12_inv_x0 1 0 2016 851 inv_x0
xsubckt_186_nand4_x0 1 0 677 679 685 700 706 nand4_x0
xsubckt_687_nand2_x0 1 0 217 599 2073 nand2_x0
xsubckt_773_and21nor_x0 1 0 1881 1883 706 10 and21nor_x0
xsubckt_871_or2_x1 1 0 1791 1961 2077 or2_x1
xfeed_171 1 0 decap_w0
xfeed_104 1 0 decap_w0
xspare_buffer_32 1 0 75 65 buf_x4
xsubckt_1999_dff_x1 1 0 200 61 2082 dff_x1
xsubckt_1906_dff_x1 1 0 107 72 2063 dff_x1
xsubckt_1788_and21nor_x0 1 0 969 970 972 1119 and21nor_x0
xsubckt_1522_nand2_x0 1 0 1218 1219 840 nand2_x0
xsubckt_1509_and2_x1 1 0 196 1231 1233 and2_x1
xsubckt_1487_or21nand_x0 1 0 1251 1253 654 2106 or21nand_x0
xsubckt_343_and21nor_x0 1 0 527 622 627 811 and21nor_x0
xsubckt_126_and4_x1 1 0 737 786 1964 1966 789 and4_x1
xsubckt_887_nand3_x0 1 0 1775 327 489 740 nand3_x0
xsubckt_896_and4_x1 1 0 1766 717 723 752 840 and4_x1
xfeed_198 1 0 decap_w0
xfeed_172 1 0 decap_w0
xfeed_107 1 0 tie
xspare_buffer_31 1 0 21 18 buf_x4
xsubckt_1925_dff_x1 1 0 86 73 2042 dff_x1
xsubckt_1589_and3_x1 1 0 1164 592 652 733 and3_x1
xsubckt_58_inv_x0 1 0 2022 805 inv_x0
xsubckt_862_and2_x1 1 0 1800 1802 1807 and2_x1
xsubckt_961_and4_x1 1 0 1701 1702 1703 1704 1705 and4_x1
xsubckt_981_and2_x1 1 0 1681 1682 1685 and2_x1
xfeed_199 1 0 decap_w0
xfeed_173 1 0 decap_w0
xfeed_106 1 0 decap_w0
xspare_buffer_30 1 0 75 66 buf_x4
xsubckt_1979_dff_x1 1 0 193 46 2029 dff_x1
xsubckt_1837_nand3_x0 1 0 922 924 925 1181 nand3_x0
xsubckt_1521_nand3_x0 1 0 1219 704 743 755 nand3_x0
xsubckt_420_nand4_x0 1 0 453 598 625 712 744 nand4_x0
xsubckt_736_nand2_x0 1 0 1915 599 2069 nand2_x0
xsubckt_1001_and3_x1 1 0 1662 1663 1665 1783 and3_x1
xsubckt_1091_and2_x1 1 0 1573 1574 1575 and2_x1
xsubckt_1108_and3_x1 1 0 1556 327 624 743 and3_x1
xsubckt_1276_and3_x1 1 0 153 1797 324 840 and3_x1
xfeed_174 1 0 decap_w0
xfeed_101 1 0 decap_w0
xfeed_88 1 0 tie
xspare_buffer_37 1 0 62 60 buf_x4
xsubckt_1533_nand3_x0 1 0 1208 655 743 2111 nand3_x0
xsubckt_553_nand2_x0 1 0 338 339 340 nand2_x0
xsubckt_41_inv_x0 1 0 2050 822 inv_x0
xsubckt_181_nand3_x0 1 0 682 717 723 752 nand3_x0
xsubckt_201_nand4_x0 1 0 662 671 673 677 2052 nand4_x0
xsubckt_1146_nand3_x0 1 0 1519 327 699 717 nand3_x0
xfeed_175 1 0 decap_w0
xfeed_100 1 0 decap_w0
xfeed_89 1 0 tie
xspare_buffer_36 1 0 62 61 buf_x4
xsubckt_2006_dff_x1 1 0 209 57 2091 dff_x1
xsubckt_1894_nor2_x0 1 0 869 1958 2077 nor2_x0
xsubckt_1787_nand3_x0 1 0 970 984 986 1121 nand3_x0
xsubckt_1568_and3_x1 1 0 163 2000 2033 840 and3_x1
xsubckt_1461_and21nor_x0 1 0 1269 466 702 2112 and21nor_x0
xsubckt_1295_nand3_x0 1 0 1399 1752 1797 324 nand3_x0
xsubckt_397_nor3_x0 1 0 476 506 736 753 nor3_x0
xsubckt_1046_and4_x1 1 0 1617 1619 1626 1631 1638 and4_x1
xsubckt_1195_and21nor_x0 1 0 1474 704 743 803 and21nor_x0
xfeed_176 1 0 decap_w0
xfeed_103 1 0 decap_w0
xspare_buffer_35 1 0 21 17 buf_x4
xsubckt_1990_dff_x1 1 0 166 45 2002 dff_x1
xsubckt_1360_and4_x1 1 0 1350 1352 1355 1358 1379 and4_x1
xsubckt_415_nand3_x0 1 0 458 459 462 649 nand3_x0
xsubckt_98_inv_x0 1 0 2027 765 inv_x0
xsubckt_25_inv_x0 1 0 2086 838 inv_x0
xsubckt_760_nand4_x0 1 0 1893 1894 1895 508 643 nand4_x0
xsubckt_817_and2_x1 1 0 1842 2045 840 and2_x1
xsubckt_1211_and21nor_x0 1 0 1460 735 749 853 and21nor_x0
xfeed_177 1 0 decap_w0
xfeed_102 1 0 decap_w0
xspare_buffer_34 1 0 75 63 buf_x4
xsubckt_1984_dff_x1 1 0 188 48 2024 dff_x1
xsubckt_1931_dff_x1 1 0 80 72 2036 dff_x1
xsubckt_1821_nand2_x0 1 0 937 951 1072 nand2_x0
xsubckt_1774_nand3_x0 1 0 983 984 986 1178 nand3_x0
xsubckt_1569_and2_x1 1 0 1184 445 602 and2_x1
xsubckt_1343_and4_x1 1 0 1366 1377 1762 1807 1813 and4_x1
xsubckt_570_nand2_x0 1 0 325 327 2019 nand2_x0
xsubckt_327_and21nor_x0 1 0 541 622 627 813 and21nor_x0
xsubckt_140_and2_x1 1 0 723 1965 1964 and2_x1
xsubckt_101_inv_x0 1 0 1995 762 inv_x0
xfeed_192 1 0 decap_w0
xfeed_178 1 0 decap_w0
xfeed_84 1 0 decap_w0
xsubckt_1730_and3_x1 1 0 1026 1125 1129 2109 and3_x1
xsubckt_602_nand3_x0 1 0 294 323 683 2086 nand3_x0
xsubckt_360_and21nor_x0 1 0 512 622 627 862 and21nor_x0
xsubckt_658_or21nand_x0 1 0 243 794 311 244 or21nand_x0
xsubckt_733_nand2_x0 1 0 1918 327 2014 nand2_x0
xsubckt_878_nor2_x0 1 0 1784 596 617 nor2_x0
xsubckt_999_nand4_x0 1 0 1664 1780 299 486 607 nand4_x0
xsubckt_1059_and3_x1 1 0 1604 1605 1606 1607 and3_x1
xfeed_193 1 0 tie
xfeed_179 1 0 tie
xfeed_85 1 0 decap_w0
xsubckt_1919_dff_x1 1 0 116 26 1967 dff_x1
xsubckt_1779_or21nand_x0 1 0 978 811 1148 523 or21nand_x0
xsubckt_1726_and21nor_x0 1 0 1030 1063 1034 1039 and21nor_x0
xsubckt_339_and2_x1 1 0 530 593 2070 and2_x1
xsubckt_212_and2_x1 1 0 651 652 656 and2_x1
xsubckt_813_or21nand_x0 1 0 1845 665 1880 1847 or21nand_x0
xsubckt_1013_nexor2_x0 1 0 1651 1991 1650 nexor2_x0
xsubckt_1141_and2_x1 1 0 1524 1525 1526 and2_x1
xfeed_190 1 0 decap_w0
xfeed_86 1 0 decap_w0
xspare_buffer_39 1 0 16 15 buf_x4
xsubckt_2010_dff_x1 1 0 183 71 2019 dff_x1
xsubckt_1547_nand4_x0 1 0 1195 704 743 1971 831 nand4_x0
xsubckt_1544_nand3_x0 1 0 1198 655 743 2112 nand3_x0
xsubckt_599_nand2_x0 1 0 183 297 325 nand2_x0
xsubckt_386_nand4_x0 1 0 487 723 788 1967 841 nand4_x0
xsubckt_366_nand2_x0 1 0 2121 507 513 nand2_x0
xsubckt_694_nand4_x0 1 0 1953 1956 223 234 241 nand4_x0
xsubckt_1031_and3_x1 1 0 1632 327 737 740 and3_x1
xsubckt_1228_or21nand_x0 1 0 1446 736 750 2014 or21nand_x0
xfeed_191 1 0 decap_w0
xfeed_87 1 0 decap_w0
xspare_buffer_38 1 0 62 59 buf_x4
xsubckt_1900_and21nor_x0 1 0 127 864 866 869 and21nor_x0
xsubckt_1764_and21nor_x0 1 0 993 1065 1031 994 and21nor_x0
xsubckt_1688_nexor2_x0 1 0 1067 1101 1066 nexor2_x0
xsubckt_1667_nand2_x0 1 0 1087 1088 1089 nand2_x0
xsubckt_1565_and2_x1 1 0 1185 840 2051 and2_x1
xsubckt_66_inv_x0 1 0 2096 797 inv_x0
xsubckt_980_and2_x1 1 0 1682 1683 1684 and2_x1
xsubckt_1254_or21nand_x0 1 0 186 654 1428 1425 or21nand_x0
xfeed_196 1 0 decap_w0
xfeed_109 1 0 decap_w0
xfeed_80 1 0 decap_w0
xsubckt_1862_mux2_x1 1 0 899 2068 830 118 mux2_x1
xsubckt_1649_nand3_x0 1 0 1104 1105 1109 1159 nand3_x0
xsubckt_1586_nand3_x0 1 0 1167 613 623 625 nand3_x0
xsubckt_340_nor4_x0 1 0 529 530 532 533 534 nor4_x0
xsubckt_746_nand2_x0 1 0 1906 599 2068 nand2_x0
xsubckt_906_mux2_x1 1 0 2107 2026 2023 1756 mux2_x1
xfeed_197 1 0 decap_w0
xfeed_81 1 0 decap_w0
xsubckt_2028_dff_x1 1 0 126 55 2076 dff_x1
xsubckt_1704_and21nor_x0 1 0 1051 1053 1054 1119 and21nor_x0
xsubckt_1567_and2_x1 1 0 162 840 2105 and2_x1
xsubckt_1465_and3_x1 1 0 1266 466 702 768 and3_x1
xsubckt_1421_nor2_x0 1 0 1303 1304 1305 nor2_x0
xsubckt_516_and3_x1 1 0 371 372 373 375 and3_x1
xsubckt_393_nand3_x0 1 0 480 481 503 505 nand3_x0
xsubckt_33_inv_x0 1 0 1958 830 inv_x0
xsubckt_725_and21nor_x0 1 0 1925 2108 461 1926 and21nor_x0
xsubckt_1134_and2_x1 1 0 1531 1532 1617 and2_x1
xfeed_194 1 0 decap_w0
xfeed_82 1 0 decap_w0
xsubckt_1976_dff_x1 1 0 140 65 1976 dff_x1
xsubckt_1558_mux2_x1 1 0 1848 1189 1193 99 mux2_x1
xsubckt_1355_nand3_x0 1 0 1354 1355 1358 1379 nand3_x0
xsubckt_561_nand3_x0 1 0 332 443 450 833 nand3_x0
xsubckt_490_nand2_x0 1 0 393 394 395 nand2_x0
xsubckt_724_nand4_x0 1 0 1926 1927 1928 531 643 nand4_x0
xsubckt_942_and21nor_x0 1 0 1720 299 1781 1721 and21nor_x0
xsubckt_1069_and2_x1 1 0 1595 1738 299 and2_x1
xfeed_195 1 0 decap_w0
xfeed_83 1 0 decap_w0
xsubckt_1717_nand2_x0 1 0 1038 1040 1056 nand2_x0
xsubckt_1652_mux2_x1 1 0 1102 2074 830 124 mux2_x1
xsubckt_1561_and2_x1 1 0 1187 2053 840 and2_x1
xsubckt_148_and2_x1 1 0 715 1966 1967 and2_x1
xsubckt_701_nand4_x0 1 0 1947 1948 1949 545 643 nand4_x0
xsubckt_895_and3_x1 1 0 1767 327 743 746 and3_x1
xsubckt_984_and2_x1 1 0 1678 1679 1680 and2_x1
xsubckt_1089_or21nand_x0 1 0 1575 1578 1583 1602 or21nand_x0
xsubckt_1200_or2_x1 1 0 2104 1470 1481 or2_x1
xfeed_112 1 0 decap_w0
xspare_buffer_55 1 0 11 10 buf_x4
xspare_buffer_20 1 0 75 74 buf_x4
xsubckt_1603_and2_x1 1 0 1150 1151 637 and2_x1
xsubckt_1503_and21nor_x0 1 0 1236 1237 683 2033 and21nor_x0
xsubckt_496_nand2_x0 1 0 388 389 840 nand2_x0
xsubckt_142_nand4_x0 1 0 721 723 752 841 1962 nand4_x0
xsubckt_650_and21nor_x0 1 0 250 267 259 251 and21nor_x0
xsubckt_1191_nand3_x0 1 0 1478 731 743 1978 nand3_x0
xfeed_113 1 0 decap_w0
xspare_buffer_54 1 0 49 46 buf_x4
xspare_buffer_21 1 0 75 73 buf_x4
xsubckt_1964_dff_x1 1 0 165 67 2001 dff_x1
xsubckt_1911_dff_x1 1 0 102 74 2058 dff_x1
xsubckt_1829_or21nand_x0 1 0 930 958 939 935 or21nand_x0
xsubckt_1575_nor4_x0 1 0 1178 1179 1180 1486 1488 nor4_x0
xsubckt_321_and3_x1 1 0 546 648 717 2093 and3_x1
xsubckt_64_inv_x0 1 0 2071 799 inv_x0
xsubckt_299_and21nor_x0 1 0 565 2067 609 566 and21nor_x0
xsubckt_642_or21nand_x0 1 0 257 259 267 299 or21nand_x0
xsubckt_729_nand4_x0 1 0 1921 1923 1934 1944 1954 nand4_x0
xsubckt_1039_nand3_x0 1 0 1624 327 704 743 nand3_x0
xfeed_110 1 0 decap_w0
xspare_buffer_57 1 0 49 44 buf_x4
xspare_buffer_22 1 0 75 72 buf_x4
xsubckt_1537_nor3_x0 1 0 1205 2000 1992 1971 nor3_x0
xsubckt_1431_or21nand_x0 1 0 1294 1295 1301 1410 or21nand_x0
xsubckt_1328_nand3_x0 1 0 1380 682 1997 840 nand3_x0
xsubckt_623_nand2_x0 1 0 275 327 2010 nand2_x0
xsubckt_505_and2_x1 1 0 380 588 2110 and2_x1
xsubckt_1048_nor2_x0 1 0 1615 1616 1642 nor2_x0
xsubckt_1093_or21nand_x0 1 0 1571 642 699 743 or21nand_x0
xsubckt_1184_nand3_x0 1 0 1484 1487 1489 607 nand3_x0
xsubckt_1233_and21nor_x0 1 0 1442 639 656 863 and21nor_x0
xfeed_111 1 0 decap_w0
xspare_buffer_56 1 0 49 45 buf_x4
xspare_buffer_23 1 0 21 20 buf_x4
xsubckt_1980_dff_x1 1 0 192 48 2028 dff_x1
xsubckt_1935_dff_x1 1 0 92 72 2048 dff_x1
xsubckt_1748_mux2_x1 1 0 1009 1014 1043 1008 mux2_x1
xsubckt_1590_and2_x1 1 0 1163 1164 1165 and2_x1
xsubckt_1452_and21nor_x0 1 0 1276 1661 1413 1277 and21nor_x0
xsubckt_1451_and2_x1 1 0 1277 1363 1592 and2_x1
xsubckt_414_and4_x1 1 0 459 460 598 625 744 and4_x1
xsubckt_345_and21nor_x0 1 0 525 602 607 848 and21nor_x0
xsubckt_333_or2_x1 1 0 2125 536 542 or2_x1
xsubckt_105_inv_x0 1 0 1992 758 inv_x0
xsubckt_834_nexor2_x0 1 0 1827 1836 1826 nexor2_x0
xsubckt_1081_and21nor_x0 1 0 1583 1590 1801 1815 and21nor_x0
xfeed_116 1 0 decap_w0
xfeed_8 1 0 decap_w0
xspare_buffer_51 1 0 16 12 buf_x4
xspare_buffer_24 1 0 75 71 buf_x4
xsubckt_2027_dff_x1 1 0 125 35 2075 dff_x1
xsubckt_354_nand3_x0 1 0 517 648 717 2089 nand3_x0
xsubckt_657_and2_x1 1 0 244 245 643 and2_x1
xsubckt_715_or21nand_x0 1 0 1934 851 306 1936 or21nand_x0
xsubckt_816_nand2_x0 1 0 90 1843 1845 nand2_x0
xsubckt_858_mux2_x1 1 0 815 768 2023 1804 mux2_x1
xsubckt_1090_nand3_x0 1 0 1574 1580 1760 1762 nand3_x0
xsubckt_1219_nor4_x0 1 0 1453 1454 1455 1456 1457 nor4_x0
xfeed_117 1 0 decap_w0
xfeed_9 1 0 decap_w0
xspare_buffer_50 1 0 62 50 buf_x4
xspare_buffer_25 1 0 75 70 buf_x4
xsubckt_2019_dff_x1 1 0 168 70 2004 dff_x1
xsubckt_624_or21nand_x0 1 0 274 305 599 2010 or21nand_x0
xsubckt_509_and3_x1 1 0 377 443 450 837 and3_x1
xsubckt_641_and2_x1 1 0 258 259 267 and2_x1
xsubckt_832_and2_x1 1 0 1828 1840 794 and2_x1
xsubckt_1040_or2_x1 1 0 1623 326 689 or2_x1
xsubckt_1142_and3_x1 1 0 1523 1524 1528 1529 and3_x1
xsubckt_1145_and2_x1 1 0 1520 1521 1522 and2_x1
xsubckt_1182_nand4_x0 1 0 1486 639 643 656 729 nand4_x0
xfeed_114 1 0 tie
xspare_buffer_53 1 0 49 47 buf_x4
xspare_buffer_26 1 0 75 69 buf_x4
xsubckt_1598_nand4_x0 1 0 1155 1157 478 726 727 nand4_x0
xsubckt_1377_nand3_x0 1 0 1337 682 1970 840 nand3_x0
xsubckt_1302_nand3_x0 1 0 1394 682 1995 840 nand3_x0
xsubckt_525_or2_x1 1 0 363 2119 441 or2_x1
xsubckt_388_and3_x1 1 0 485 486 625 744 and3_x1
xsubckt_168_nand2_x0 1 0 695 1963 1962 nand2_x0
xsubckt_313_and3_x1 1 0 553 648 717 2094 and3_x1
xsubckt_880_or4_x1 1 0 1782 474 591 596 617 or4_x1
xfeed_115 1 0 tie
xfeed_69 1 0 tie
xspare_buffer_52 1 0 49 48 buf_x4
xspare_buffer_27 1 0 21 19 buf_x4
xsubckt_1420_and2_x1 1 0 1304 1363 1659 and2_x1
xsubckt_512_nand2_x0 1 0 375 666 2047 nand2_x0
xsubckt_508_nand3_x0 1 0 2120 378 381 383 nand3_x0
xsubckt_1086_and2_x1 1 0 1578 1579 1762 and2_x1
xfeed_66 1 0 decap_w0
xfeed_4 1 0 decap_w0
xspare_buffer_28 1 0 75 68 buf_x4
xsubckt_1963_dff_x1 1 0 135 42 1971 dff_x1
xsubckt_1916_dff_x1 1 0 97 68 2053 dff_x1
xsubckt_1709_or21nand_x0 1 0 1046 813 1148 538 or21nand_x0
xsubckt_1553_and2_x1 1 0 1191 2057 840 and2_x1
xsubckt_1541_mux2_x1 1 0 831 1203 1205 1201 mux2_x1
xsubckt_1325_mux2_x1 1 0 1825 1382 1389 104 mux2_x1
xsubckt_481_or21nand_x0 1 0 402 821 665 404 or21nand_x0
xsubckt_668_or2_x1 1 0 234 235 238 or2_x1
xsubckt_672_or21nand_x0 1 0 170 231 233 239 or21nand_x0
xsubckt_754_nand3_x0 1 0 1898 1899 1900 299 nand3_x0
xsubckt_823_or21nand_x0 1 0 1836 1839 1841 2069 or21nand_x0
xfeed_67 1 0 tie
xfeed_5 1 0 decap_w0
xspare_buffer_29 1 0 75 67 buf_x4
xsubckt_1920_dff_x1 1 0 115 29 1966 dff_x1
xsubckt_1845_nand2_x0 1 0 914 916 1118 nand2_x0
xsubckt_1715_mux2_x1 1 0 1042 1048 1160 1040 mux2_x1
xsubckt_1291_nand3_x0 1 0 1402 1756 1815 324 nand3_x0
xsubckt_376_and21nor_x0 1 0 497 624 743 751 and21nor_x0
xsubckt_329_and3_x1 1 0 539 648 717 2092 and3_x1
xsubckt_1017_nand3_x0 1 0 1646 327 648 743 nand3_x0
xsubckt_1062_nand3_x0 1 0 1601 1808 1811 324 nand3_x0
xfeed_118 1 0 decap_w0
xfeed_64 1 0 decap_w0
xfeed_6 1 0 decap_w0
xsubckt_1958_dff_x1 1 0 144 44 1980 dff_x1
xsubckt_1794_nand2_x0 1 0 963 980 1072 nand2_x0
xsubckt_1765_or21nand_x0 1 0 992 1066 1032 995 or21nand_x0
xsubckt_1634_and2_x1 1 0 1119 1121 1132 and2_x1
xsubckt_1369_or21nand_x0 1 0 144 1765 1353 1343 or21nand_x0
xsubckt_560_and21nor_x0 1 0 200 440 335 333 and21nor_x0
xsubckt_371_nand2_x0 1 0 502 503 505 nand2_x0
xsubckt_94_inv_x0 1 0 2031 769 inv_x0
xsubckt_29_inv_x0 1 0 2082 834 inv_x0
xsubckt_259_and2_x1 1 0 604 624 743 and2_x1
xsubckt_812_mux2_x1 1 0 2108 2070 735 1846 mux2_x1
xsubckt_998_and4_x1 1 0 1665 1780 299 486 607 and4_x1
xsubckt_1051_nand4_x0 1 0 1612 1760 1764 1802 1814 nand4_x0
xfeed_119 1 0 decap_w0
xfeed_65 1 0 decap_w0
xfeed_7 1 0 decap_w0
xsubckt_1843_nand2_x0 1 0 916 917 918 nand2_x0
xsubckt_1670_mux2_x1 1 0 1086 1089 1144 1084 mux2_x1
xsubckt_1500_or21nand_x0 1 0 1238 654 1239 1251 or21nand_x0
xsubckt_1359_or21nand_x0 1 0 1351 683 1981 840 or21nand_x0
xsubckt_426_nand2_x0 1 0 447 699 717 nand2_x0
xsubckt_200_and3_x1 1 0 663 671 673 677 and3_x1
xsubckt_275_or21nand_x0 1 0 588 739 730 590 or21nand_x0
xsubckt_1120_nand2_x0 1 0 1544 1545 1618 nand2_x0
xsubckt_1277_and4_x1 1 0 1414 1753 1797 1815 324 and4_x1
xfeed_62 1 0 tie
xfeed_0 1 0 decap_w0
xspare_buffer_59 1 0 11 9 buf_x4
xsubckt_2009_dff_x1 1 0 206 57 2088 dff_x1
xsubckt_489_nand2_x0 1 0 394 588 2111 nand2_x0
xsubckt_720_nand2_x0 1 0 1930 327 2015 nand2_x0
xsubckt_742_or21nand_x0 1 0 1909 1912 1921 299 or21nand_x0
xsubckt_755_nand2_x0 1 0 177 1898 1908 nand2_x0
xsubckt_850_mux2_x1 1 0 813 766 2023 1812 mux2_x1
xsubckt_914_and2_x1 1 0 1748 1749 1754 and2_x1
xdiode_22 1 0 743 diode_w1
xfeed_63 1 0 decap_w0
xfeed_1 1 0 decap_w0
xspare_buffer_58 1 0 49 43 buf_x4
xsubckt_1816_mux2_x1 1 0 943 945 975 942 mux2_x1
xsubckt_1799_mux2_x1 1 0 959 2070 830 120 mux2_x1
xsubckt_1315_mux2_x1 1 0 1864 1387 1389 109 mux2_x1
xsubckt_91_inv_x0 1 0 2026 772 inv_x0
xsubckt_231_nand2_x0 1 0 632 635 1963 nand2_x0
xsubckt_890_nand3_x0 1 0 1772 327 488 1962 nand3_x0
xsubckt_1216_and21nor_x0 1 0 1456 735 749 851 and21nor_x0
xdiode_21 1 0 743 diode_w1
xfeed_60 1 0 decap_w0
xfeed_2 1 0 decap_w0
xsubckt_1783_or21nand_x0 1 0 974 343 1154 977 or21nand_x0
xsubckt_1772_and3_x1 1 0 985 1125 1129 2108 and3_x1
xsubckt_1389_nand4_x0 1 0 1328 752 1964 841 842 nand4_x0
xsubckt_32_inv_x0 1 0 2077 831 inv_x0
xsubckt_784_and3_x1 1 0 1871 2001 2076 1999 and3_x1
xsubckt_818_and3_x1 1 0 1841 2001 1999 2077 and3_x1
xdiode_20 1 0 717 diode_w1
xfeed_61 1 0 decap_w0
xfeed_3 1 0 decap_w0
xsubckt_1824_and2_x1 1 0 934 935 938 and2_x1
xsubckt_1746_and21nor_x0 1 0 1010 1012 1013 1119 and21nor_x0
xsubckt_1723_nexor2_x0 1 0 1033 1064 1032 nexor2_x0
xsubckt_287_and2_x1 1 0 577 578 579 and2_x1
xsubckt_879_nor4_x0 1 0 1783 474 591 596 617 nor4_x0
xfeed_228 1 0 decap_w0
xspare_feed_88 1 0 tie
xspare_feed_13 1 0 tie
xsubckt_1608_and21nor_x0 1 0 1145 2073 1149 1146 and21nor_x0
xsubckt_1587_nand2_x0 1 0 1166 1167 2077 nand2_x0
xsubckt_1515_or2_x1 1 0 1225 1226 805 or2_x1
xsubckt_391_or3_x1 1 0 482 484 492 502 or3_x1
xsubckt_63_inv_x0 1 0 2032 800 inv_x0
xsubckt_314_nand3_x0 1 0 552 648 717 2094 nand3_x0
xsubckt_810_mux2_x1 1 0 1848 1855 1879 91 mux2_x1
xfeed_229 1 0 decap_w0
xspare_feed_89 1 0 tie
xspare_feed_12 1 0 tie
xsubckt_1928_dff_x1 1 0 83 72 2039 dff_x1
xsubckt_1836_and3_x1 1 0 923 924 925 1181 and3_x1
xsubckt_379_or2_x1 1 0 494 495 696 or2_x1
xsubckt_114_nand2_x0 1 0 749 751 842 nand2_x0
xsubckt_993_and4_x1 1 0 1669 1670 1671 1673 1678 and4_x1
xsubckt_1192_and2_x1 1 0 1477 1478 643 and2_x1
xsubckt_1230_or21nand_x0 1 0 1444 640 657 2008 or21nand_x0
xsubckt_1245_or21nand_x0 1 0 2097 571 1484 1432 or21nand_x0
xspare_feed_11 1 0 tie
xsubckt_1749_mux2_x1 1 0 1010 1013 1043 1007 mux2_x1
xsubckt_1740_and2_x1 1 0 1016 1017 1019 and2_x1
xsubckt_1735_and2_x1 1 0 1021 1023 1181 and2_x1
xsubckt_1530_or21nand_x0 1 0 1211 1997 1226 1212 or21nand_x0
xsubckt_396_and4_x1 1 0 477 682 692 697 718 and4_x1
xsubckt_7_inv_x0 1 0 2094 856 inv_x0
xsubckt_254_nand4_x0 1 0 609 611 613 620 636 nand4_x0
xspare_feed_10 1 0 tie
xsubckt_1997_dff_x1 1 0 202 57 2084 dff_x1
xsubckt_1908_dff_x1 1 0 105 68 2061 dff_x1
xsubckt_1860_nexor2_x0 1 0 900 931 899 nexor2_x0
xsubckt_1618_and21nor_x0 1 0 1135 445 602 759 and21nor_x0
xsubckt_416_and2_x1 1 0 457 466 639 and2_x1
xsubckt_79_inv_x0 1 0 1988 784 inv_x0
xsubckt_662_or21nand_x0 1 0 171 240 241 247 or21nand_x0
xsubckt_857_mux2_x1 1 0 2112 2031 2023 1805 mux2_x1
xfeed_259 1 0 tie
xspare_feed_17 1 0 tie
xsubckt_1923_dff_x1 1 0 112 29 1963 dff_x1
xsubckt_1324_and2_x1 1 0 1382 2060 840 and2_x1
xsubckt_96_inv_x0 1 0 2029 767 inv_x0
xsubckt_706_or21nand_x0 1 0 1942 1945 1953 299 or21nand_x0
xsubckt_865_mux2_x1 1 0 2105 2024 2023 1797 mux2_x1
xsubckt_1115_nand3_x0 1 0 1549 327 624 740 nand3_x0
xsubckt_1235_or3_x1 1 0 1440 1474 1475 794 or3_x1
xfeed_258 1 0 decap_w0
xspare_feed_16 1 0 tie
xsubckt_1951_dff_x1 1 0 137 47 1973 dff_x1
xsubckt_1619_and2_x1 1 0 1134 473 682 and2_x1
xsubckt_635_nand2_x0 1 0 264 327 2009 nand2_x0
xsubckt_115_and2_x1 1 0 748 1965 787 and2_x1
xsubckt_11_inv_x0 1 0 2092 852 inv_x0
xsubckt_240_nand2_x0 1 0 623 624 740 nand2_x0
xsubckt_651_and3_x1 1 0 249 251 259 267 and3_x1
xsubckt_990_nand2_x0 1 0 1672 1673 1678 nand2_x0
xsubckt_1127_nand3_x0 1 0 1538 327 751 1962 nand3_x0
xspare_feed_15 1 0 tie
xsubckt_2036_dff_x1 1 0 117 35 2067 dff_x1
xsubckt_1880_and3_x1 1 0 880 881 882 1181 and3_x1
xsubckt_1834_nand3_x0 1 0 925 926 928 1178 nand3_x0
xsubckt_1762_and2_x1 1 0 995 446 2001 and2_x1
xsubckt_1462_and3_x1 1 0 1268 466 702 769 and3_x1
xsubckt_1408_and21nor_x0 1 0 130 1372 1330 1314 and21nor_x0
xsubckt_1332_and3_x1 1 0 1377 1757 1797 324 and3_x1
xsubckt_627_and21nor_x0 1 0 271 2071 310 272 and21nor_x0
xsubckt_518_nand3_x0 1 0 369 587 610 2010 nand3_x0
xsubckt_147_or2_x1 1 0 716 1963 1962 or2_x1
xsubckt_274_and21nor_x0 1 0 589 740 731 591 and21nor_x0
xsubckt_309_nand3_x0 1 0 2114 557 558 559 nand3_x0
xsubckt_703_and2_x1 1 0 1945 1946 1950 and2_x1
xsubckt_965_nand3_x0 1 0 1697 1699 1720 1722 nand3_x0
xspare_feed_14 1 0 tie
xsubckt_2026_dff_x1 1 0 127 32 2077 dff_x1
xsubckt_1890_nand2_x0 1 0 871 2078 830 nand2_x0
xsubckt_1631_nand3_x0 1 0 1122 1123 1137 1140 nand3_x0
xsubckt_1356_nor3_x0 1 0 1353 1354 1361 1364 nor3_x0
xsubckt_603_nand3_x0 1 0 293 717 737 828 nand3_x0
xsubckt_135_nand3_x0 1 0 728 738 743 786 nand3_x0
xsubckt_699_nand2_x0 1 0 1949 599 2072 nand2_x0
xfeed_255 1 0 decap_w0
xfeed_220 1 0 tie
xspare_feed_80 1 0 tie
xsubckt_1970_dff_x1 1 0 149 37 1985 dff_x1
xsubckt_1635_nand2_x0 1 0 1118 1121 1132 nand2_x0
xsubckt_285_nand4_x0 1 0 579 671 673 677 2051 nand4_x0
xsubckt_970_or2_x1 1 0 1692 1693 1763 or2_x1
xsubckt_1050_nand3_x0 1 0 1613 1760 1802 1814 nand3_x0
xsubckt_1204_and21nor_x0 1 0 1466 1478 643 807 and21nor_x0
xfeed_254 1 0 decap_w0
xfeed_221 1 0 decap_w0
xspare_feed_81 1 0 tie
xsubckt_1986_dff_x1 1 0 167 45 2003 dff_x1
xsubckt_1933_dff_x1 1 0 94 74 2050 dff_x1
xsubckt_1766_or21nand_x0 1 0 991 1029 1000 1003 or21nand_x0
xsubckt_649_or2_x1 1 0 251 252 255 or2_x1
xsubckt_700_nand3_x0 1 0 1948 323 683 2093 nand3_x0
xsubckt_707_or21nand_x0 1 0 181 1942 1943 1951 or21nand_x0
xsubckt_728_and4_x1 1 0 1922 1923 1934 1944 1954 and4_x1
xsubckt_897_nand4_x0 1 0 1765 717 723 752 840 nand4_x0
xsubckt_1032_and21nor_x0 1 0 1631 1758 1634 1632 and21nor_x0
xsubckt_1250_mux2_x1 1 0 1429 1431 604 1428 mux2_x1
xfeed_257 1 0 decap_w0
xfeed_222 1 0 decap_w0
xspare_feed_82 1 0 tie
xspare_feed_19 1 0 tie
xsubckt_1844_and21nor_x0 1 0 915 917 918 1119 and21nor_x0
xsubckt_1825_nexor2_x0 1 0 934 958 933 nexor2_x0
xsubckt_1694_nand3_x0 1 0 1061 717 746 2011 nand3_x0
xsubckt_1628_and3_x1 1 0 1125 1126 1127 744 and3_x1
xsubckt_106_inv_x0 1 0 2000 757 inv_x0
xsubckt_776_and2_x1 1 0 1878 2050 840 and2_x1
xsubckt_1252_and2_x1 1 0 1426 712 840 and2_x1
xsubckt_1259_or21nand_x0 1 0 85 778 1424 1422 or21nand_x0
xfeed_256 1 0 decap_w0
xfeed_223 1 0 decap_w0
xspare_feed_83 1 0 tie
xspare_feed_18 1 0 tie
xsubckt_1971_dff_x1 1 0 133 42 1969 dff_x1
xsubckt_1902_mux2_x1 1 0 872 2075 830 125 mux2_x1
xsubckt_1728_and3_x1 1 0 1028 717 746 2010 and3_x1
xsubckt_1528_nor4_x0 1 0 1213 2071 2072 2073 2074 nor4_x0
xsubckt_198_or21nand_x0 1 0 665 670 674 678 or21nand_x0
xsubckt_1023_and3_x1 1 0 1640 1756 1816 324 and3_x1
xfeed_251 1 0 tie
xfeed_224 1 0 decap_w0
xspare_feed_84 1 0 decap_w0
xsubckt_1656_nand3_x0 1 0 1098 717 746 2018 nand3_x0
xsubckt_1633_mux2_x1 1 0 1981 1134 1184 1120 mux2_x1
xsubckt_1481_nor3_x0 1 0 189 1256 1257 10 nor3_x0
xsubckt_5_inv_x0 1 0 2005 858 inv_x0
xsubckt_881_and21nor_x0 1 0 1781 1784 1785 756 and21nor_x0
xsubckt_1096_nor3_x0 1 0 1568 1569 1664 1782 nor3_x0
xsubckt_1177_and4_x1 1 0 1490 1491 1493 1497 1720 and4_x1
xsubckt_1279_nand2_x0 1 0 1412 1414 1756 nand2_x0
xfeed_250 1 0 tie
xfeed_225 1 0 tie
xspare_feed_85 1 0 tie
xsubckt_1857_and2_x1 1 0 902 906 922 and2_x1
xsubckt_1384_and3_x1 1 0 1332 1591 1796 1807 and3_x1
xsubckt_501_or21nand_x0 1 0 384 777 668 386 or21nand_x0
xsubckt_408_or21nand_x0 1 0 465 1962 1963 630 or21nand_x0
xsubckt_82_inv_x0 1 0 2042 781 inv_x0
xsubckt_19_inv_x0 1 0 2088 844 inv_x0
xsubckt_872_nor3_x0 1 0 1790 1960 1961 2077 nor3_x0
xsubckt_1123_or2_x1 1 0 114 1542 1557 or2_x1
xsubckt_1209_and21nor_x0 1 0 1462 1478 643 800 and21nor_x0
xfeed_253 1 0 decap_w0
xfeed_226 1 0 decap_w0
xspare_feed_86 1 0 tie
xsubckt_2014_dff_x1 1 0 173 69 2009 dff_x1
xsubckt_1881_nand3_x0 1 0 879 881 882 1181 nand3_x0
xsubckt_1664_and21nor_x0 1 0 1090 1096 1098 1131 and21nor_x0
xsubckt_1645_and2_x1 1 0 1108 1111 1181 and2_x1
xsubckt_1615_or21nand_x0 1 0 1138 816 1148 561 or21nand_x0
xsubckt_1584_or2_x1 1 0 1169 1170 602 or2_x1
xsubckt_1333_nand3_x0 1 0 1376 1757 1797 324 nand3_x0
xsubckt_511_nor2_x0 1 0 203 376 377 nor2_x0
xsubckt_788_or21nand_x0 1 0 1867 1869 1871 2073 or21nand_x0
xsubckt_1128_and2_x1 1 0 1537 1538 1539 and2_x1
xfeed_252 1 0 decap_w0
xfeed_227 1 0 decap_w0
xspare_feed_87 1 0 decap_w0
xsubckt_2008_dff_x1 1 0 207 56 2089 dff_x1
xsubckt_1666_nand3_x0 1 0 1088 1096 1098 1121 nand3_x0
xsubckt_1366_nor4_x0 1 0 1344 1345 1361 1364 682 nor4_x0
xsubckt_639_or21nand_x0 1 0 260 796 311 261 or21nand_x0
xsubckt_764_and2_x1 1 0 1889 1891 1899 and2_x1
xsubckt_1041_and3_x1 1 0 1622 1623 1624 1625 and3_x1
xfeed_48 1 0 decap_w0
xsubckt_1712_and21nor_x0 1 0 1043 370 1153 1044 and21nor_x0
xsubckt_1419_and3_x1 1 0 1305 1375 1757 1762 and3_x1
xsubckt_825_mux2_x1 1 0 2107 1835 735 1834 mux2_x1
xsubckt_1007_nand3_x0 1 0 1656 327 648 740 nand3_x0
xfeed_49 1 0 decap_w0
xsubckt_1307_nand3_x0 1 0 1391 682 1977 840 nand3_x0
xsubckt_1299_nand3_x0 1 0 1396 682 1974 840 nand3_x0
xsubckt_59_inv_x0 1 0 2074 804 inv_x0
xsubckt_691_or21nand_x0 1 0 1956 855 306 215 or21nand_x0
xsubckt_1084_nand3_x0 1 0 1580 1797 1816 324 nand3_x0
xsubckt_1144_nand2_x0 1 0 1521 299 710 nand2_x0
xsubckt_1776_and3_x1 1 0 981 982 983 1181 and3_x1
xsubckt_586_and21nor_x0 1 0 309 737 717 683 and21nor_x0
xsubckt_21_inv_x0 1 0 1962 842 inv_x0
xsubckt_1016_nand3_x0 1 0 1647 299 743 746 nand3_x0
xsubckt_1246_or21nand_x0 1 0 140 683 828 840 or21nand_x0
xsubckt_2022_dff_x1 1 0 179 61 2015 dff_x1
xsubckt_1841_or21nand_x0 1 0 918 927 929 1132 or21nand_x0
xsubckt_1020_nand3_x0 1 0 1643 1644 1645 1648 nand3_x0
xfeed_39 1 0 decap_w0
xsubckt_1820_or21nand_x0 1 0 938 941 947 951 or21nand_x0
xsubckt_1724_nexor2_x0 1 0 1033 1063 1031 nexor2_x0
xsubckt_1657_and3_x1 1 0 1097 1125 1129 2111 and3_x1
xsubckt_1557_and2_x1 1 0 1189 2055 840 and2_x1
xsubckt_1415_or21nand_x0 1 0 1308 683 1985 840 or21nand_x0
xsubckt_587_and2_x1 1 0 308 309 598 and2_x1
xsubckt_504_or21nand_x0 1 0 381 593 600 2085 or21nand_x0
xsubckt_52_inv_x0 1 0 2107 811 inv_x0
xsubckt_302_and21nor_x0 1 0 563 602 607 857 and21nor_x0
xsubckt_838_or21nand_x0 1 0 1823 1836 1828 1829 or21nand_x0
xsubckt_1054_nand3_x0 1 0 1609 327 717 737 nand3_x0
xfeed_38 1 0 decap_w0
xsubckt_2033_dff_x1 1 0 120 52 2070 dff_x1
xsubckt_1713_or21nand_x0 1 0 1042 371 1154 1045 or21nand_x0
xsubckt_1562_mux2_x1 1 0 1834 1187 1193 97 mux2_x1
xsubckt_598_or3_x1 1 0 297 298 300 301 or3_x1
xsubckt_556_and21nor_x0 1 0 335 724 342 336 and21nor_x0
xsubckt_422_and21nor_x0 1 0 451 452 454 483 and21nor_x0
xsubckt_726_and2_x1 1 0 1924 1925 1929 and2_x1
xsubckt_864_mux2_x1 1 0 862 770 2023 1798 mux2_x1
xsubckt_910_mux2_x1 1 0 2106 2025 2023 1752 mux2_x1
xsubckt_939_and4_x1 1 0 1723 1724 1726 1727 1730 and4_x1
xsubckt_1158_and4_x1 1 0 1508 1707 1708 1718 1719 and4_x1
xsubckt_2003_dff_x1 1 0 212 57 2094 dff_x1
xsubckt_1870_or2_x1 1 0 890 892 893 or2_x1
xsubckt_1493_or21nand_x0 1 0 1245 2068 791 757 or21nand_x0
xsubckt_631_and4_x1 1 0 267 269 278 290 301 and4_x1
xsubckt_568_nor2_x0 1 0 327 1958 2 nor2_x0
xsubckt_520_nand2_x0 1 0 367 588 2109 nand2_x0
xsubckt_150_and4_x1 1 0 713 715 717 786 1964 and4_x1
xsubckt_3_inv_x0 1 0 2043 860 inv_x0
xsubckt_244_and4_x1 1 0 619 732 788 1967 1963 and4_x1
xsubckt_1066_and3_x1 1 0 1597 1598 1603 1611 and3_x1
xsubckt_1922_dff_x1 1 0 113 26 1964 dff_x1
xsubckt_1284_nand3_x0 1 0 1408 682 1994 840 nand3_x0
xsubckt_770_nor2_x0 1 0 1884 1885 785 nor2_x0
xsubckt_820_and3_x1 1 0 1839 779 1999 831 and3_x1
xfeed_40 1 0 decap_w0
xfeed_35 1 0 decap_w0
xsubckt_1781_or21nand_x0 1 0 976 795 1150 979 or21nand_x0
xsubckt_1595_nand3_x0 1 0 1158 1160 1162 1176 nand3_x0
xsubckt_1304_nand3_x0 1 0 1393 682 1996 840 nand3_x0
xsubckt_1293_or21nand_x0 1 0 136 1411 1401 1404 or21nand_x0
xsubckt_45_inv_x0 1 0 1984 818 inv_x0
xsubckt_247_nand2_x0 1 0 616 711 841 nand2_x0
xsubckt_907_and2_x1 1 0 1755 1756 324 and2_x1
xsubckt_1130_nand4_x0 1 0 1535 1609 1610 1704 1705 nand4_x0
xfeed_41 1 0 decap_w0
xfeed_34 1 0 decap_w0
xsubckt_1687_mux2_x1 1 0 1092 1071 1076 1067 mux2_x1
xsubckt_1334_and4_x1 1 0 1375 1752 1797 1816 324 and4_x1
xsubckt_582_and2_x1 1 0 313 314 315 and2_x1
xsubckt_86_inv_x0 1 0 2040 777 inv_x0
xsubckt_1131_or3_x1 1 0 1534 1535 1712 1713 or3_x1
xsubckt_1258_nand2_x0 1 0 1422 1863 669 nand2_x0
xfeed_42 1 0 tie
xfeed_37 1 0 decap_w0
xsubckt_1947_dff_x1 1 0 142 38 1978 dff_x1
xsubckt_1743_or21nand_x0 1 0 1013 1026 1028 1132 or21nand_x0
xsubckt_1550_nand4_x0 1 0 1193 1881 671 673 677 nand4_x0
xsubckt_1434_nand3_x0 1 0 1292 1809 1815 324 nand3_x0
xsubckt_1381_nor4_x0 1 0 1334 1335 1367 1369 682 nor4_x0
xsubckt_494_and21nor_x0 1 0 390 450 443 2127 and21nor_x0
xsubckt_844_and2_x1 1 0 1817 1818 1820 and2_x1
xsubckt_915_nand2_x0 1 0 1747 1749 1754 nand2_x0
xfeed_43 1 0 tie
xfeed_36 1 0 tie
xsubckt_1867_and3_x1 1 0 893 717 746 2006 and3_x1
xsubckt_1309_nand3_x0 1 0 1390 682 1978 840 nand3_x0
xsubckt_1297_nand3_x0 1 0 1397 682 1973 840 nand3_x0
xsubckt_486_and21nor_x0 1 0 397 399 403 725 and21nor_x0
xsubckt_71_inv_x0 1 0 1994 792 inv_x0
xsubckt_194_and21nor_x0 1 0 669 671 673 678 and21nor_x0
xsubckt_800_mux2_x1 1 0 2110 1857 735 1856 mux2_x1
xsubckt_1021_or3_x1 1 0 1642 1643 1655 1662 or3_x1
xsubckt_1121_nor3_x0 1 0 1543 1544 1551 1642 nor3_x0
xsubckt_1169_and2_x1 1 0 1498 1499 1555 and2_x1
xfeed_44 1 0 tie
xfeed_31 1 0 decap_w0
xsubckt_1864_or21nand_x0 1 0 896 931 902 903 or21nand_x0
xsubckt_1828_and21nor_x0 1 0 931 957 938 936 and21nor_x0
xsubckt_1468_and3_x1 1 0 1264 466 702 767 and3_x1
xsubckt_1338_and3_x1 1 0 1371 1373 1400 1757 and3_x1
xsubckt_1305_nand2_x0 1 0 1392 1407 1637 nand2_x0
xsubckt_544_nand2_x0 1 0 347 666 2045 nand2_x0
xsubckt_535_or21nand_x0 1 0 354 593 600 2083 or21nand_x0
xsubckt_261_and21nor_x0 1 0 602 743 624 606 and21nor_x0
xsubckt_900_or21nand_x0 1 0 1762 1803 1805 324 or21nand_x0
xsubckt_932_and2_x1 1 0 1730 1731 1732 and2_x1
xfeed_45 1 0 decap_w0
xfeed_30 1 0 tie
xsubckt_1397_and3_x1 1 0 164 1322 1326 840 and3_x1
xsubckt_322_nand3_x0 1 0 545 648 717 2093 nand3_x0
xsubckt_655_and21nor_x0 1 0 246 306 598 863 and21nor_x0
xsubckt_1106_nor2_x0 1 0 1558 1559 1568 nor2_x0
xsubckt_1119_and3_x1 1 0 1545 1546 1723 1733 and3_x1
xsubckt_1270_or21nand_x0 1 0 1417 773 2021 826 or21nand_x0
xfeed_46 1 0 decap_w0
xsubckt_1551_and2_x1 1 0 1192 2058 840 and2_x1
xsubckt_1363_nand4_x0 1 0 1347 1752 1804 1805 324 nand4_x0
xsubckt_389_nand3_x0 1 0 484 485 490 651 nand3_x0
xsubckt_83_inv_x0 1 0 2076 780 inv_x0
xsubckt_18_inv_x0 1 0 2013 845 inv_x0
xsubckt_206_and2_x1 1 0 657 714 740 and2_x1
xsubckt_963_and2_x1 1 0 1699 1700 1709 and2_x1
xsubckt_1034_nand3_x0 1 0 1629 1762 1807 1813 nand3_x0
xfeed_47 1 0 tie
xfeed_32 1 0 decap_w0
xsubckt_1375_nand2_x0 1 0 1338 682 1975 nand2_x0
xsubckt_1300_nand2_x0 1 0 1395 1403 1637 nand2_x0
xsubckt_491_and21nor_x0 1 0 392 2073 609 393 and21nor_x0
xsubckt_315_and2_x1 1 0 551 593 2073 and2_x1
xsubckt_973_and4_x1 1 0 1689 696 699 1958 840 and4_x1
xsubckt_1167_and4_x1 1 0 1500 1606 1607 1624 1625 and4_x1
xfeed_277 1 0 decap_w0
xspare_feed_62 1 0 tie
xsubckt_1901_mux2_x1 1 0 988 2076 830 126 mux2_x1
xsubckt_615_nand3_x0 1 0 282 323 683 2085 nand3_x0
xsubckt_166_nand2_x0 1 0 697 699 1963 nand2_x0
xsubckt_904_and3_x1 1 0 1758 1760 1762 1764 and3_x1
xfeed_276 1 0 decap_w0
xspare_feed_63 1 0 tie
xsubckt_604_nand2_x0 1 0 292 293 294 nand2_x0
xsubckt_743_or21nand_x0 1 0 178 1909 1910 1918 or21nand_x0
xsubckt_814_and2_x1 1 0 1844 1846 1881 and2_x1
xsubckt_1012_mux2_x1 1 0 1652 1653 1989 1651 mux2_x1
xsubckt_1025_and21nor_x0 1 0 1638 1758 1639 1641 and21nor_x0
xfeed_275 1 0 tie
xspare_feed_60 1 0 tie
xsubckt_1592_and21nor_x0 1 0 1161 445 602 790 and21nor_x0
xsubckt_1453_and21nor_x0 1 0 1275 1589 1413 1374 and21nor_x0
xsubckt_1376_and21nor_x0 1 0 139 1338 1339 7 and21nor_x0
xsubckt_591_or21nand_x0 1 0 304 305 599 2019 or21nand_x0
xsubckt_524_or21nand_x0 1 0 2119 725 371 364 or21nand_x0
xsubckt_14_inv_x0 1 0 2015 849 inv_x0
xsubckt_1074_nand3_x0 1 0 1590 1803 1806 324 nand3_x0
xfeed_274 1 0 tie
xspare_feed_61 1 0 tie
xsubckt_1926_dff_x1 1 0 85 67 2041 dff_x1
xsubckt_449_nand3_x0 1 0 429 443 450 2090 nand3_x0
xsubckt_203_and2_x1 1 0 660 661 662 and2_x1
xsubckt_988_nand3_x0 1 0 1674 327 642 717 nand3_x0
xsubckt_1092_and21nor_x0 1 0 1572 1573 1584 327 and21nor_x0
xsubckt_1153_and3_x1 1 0 1512 1513 1514 1515 and3_x1
xfeed_273 1 0 decap_w0
xspare_feed_66 1 0 tie
xsubckt_1733_nexor2_x0 1 0 1024 1177 1023 nexor2_x0
xsubckt_1427_and2_x1 1 0 133 1298 1300 and2_x1
xsubckt_373_and3_x1 1 0 500 501 595 721 and3_x1
xsubckt_348_nor4_x0 1 0 522 524 525 526 527 nor4_x0
xsubckt_78_inv_x0 1 0 1983 785 inv_x0
xsubckt_193_nand2_x0 1 0 670 672 687 nand2_x0
xsubckt_1002_and3_x1 1 0 1661 1806 1808 324 and3_x1
xsubckt_1275_and3_x1 1 0 154 1752 324 840 and3_x1
xfeed_272 1 0 decap_w0
xfeed_139 1 0 decap_w0
xspare_feed_67 1 0 tie
xsubckt_479_nand4_x0 1 0 404 671 673 678 2065 nand4_x0
xsubckt_169_nand2_x0 1 0 694 696 699 nand2_x0
xsubckt_211_or21nand_x0 1 0 652 655 714 743 or21nand_x0
xsubckt_652_nor3_x0 1 0 248 249 250 298 nor3_x0
xfeed_271 1 0 decap_w0
xspare_buffer_79 1 0 6 3 buf_x4
xspare_feed_64 1 0 tie
xsubckt_1773_nand3_x0 1 0 984 1125 1129 2108 nand3_x0
xsubckt_1769_or21nand_x0 1 0 988 997 992 991 or21nand_x0
xsubckt_1323_mux2_x1 1 0 1834 1383 1389 105 mux2_x1
xsubckt_785_nand3_x0 1 0 1870 2001 2076 1999 nand3_x0
xsubckt_819_nand3_x0 1 0 1840 2001 1999 2077 nand3_x0
xsubckt_1097_or21nand_x0 1 0 1567 320 1650 315 or21nand_x0
xsubckt_1171_and4_x1 1 0 1496 1679 1680 1771 1772 and4_x1
xfeed_270 1 0 decap_w0
xspare_buffer_78 1 0 36 27 buf_x4
xspare_feed_65 1 0 tie
xsubckt_1577_nand2_x0 1 0 1176 1177 1182 nand2_x0
xsubckt_611_nand2_x0 1 0 286 327 2011 nand2_x0
xsubckt_57_inv_x0 1 0 2003 806 inv_x0
xsubckt_224_nand2_x0 1 0 639 642 717 nand2_x0
xsubckt_288_or21nand_x0 1 0 576 860 665 579 or21nand_x0
xsubckt_1104_nand4_x0 1 0 1560 1561 1562 1564 1565 nand4_x0
xfeed_134 1 0 decap_w0
xspare_buffer_77 1 0 36 28 buf_x4
xsubckt_1868_and3_x1 1 0 892 1125 1129 2105 and3_x1
xsubckt_1320_and2_x1 1 0 1384 2062 840 and2_x1
xsubckt_483_nand4_x0 1 0 400 671 673 677 2057 nand4_x0
xsubckt_30_inv_x0 1 0 2081 833 inv_x0
xsubckt_9_inv_x0 1 0 2093 854 inv_x0
xsubckt_164_nor4_x0 1 0 699 1965 1964 1966 1967 nor4_x0
xsubckt_191_nand4_x0 1 0 672 717 723 752 1987 nand4_x0
xsubckt_747_nand3_x0 1 0 1905 323 683 2089 nand3_x0
xsubckt_847_mux2_x1 1 0 2108 2027 2023 1815 mux2_x1
xsubckt_972_and2_x1 1 0 1690 1691 1692 and2_x1
xfeed_135 1 0 decap_w0
xspare_buffer_76 1 0 36 29 buf_x4
xsubckt_1955_dff_x1 1 0 161 43 1997 dff_x1
xsubckt_1578_and2_x1 1 0 1175 1975 2034 and2_x1
xsubckt_1573_and21nor_x0 1 0 1180 445 602 809 and21nor_x0
xsubckt_1407_or21nand_x0 1 0 1314 683 1960 840 or21nand_x0
xsubckt_1350_nand3_x0 1 0 1359 1752 1756 324 nand3_x0
xsubckt_457_and21nor_x0 1 0 206 424 425 14 and21nor_x0
xsubckt_237_and3_x1 1 0 626 715 717 732 and3_x1
xsubckt_1043_nand4_x0 1 0 1620 1760 1764 1802 1813 nand4_x0
xsubckt_1135_nand2_x0 1 0 1530 1531 1768 nand2_x0
xfeed_136 1 0 decap_w0
xspare_buffer_75 1 0 6 4 buf_x4
xspare_feed_68 1 0 tie
xsubckt_1673_or21nand_x0 1 0 1081 814 1148 545 or21nand_x0
xsubckt_1606_or21nand_x0 1 0 1147 745 716 605 or21nand_x0
xsubckt_1581_and3_x1 1 0 1172 1173 2034 818 and3_x1
xsubckt_1538_and21nor_x0 1 0 1204 2034 761 1974 and21nor_x0
xsubckt_1512_nand2_x0 1 0 1228 1229 653 nand2_x0
xsubckt_558_nand3_x0 1 0 334 443 450 834 nand3_x0
xsubckt_555_nand2_x0 1 0 336 337 341 nand2_x0
xsubckt_506_and21nor_x0 1 0 379 2072 609 380 and21nor_x0
xsubckt_335_and21nor_x0 1 0 534 622 627 812 and21nor_x0
xsubckt_332_or4_x1 1 0 536 537 539 540 541 or4_x1
xsubckt_154_nand3_x0 1 0 709 711 1963 842 nand3_x0
xsubckt_109_and2_x1 1 0 754 786 1964 and2_x1
xsubckt_195_or21nand_x0 1 0 668 670 674 677 or21nand_x0
xsubckt_293_and4_x1 1 0 571 574 575 578 579 and4_x1
xsubckt_750_and2_x1 1 0 1902 1903 1907 and2_x1
xsubckt_801_mux2_x1 1 0 1856 1861 1879 92 mux2_x1
xsubckt_920_nand2_x0 1 0 1742 1744 1745 nand2_x0
xsubckt_1157_and4_x1 1 0 1509 1675 1676 1704 1705 and4_x1
xfeed_137 1 0 decap_w0
xspare_buffer_74 1 0 36 30 buf_x4
xspare_feed_69 1 0 tie
xsubckt_2013_dff_x1 1 0 174 71 2010 dff_x1
xsubckt_1662_and2_x1 1 0 1092 1094 1181 and2_x1
xsubckt_1474_and3_x1 1 0 1260 466 702 765 and3_x1
xsubckt_1399_and3_x1 1 0 1320 1375 1762 1807 and3_x1
xsubckt_434_nand3_x0 1 0 439 443 450 2095 nand3_x0
xsubckt_358_nand2_x0 1 0 2122 514 521 nand2_x0
xsubckt_139_nand3_x0 1 0 724 726 727 749 nand3_x0
xsubckt_749_and21nor_x0 1 0 1903 2106 461 1904 and21nor_x0
xsubckt_917_nand3_x0 1 0 1745 327 740 746 nand3_x0
xsubckt_1076_nand2_x0 1 0 1588 1591 1807 nand2_x0
xsubckt_1136_nand3_x0 1 0 1529 1739 1764 1815 nand3_x0
xfeed_130 1 0 decap_w0
xspare_buffer_73 1 0 36 31 buf_x4
xsubckt_1437_nand2_x0 1 0 1289 1291 1365 nand2_x0
xsubckt_1289_nand3_x0 1 0 1404 682 1972 840 nand3_x0
xsubckt_540_and3_x1 1 0 350 443 450 835 and3_x1
xsubckt_346_and3_x1 1 0 524 648 717 2090 and3_x1
xsubckt_758_nand3_x0 1 0 1895 323 683 2088 nand3_x0
xfeed_131 1 0 decap_w0
xspare_buffer_72 1 0 36 32 buf_x4
xsubckt_1960_dff_x1 1 0 139 39 1975 dff_x1
xsubckt_1915_dff_x1 1 0 98 74 2054 dff_x1
xsubckt_1601_or21nand_x0 1 0 1152 402 398 1153 or21nand_x0
xsubckt_1579_mux2_x1 1 0 1992 2034 1975 1174 mux2_x1
xsubckt_149_and3_x1 1 0 714 715 786 1964 and3_x1
xsubckt_68_inv_x0 1 0 2069 795 inv_x0
xsubckt_270_nand3_x0 1 0 593 595 597 598 nand3_x0
xsubckt_656_nand3_x0 1 0 245 323 683 2081 nand3_x0
xsubckt_912_and3_x1 1 0 1750 1752 1798 324 and3_x1
xsubckt_1030_nand2_x0 1 0 1633 1636 1695 nand2_x0
xsubckt_1047_nand4_x0 1 0 1616 1619 1626 1631 1638 nand4_x0
xsubckt_1133_and3_x1 1 0 1532 1533 1536 1733 and3_x1
xfeed_279 1 0 decap_w0
xfeed_132 1 0 decap_w0
xspare_buffer_71 1 0 6 5 buf_x4
xsubckt_1929_dff_x1 1 0 82 74 2038 dff_x1
xsubckt_609_or21nand_x0 1 0 287 301 290 299 or21nand_x0
xsubckt_447_or21nand_x0 1 0 430 442 451 2124 or21nand_x0
xsubckt_235_and4_x1 1 0 628 732 788 1967 842 and4_x1
xfeed_278 1 0 tie
xfeed_133 1 0 decap_w0
xspare_buffer_70 1 0 36 33 buf_x4
xsubckt_1654_or21nand_x0 1 0 1100 1158 1106 1109 or21nand_x0
xsubckt_1571_and21nor_x0 1 0 1182 445 602 808 and21nor_x0
xsubckt_1432_nand2_x0 1 0 132 1294 675 nand2_x0
xsubckt_1345_or2_x1 1 0 1364 1371 1374 or2_x1
xsubckt_617_and21nor_x0 1 0 280 2072 310 281 and21nor_x0
xsubckt_514_nand4_x0 1 0 373 671 673 677 2055 nand4_x0
xsubckt_232_nand3_x0 1 0 631 642 695 716 nand3_x0
xsubckt_969_nand4_x0 1 0 1693 1695 1754 1762 1807 nand4_x0
xsubckt_1027_and3_x1 1 0 1636 1753 1756 324 and3_x1
.ends Arlet6502_cts_r
