* Coriolis Structural SPICE Driver
* Generated on Feb 03, 2026, 23:22
* Cell/Subckt "cordic_top_cts_r".
*
* INTERF wr_top
* INTERF wok_top
* INTERF vss
* INTERF vdd
* INTERF rok_top
* INTERF reset
* INTERF rd_top
* INTERF data_out[7]
* INTERF data_out[6]
* INTERF data_out[5]
* INTERF data_out[4]
* INTERF data_out[3]
* INTERF data_out[2]
* INTERF data_out[1]
* INTERF data_out[0]
* INTERF data_in[7]
* INTERF data_in[6]
* INTERF data_in[5]
* INTERF data_in[4]
* INTERF data_in[3]
* INTERF data_in[2]
* INTERF data_in[1]
* INTERF data_in[0]
* INTERF clk

* Terminal models (aka standard cells) used througout all the hierarchy.
.include tie.spi
.include decap_w0.spi
.include nexor2_x0.spi
.include and2_x1.spi
.include nand2_x0.spi
.include or21nand_x0.spi
.include nand3_x0.spi
.include mux2_x1.spi
.include and21nor_x0.spi
.include nand4_x0.spi
.include or4_x1.spi
.include buf_x4.spi
.include inv_x0.spi
.include and4_x1.spi
.include and3_x1.spi
.include dff_x1.spi
.include or2_x1.spi
.include xor2_x0.spi
.include diode_w1.spi
.include nor4_x0.spi
.include or3_x1.spi
.include nor2_x0.spi
.include nor3_x0.spi
.include buf_x1.spi

* Non-terminal models (part of the user's design hierarchy).

.subckt cordic_top_cts_r 80 81 82 83 87 88 89 252 253 254 255 256 257 258 259 260 261 262 263 264 265 266 267 270
* NET     0 = ykc[9]
* NET     1 = ykc[8]
* NET     2 = ykc[7]
* NET     3 = ykc[6]
* NET     4 = ykc[5]
* NET     5 = ykc[4]
* NET     6 = ykc[3]
* NET     7 = ykc[2]
* NET     8 = ykc[15]
* NET     9 = ykc[14]
* NET    10 = ykc[13]
* NET    11 = ykc[12]
* NET    12 = ykc[11]
* NET    13 = ykc[10]
* NET    14 = ykc[1]
* NET    15 = ykc[0]
* NET    16 = y_reg[7]
* NET    17 = y_reg[6]
* NET    18 = y_reg[5]
* NET    19 = y_reg[4]
* NET    20 = y_reg[3]
* NET    21 = y_reg[2]
* NET    22 = y_reg[1]
* NET    23 = y_reg[0]
* NET    24 = y[9]
* NET    25 = y[8]
* NET    26 = y[7]
* NET    27 = y[6]
* NET    28 = y[5]
* NET    29 = y[4]
* NET    30 = y[3]
* NET    31 = y[2]
* NET    32 = y[15]
* NET    33 = y[14]
* NET    34 = y[13]
* NET    35 = y[12]
* NET    36 = y[11]
* NET    37 = y[10]
* NET    38 = y[1]
* NET    39 = y[0]
* NET    40 = xkc[9]
* NET    41 = xkc[8]
* NET    42 = xkc[7]
* NET    43 = xkc[6]
* NET    44 = xkc[5]
* NET    45 = xkc[4]
* NET    46 = xkc[3]
* NET    47 = xkc[2]
* NET    48 = xkc[15]
* NET    49 = xkc[14]
* NET    50 = xkc[13]
* NET    51 = xkc[12]
* NET    52 = xkc[11]
* NET    53 = xkc[10]
* NET    54 = xkc[1]
* NET    55 = xkc[0]
* NET    56 = x_reg[7]
* NET    57 = x_reg[6]
* NET    58 = x_reg[5]
* NET    59 = x_reg[4]
* NET    60 = x_reg[3]
* NET    61 = x_reg[2]
* NET    62 = x_reg[1]
* NET    63 = x_reg[0]
* NET    64 = x[9]
* NET    65 = x[8]
* NET    66 = x[7]
* NET    67 = x[6]
* NET    68 = x[5]
* NET    69 = x[4]
* NET    70 = x[3]
* NET    71 = x[2]
* NET    72 = x[15]
* NET    73 = x[14]
* NET    74 = x[13]
* NET    75 = x[12]
* NET    76 = x[11]
* NET    77 = x[10]
* NET    78 = x[1]
* NET    79 = x[0]
* NET    80 = wr_top
* NET    81 = wok_top
* NET    82 = vss
* NET    83 = vdd
* NET    84 = stateoito
* NET    85 = state[1]
* NET    86 = state[0]
* NET    87 = rok_top
* NET    88 = reset
* NET    89 = rd_top
* NET    90 = quadrant[1]
* NET    91 = quadrant[0]
* NET    92 = put
* NET    93 = place
* NET    94 = ny_reg[7]
* NET    95 = ny_reg[6]
* NET    96 = ny_reg[5]
* NET    97 = ny_reg[4]
* NET    98 = ny_reg[3]
* NET    99 = ny_reg[2]
* NET   100 = ny_reg[1]
* NET   101 = ny_reg[0]
* NET   102 = nx_reg[7]
* NET   103 = nx_reg[6]
* NET   104 = nx_reg[5]
* NET   105 = nx_reg[4]
* NET   106 = nx_reg[3]
* NET   107 = nx_reg[2]
* NET   108 = nx_reg[1]
* NET   109 = nx_reg[0]
* NET   110 = norm
* NET   111 = n_ykc[9]
* NET   112 = n_ykc[8]
* NET   113 = n_ykc[7]
* NET   114 = n_ykc[6]
* NET   115 = n_ykc[5]
* NET   116 = n_ykc[4]
* NET   117 = n_ykc[3]
* NET   118 = n_ykc[2]
* NET   119 = n_ykc[15]
* NET   120 = n_ykc[14]
* NET   121 = n_ykc[13]
* NET   122 = n_ykc[12]
* NET   123 = n_ykc[11]
* NET   124 = n_ykc[10]
* NET   125 = n_ykc[1]
* NET   126 = n_ykc[0]
* NET   127 = n_y[9]
* NET   128 = n_y[8]
* NET   129 = n_y[7]
* NET   130 = n_y[6]
* NET   131 = n_y[5]
* NET   132 = n_y[4]
* NET   133 = n_y[3]
* NET   134 = n_y[2]
* NET   135 = n_y[15]
* NET   136 = n_y[14]
* NET   137 = n_y[13]
* NET   138 = n_y[12]
* NET   139 = n_y[11]
* NET   140 = n_y[10]
* NET   141 = n_y[1]
* NET   142 = n_y[0]
* NET   143 = n_xkc[9]
* NET   144 = n_xkc[8]
* NET   145 = n_xkc[7]
* NET   146 = n_xkc[6]
* NET   147 = n_xkc[5]
* NET   148 = n_xkc[4]
* NET   149 = n_xkc[3]
* NET   150 = n_xkc[2]
* NET   151 = n_xkc[15]
* NET   152 = n_xkc[14]
* NET   153 = n_xkc[13]
* NET   154 = n_xkc[12]
* NET   155 = n_xkc[11]
* NET   156 = n_xkc[10]
* NET   157 = n_xkc[1]
* NET   158 = n_xkc[0]
* NET   159 = n_x[9]
* NET   160 = n_x[8]
* NET   161 = n_x[7]
* NET   162 = n_x[6]
* NET   163 = n_x[5]
* NET   164 = n_x[4]
* NET   165 = n_x[3]
* NET   166 = n_x[2]
* NET   167 = n_x[15]
* NET   168 = n_x[14]
* NET   169 = n_x[13]
* NET   170 = n_x[12]
* NET   171 = n_x[11]
* NET   172 = n_x[10]
* NET   173 = n_x[1]
* NET   174 = n_x[0]
* NET   175 = n_quadrant[1]
* NET   176 = n_quadrant[0]
* NET   177 = n_i[2]
* NET   178 = n_i[1]
* NET   179 = n_i[0]
* NET   180 = n_a[9]
* NET   181 = n_a[8]
* NET   182 = n_a[7]
* NET   183 = n_a[6]
* NET   184 = n_a[5]
* NET   185 = n_a[4]
* NET   186 = n_a[3]
* NET   187 = n_a[2]
* NET   188 = n_a[15]
* NET   189 = n_a[14]
* NET   190 = n_a[13]
* NET   191 = n_a[12]
* NET   192 = n_a[11]
* NET   193 = n_a[10]
* NET   194 = n_a[1]
* NET   195 = n_a[0]
* NET   196 = n0_y_reg_7_0_7
* NET   197 = n0_y_reg_7_0_6
* NET   198 = n0_y_reg_7_0_5
* NET   199 = n0_y_reg_7_0_4
* NET   200 = n0_y_reg_7_0_3
* NET   201 = n0_y_reg_7_0_2
* NET   202 = n0_y_reg_7_0_1
* NET   203 = n0_y_reg_7_0_0
* NET   204 = n0_x_reg_7_0_7
* NET   205 = n0_x_reg_7_0_6
* NET   206 = n0_x_reg_7_0_5
* NET   207 = n0_x_reg_7_0_4
* NET   208 = n0_x_reg_7_0_3
* NET   209 = n0_x_reg_7_0_2
* NET   210 = n0_x_reg_7_0_1
* NET   211 = n0_x_reg_7_0_0
* NET   212 = n0_stateoito_0_0
* NET   213 = n0_state_1_0_1
* NET   214 = n0_state_1_0_0
* NET   215 = n0_put_0_0
* NET   216 = n0_place_0_0
* NET   217 = n0_ny_reg_7_0_7
* NET   218 = n0_ny_reg_7_0_6
* NET   219 = n0_ny_reg_7_0_5
* NET   220 = n0_ny_reg_7_0_4
* NET   221 = n0_ny_reg_7_0_3
* NET   222 = n0_ny_reg_7_0_2
* NET   223 = n0_ny_reg_7_0_1
* NET   224 = n0_ny_reg_7_0_0
* NET   225 = n0_nx_reg_7_0_7
* NET   226 = n0_nx_reg_7_0_6
* NET   227 = n0_nx_reg_7_0_5
* NET   228 = n0_nx_reg_7_0_4
* NET   229 = n0_nx_reg_7_0_3
* NET   230 = n0_nx_reg_7_0_2
* NET   231 = n0_nx_reg_7_0_1
* NET   232 = n0_nx_reg_7_0_0
* NET   233 = n0_norm_0_0
* NET   234 = n0_mkc_0_0
* NET   235 = n0_get_0_0
* NET   236 = n0_counter_1_0_1
* NET   237 = n0_counter_1_0_0
* NET   238 = n0_calc_0_0
* NET   239 = n0_a_reg_7_0_7
* NET   240 = n0_a_reg_7_0_6
* NET   241 = n0_a_reg_7_0_5
* NET   242 = n0_a_reg_7_0_4
* NET   243 = n0_a_reg_7_0_3
* NET   244 = n0_a_reg_7_0_2
* NET   245 = n0_a_reg_7_0_1
* NET   246 = n0_a_reg_7_0_0
* NET   247 = mkc
* NET   248 = i[2]
* NET   249 = i[1]
* NET   250 = i[0]
* NET   251 = get
* NET   252 = data_out[7]
* NET   253 = data_out[6]
* NET   254 = data_out[5]
* NET   255 = data_out[4]
* NET   256 = data_out[3]
* NET   257 = data_out[2]
* NET   258 = data_out[1]
* NET   259 = data_out[0]
* NET   260 = data_in[7]
* NET   261 = data_in[6]
* NET   262 = data_in[5]
* NET   263 = data_in[4]
* NET   264 = data_in[3]
* NET   265 = data_in[2]
* NET   266 = data_in[1]
* NET   267 = data_in[0]
* NET   268 = counter[1]
* NET   269 = counter[0]
* NET   270 = clk
* NET   271 = calc
* NET   272 = abc_6876_new_n998
* NET   273 = abc_6876_new_n997
* NET   274 = abc_6876_new_n996
* NET   275 = abc_6876_new_n995
* NET   276 = abc_6876_new_n994
* NET   277 = abc_6876_new_n993
* NET   278 = abc_6876_new_n992
* NET   279 = abc_6876_new_n991
* NET   280 = abc_6876_new_n990
* NET   281 = abc_6876_new_n989
* NET   282 = abc_6876_new_n988
* NET   283 = abc_6876_new_n987
* NET   284 = abc_6876_new_n986
* NET   285 = abc_6876_new_n985
* NET   286 = abc_6876_new_n984
* NET   287 = abc_6876_new_n983
* NET   288 = abc_6876_new_n982
* NET   289 = abc_6876_new_n981
* NET   290 = abc_6876_new_n980
* NET   291 = abc_6876_new_n979
* NET   292 = abc_6876_new_n978
* NET   293 = abc_6876_new_n977
* NET   294 = abc_6876_new_n976
* NET   295 = abc_6876_new_n974
* NET   296 = abc_6876_new_n973
* NET   297 = abc_6876_new_n972
* NET   298 = abc_6876_new_n971
* NET   299 = abc_6876_new_n970
* NET   300 = abc_6876_new_n969
* NET   301 = abc_6876_new_n968
* NET   302 = abc_6876_new_n967
* NET   303 = abc_6876_new_n966
* NET   304 = abc_6876_new_n965
* NET   305 = abc_6876_new_n964
* NET   306 = abc_6876_new_n963
* NET   307 = abc_6876_new_n962
* NET   308 = abc_6876_new_n961
* NET   309 = abc_6876_new_n960
* NET   310 = abc_6876_new_n959
* NET   311 = abc_6876_new_n958
* NET   312 = abc_6876_new_n957
* NET   313 = abc_6876_new_n956
* NET   314 = abc_6876_new_n954
* NET   315 = abc_6876_new_n953
* NET   316 = abc_6876_new_n952
* NET   317 = abc_6876_new_n951
* NET   318 = abc_6876_new_n950
* NET   319 = abc_6876_new_n949
* NET   320 = abc_6876_new_n948
* NET   321 = abc_6876_new_n947
* NET   322 = abc_6876_new_n946
* NET   323 = abc_6876_new_n945
* NET   324 = abc_6876_new_n944
* NET   325 = abc_6876_new_n943
* NET   326 = abc_6876_new_n942
* NET   327 = abc_6876_new_n941
* NET   328 = abc_6876_new_n940
* NET   329 = abc_6876_new_n939
* NET   330 = abc_6876_new_n938
* NET   331 = abc_6876_new_n937
* NET   332 = abc_6876_new_n936
* NET   333 = abc_6876_new_n935
* NET   334 = abc_6876_new_n934
* NET   335 = abc_6876_new_n933
* NET   336 = abc_6876_new_n932
* NET   337 = abc_6876_new_n930
* NET   338 = abc_6876_new_n929
* NET   339 = abc_6876_new_n928
* NET   340 = abc_6876_new_n927
* NET   341 = abc_6876_new_n926
* NET   342 = abc_6876_new_n925
* NET   343 = abc_6876_new_n924
* NET   344 = abc_6876_new_n923
* NET   345 = abc_6876_new_n922
* NET   346 = abc_6876_new_n921
* NET   347 = abc_6876_new_n920
* NET   348 = abc_6876_new_n919
* NET   349 = abc_6876_new_n918
* NET   350 = abc_6876_new_n917
* NET   351 = abc_6876_new_n916
* NET   352 = abc_6876_new_n915
* NET   353 = abc_6876_new_n914
* NET   354 = abc_6876_new_n913
* NET   355 = abc_6876_new_n912
* NET   356 = abc_6876_new_n910
* NET   357 = abc_6876_new_n909
* NET   358 = abc_6876_new_n908
* NET   359 = abc_6876_new_n907
* NET   360 = abc_6876_new_n906
* NET   361 = abc_6876_new_n905
* NET   362 = abc_6876_new_n904
* NET   363 = abc_6876_new_n903
* NET   364 = abc_6876_new_n902
* NET   365 = abc_6876_new_n901
* NET   366 = abc_6876_new_n900
* NET   367 = abc_6876_new_n899
* NET   368 = abc_6876_new_n898
* NET   369 = abc_6876_new_n897
* NET   370 = abc_6876_new_n896
* NET   371 = abc_6876_new_n895
* NET   372 = abc_6876_new_n894
* NET   373 = abc_6876_new_n893
* NET   374 = abc_6876_new_n892
* NET   375 = abc_6876_new_n891
* NET   376 = abc_6876_new_n890
* NET   377 = abc_6876_new_n888
* NET   378 = abc_6876_new_n887
* NET   379 = abc_6876_new_n886
* NET   380 = abc_6876_new_n885
* NET   381 = abc_6876_new_n884
* NET   382 = abc_6876_new_n883
* NET   383 = abc_6876_new_n882
* NET   384 = abc_6876_new_n881
* NET   385 = abc_6876_new_n880
* NET   386 = abc_6876_new_n879
* NET   387 = abc_6876_new_n878
* NET   388 = abc_6876_new_n877
* NET   389 = abc_6876_new_n876
* NET   390 = abc_6876_new_n875
* NET   391 = abc_6876_new_n874
* NET   392 = abc_6876_new_n873
* NET   393 = abc_6876_new_n872
* NET   394 = abc_6876_new_n871
* NET   395 = abc_6876_new_n870
* NET   396 = abc_6876_new_n869
* NET   397 = abc_6876_new_n867
* NET   398 = abc_6876_new_n866
* NET   399 = abc_6876_new_n865
* NET   400 = abc_6876_new_n864
* NET   401 = abc_6876_new_n863
* NET   402 = abc_6876_new_n862
* NET   403 = abc_6876_new_n861
* NET   404 = abc_6876_new_n860
* NET   405 = abc_6876_new_n859
* NET   406 = abc_6876_new_n858
* NET   407 = abc_6876_new_n857
* NET   408 = abc_6876_new_n856
* NET   409 = abc_6876_new_n855
* NET   410 = abc_6876_new_n854
* NET   411 = abc_6876_new_n853
* NET   412 = abc_6876_new_n852
* NET   413 = abc_6876_new_n851
* NET   414 = abc_6876_new_n850
* NET   415 = abc_6876_new_n848
* NET   416 = abc_6876_new_n847
* NET   417 = abc_6876_new_n846
* NET   418 = abc_6876_new_n845
* NET   419 = abc_6876_new_n844
* NET   420 = abc_6876_new_n843
* NET   421 = abc_6876_new_n842
* NET   422 = abc_6876_new_n841
* NET   423 = abc_6876_new_n840
* NET   424 = abc_6876_new_n839
* NET   425 = abc_6876_new_n838
* NET   426 = abc_6876_new_n837
* NET   427 = abc_6876_new_n836
* NET   428 = abc_6876_new_n835
* NET   429 = abc_6876_new_n834
* NET   430 = abc_6876_new_n832
* NET   431 = abc_6876_new_n831
* NET   432 = abc_6876_new_n830
* NET   433 = abc_6876_new_n829
* NET   434 = abc_6876_new_n828
* NET   435 = abc_6876_new_n827
* NET   436 = abc_6876_new_n826
* NET   437 = abc_6876_new_n825
* NET   438 = abc_6876_new_n824
* NET   439 = abc_6876_new_n823
* NET   440 = abc_6876_new_n822
* NET   441 = abc_6876_new_n821
* NET   442 = abc_6876_new_n820
* NET   443 = abc_6876_new_n819
* NET   444 = abc_6876_new_n818
* NET   445 = abc_6876_new_n817
* NET   446 = abc_6876_new_n816
* NET   447 = abc_6876_new_n815
* NET   448 = abc_6876_new_n813
* NET   449 = abc_6876_new_n812
* NET   450 = abc_6876_new_n810
* NET   451 = abc_6876_new_n809
* NET   452 = abc_6876_new_n807
* NET   453 = abc_6876_new_n806
* NET   454 = abc_6876_new_n805
* NET   455 = abc_6876_new_n803
* NET   456 = abc_6876_new_n802
* NET   457 = abc_6876_new_n801
* NET   458 = abc_6876_new_n800
* NET   459 = abc_6876_new_n799
* NET   460 = abc_6876_new_n797
* NET   461 = abc_6876_new_n796
* NET   462 = abc_6876_new_n795
* NET   463 = abc_6876_new_n794
* NET   464 = abc_6876_new_n793
* NET   465 = abc_6876_new_n792
* NET   466 = abc_6876_new_n791
* NET   467 = abc_6876_new_n790
* NET   468 = abc_6876_new_n789
* NET   469 = abc_6876_new_n788
* NET   470 = abc_6876_new_n787
* NET   471 = abc_6876_new_n786
* NET   472 = abc_6876_new_n785
* NET   473 = abc_6876_new_n784
* NET   474 = abc_6876_new_n783
* NET   475 = abc_6876_new_n781
* NET   476 = abc_6876_new_n780
* NET   477 = abc_6876_new_n779
* NET   478 = abc_6876_new_n778
* NET   479 = abc_6876_new_n777
* NET   480 = abc_6876_new_n776
* NET   481 = abc_6876_new_n774
* NET   482 = abc_6876_new_n773
* NET   483 = abc_6876_new_n772
* NET   484 = abc_6876_new_n771
* NET   485 = abc_6876_new_n770
* NET   486 = abc_6876_new_n769
* NET   487 = abc_6876_new_n768
* NET   488 = abc_6876_new_n767
* NET   489 = abc_6876_new_n765
* NET   490 = abc_6876_new_n764
* NET   491 = abc_6876_new_n763
* NET   492 = abc_6876_new_n762
* NET   493 = abc_6876_new_n761
* NET   494 = abc_6876_new_n759
* NET   495 = abc_6876_new_n758
* NET   496 = abc_6876_new_n757
* NET   497 = abc_6876_new_n756
* NET   498 = abc_6876_new_n755
* NET   499 = abc_6876_new_n754
* NET   500 = abc_6876_new_n753
* NET   501 = abc_6876_new_n752
* NET   502 = abc_6876_new_n751
* NET   503 = abc_6876_new_n750
* NET   504 = abc_6876_new_n749
* NET   505 = abc_6876_new_n748
* NET   506 = abc_6876_new_n747
* NET   507 = abc_6876_new_n745
* NET   508 = abc_6876_new_n744
* NET   509 = abc_6876_new_n743
* NET   510 = abc_6876_new_n742
* NET   511 = abc_6876_new_n741
* NET   512 = abc_6876_new_n740
* NET   513 = abc_6876_new_n739
* NET   514 = abc_6876_new_n738
* NET   515 = abc_6876_new_n736
* NET   516 = abc_6876_new_n735
* NET   517 = abc_6876_new_n734
* NET   518 = abc_6876_new_n733
* NET   519 = abc_6876_new_n732
* NET   520 = abc_6876_new_n731
* NET   521 = abc_6876_new_n730
* NET   522 = abc_6876_new_n729
* NET   523 = abc_6876_new_n727
* NET   524 = abc_6876_new_n726
* NET   525 = abc_6876_new_n725
* NET   526 = abc_6876_new_n724
* NET   527 = abc_6876_new_n723
* NET   528 = abc_6876_new_n722
* NET   529 = abc_6876_new_n721
* NET   530 = abc_6876_new_n720
* NET   531 = abc_6876_new_n718
* NET   532 = abc_6876_new_n717
* NET   533 = abc_6876_new_n716
* NET   534 = abc_6876_new_n715
* NET   535 = abc_6876_new_n714
* NET   536 = abc_6876_new_n713
* NET   537 = abc_6876_new_n712
* NET   538 = abc_6876_new_n711
* NET   539 = abc_6876_new_n710
* NET   540 = abc_6876_new_n709
* NET   541 = abc_6876_new_n708
* NET   542 = abc_6876_new_n707
* NET   543 = abc_6876_new_n706
* NET   544 = abc_6876_new_n705
* NET   545 = abc_6876_new_n704
* NET   546 = abc_6876_new_n703
* NET   547 = abc_6876_new_n702
* NET   548 = abc_6876_new_n701
* NET   549 = abc_6876_new_n700
* NET   550 = abc_6876_new_n699
* NET   551 = abc_6876_new_n698
* NET   552 = abc_6876_new_n697
* NET   553 = abc_6876_new_n696
* NET   554 = abc_6876_new_n695
* NET   555 = abc_6876_new_n694
* NET   556 = abc_6876_new_n693
* NET   557 = abc_6876_new_n692
* NET   558 = abc_6876_new_n691
* NET   559 = abc_6876_new_n690
* NET   560 = abc_6876_new_n688
* NET   561 = abc_6876_new_n687
* NET   562 = abc_6876_new_n686
* NET   563 = abc_6876_new_n685
* NET   564 = abc_6876_new_n684
* NET   565 = abc_6876_new_n683
* NET   566 = abc_6876_new_n682
* NET   567 = abc_6876_new_n681
* NET   568 = abc_6876_new_n680
* NET   569 = abc_6876_new_n679
* NET   570 = abc_6876_new_n678
* NET   571 = abc_6876_new_n677
* NET   572 = abc_6876_new_n676
* NET   573 = abc_6876_new_n675
* NET   574 = abc_6876_new_n674
* NET   575 = abc_6876_new_n673
* NET   576 = abc_6876_new_n672
* NET   577 = abc_6876_new_n671
* NET   578 = abc_6876_new_n670
* NET   579 = abc_6876_new_n669
* NET   580 = abc_6876_new_n667
* NET   581 = abc_6876_new_n666
* NET   582 = abc_6876_new_n665
* NET   583 = abc_6876_new_n664
* NET   584 = abc_6876_new_n663
* NET   585 = abc_6876_new_n662
* NET   586 = abc_6876_new_n661
* NET   587 = abc_6876_new_n660
* NET   588 = abc_6876_new_n659
* NET   589 = abc_6876_new_n658
* NET   590 = abc_6876_new_n657
* NET   591 = abc_6876_new_n656
* NET   592 = abc_6876_new_n655
* NET   593 = abc_6876_new_n654
* NET   594 = abc_6876_new_n653
* NET   595 = abc_6876_new_n652
* NET   596 = abc_6876_new_n651
* NET   597 = abc_6876_new_n650
* NET   598 = abc_6876_new_n649
* NET   599 = abc_6876_new_n648
* NET   600 = abc_6876_new_n647
* NET   601 = abc_6876_new_n646
* NET   602 = abc_6876_new_n645
* NET   603 = abc_6876_new_n643
* NET   604 = abc_6876_new_n642
* NET   605 = abc_6876_new_n641
* NET   606 = abc_6876_new_n640
* NET   607 = abc_6876_new_n639
* NET   608 = abc_6876_new_n638
* NET   609 = abc_6876_new_n637
* NET   610 = abc_6876_new_n636
* NET   611 = abc_6876_new_n635
* NET   612 = abc_6876_new_n634
* NET   613 = abc_6876_new_n633
* NET   614 = abc_6876_new_n632
* NET   615 = abc_6876_new_n631
* NET   616 = abc_6876_new_n630
* NET   617 = abc_6876_new_n629
* NET   618 = abc_6876_new_n628
* NET   619 = abc_6876_new_n627
* NET   620 = abc_6876_new_n626
* NET   621 = abc_6876_new_n625
* NET   622 = abc_6876_new_n624
* NET   623 = abc_6876_new_n623
* NET   624 = abc_6876_new_n622
* NET   625 = abc_6876_new_n621
* NET   626 = abc_6876_new_n620
* NET   627 = abc_6876_new_n618
* NET   628 = abc_6876_new_n617
* NET   629 = abc_6876_new_n616
* NET   630 = abc_6876_new_n615
* NET   631 = abc_6876_new_n614
* NET   632 = abc_6876_new_n613
* NET   633 = abc_6876_new_n612
* NET   634 = abc_6876_new_n611
* NET   635 = abc_6876_new_n610
* NET   636 = abc_6876_new_n609
* NET   637 = abc_6876_new_n608
* NET   638 = abc_6876_new_n607
* NET   639 = abc_6876_new_n606
* NET   640 = abc_6876_new_n605
* NET   641 = abc_6876_new_n604
* NET   642 = abc_6876_new_n603
* NET   643 = abc_6876_new_n602
* NET   644 = abc_6876_new_n601
* NET   645 = abc_6876_new_n600
* NET   646 = abc_6876_new_n599
* NET   647 = abc_6876_new_n598
* NET   648 = abc_6876_new_n597
* NET   649 = abc_6876_new_n596
* NET   650 = abc_6876_new_n594
* NET   651 = abc_6876_new_n593
* NET   652 = abc_6876_new_n592
* NET   653 = abc_6876_new_n591
* NET   654 = abc_6876_new_n590
* NET   655 = abc_6876_new_n589
* NET   656 = abc_6876_new_n588
* NET   657 = abc_6876_new_n587
* NET   658 = abc_6876_new_n586
* NET   659 = abc_6876_new_n585
* NET   660 = abc_6876_new_n584
* NET   661 = abc_6876_new_n583
* NET   662 = abc_6876_new_n582
* NET   663 = abc_6876_new_n581
* NET   664 = abc_6876_new_n580
* NET   665 = abc_6876_new_n579
* NET   666 = abc_6876_new_n578
* NET   667 = abc_6876_new_n577
* NET   668 = abc_6876_new_n576
* NET   669 = abc_6876_new_n575
* NET   670 = abc_6876_new_n574
* NET   671 = abc_6876_new_n573
* NET   672 = abc_6876_new_n572
* NET   673 = abc_6876_new_n571
* NET   674 = abc_6876_new_n570
* NET   675 = abc_6876_new_n569
* NET   676 = abc_6876_new_n567
* NET   677 = abc_6876_new_n566
* NET   678 = abc_6876_new_n565
* NET   679 = abc_6876_new_n564
* NET   680 = abc_6876_new_n563
* NET   681 = abc_6876_new_n562
* NET   682 = abc_6876_new_n561
* NET   683 = abc_6876_new_n560
* NET   684 = abc_6876_new_n559
* NET   685 = abc_6876_new_n558
* NET   686 = abc_6876_new_n557
* NET   687 = abc_6876_new_n555
* NET   688 = abc_6876_new_n553
* NET   689 = abc_6876_new_n552
* NET   690 = abc_6876_new_n551
* NET   691 = abc_6876_new_n550
* NET   692 = abc_6876_new_n549
* NET   693 = abc_6876_new_n548
* NET   694 = abc_6876_new_n547
* NET   695 = abc_6876_new_n546
* NET   696 = abc_6876_new_n545
* NET   697 = abc_6876_new_n544
* NET   698 = abc_6876_new_n543
* NET   699 = abc_6876_new_n542
* NET   700 = abc_6876_new_n541
* NET   701 = abc_6876_new_n540
* NET   702 = abc_6876_new_n539
* NET   703 = abc_6876_new_n538
* NET   704 = abc_6876_new_n537
* NET   705 = abc_6876_new_n536
* NET   706 = abc_6876_new_n535
* NET   707 = abc_6876_new_n534
* NET   708 = abc_6876_new_n533
* NET   709 = abc_6876_new_n532
* NET   710 = abc_6876_new_n531
* NET   711 = abc_6876_new_n530
* NET   712 = abc_6876_new_n529
* NET   713 = abc_6876_new_n528
* NET   714 = abc_6876_new_n527
* NET   715 = abc_6876_new_n526
* NET   716 = abc_6876_new_n525
* NET   717 = abc_6876_new_n523
* NET   718 = abc_6876_new_n522
* NET   719 = abc_6876_new_n520
* NET   720 = abc_6876_new_n519
* NET   721 = abc_6876_new_n517
* NET   722 = abc_6876_new_n516
* NET   723 = abc_6876_new_n514
* NET   724 = abc_6876_new_n513
* NET   725 = abc_6876_new_n511
* NET   726 = abc_6876_new_n510
* NET   727 = abc_6876_new_n508
* NET   728 = abc_6876_new_n507
* NET   729 = abc_6876_new_n505
* NET   730 = abc_6876_new_n504
* NET   731 = abc_6876_new_n502
* NET   732 = abc_6876_new_n501
* NET   733 = abc_6876_new_n500
* NET   734 = abc_6876_new_n499
* NET   735 = abc_6876_new_n497
* NET   736 = abc_6876_new_n496
* NET   737 = abc_6876_new_n494
* NET   738 = abc_6876_new_n493
* NET   739 = abc_6876_new_n491
* NET   740 = abc_6876_new_n490
* NET   741 = abc_6876_new_n488
* NET   742 = abc_6876_new_n487
* NET   743 = abc_6876_new_n485
* NET   744 = abc_6876_new_n484
* NET   745 = abc_6876_new_n482
* NET   746 = abc_6876_new_n481
* NET   747 = abc_6876_new_n479
* NET   748 = abc_6876_new_n478
* NET   749 = abc_6876_new_n476
* NET   750 = abc_6876_new_n475
* NET   751 = abc_6876_new_n474
* NET   752 = abc_6876_new_n473
* NET   753 = abc_6876_new_n472
* NET   754 = abc_6876_new_n471
* NET   755 = abc_6876_new_n469
* NET   756 = abc_6876_new_n468
* NET   757 = abc_6876_new_n466
* NET   758 = abc_6876_new_n465
* NET   759 = abc_6876_new_n463
* NET   760 = abc_6876_new_n462
* NET   761 = abc_6876_new_n460
* NET   762 = abc_6876_new_n459
* NET   763 = abc_6876_new_n457
* NET   764 = abc_6876_new_n456
* NET   765 = abc_6876_new_n454
* NET   766 = abc_6876_new_n453
* NET   767 = abc_6876_new_n451
* NET   768 = abc_6876_new_n450
* NET   769 = abc_6876_new_n448
* NET   770 = abc_6876_new_n447
* NET   771 = abc_6876_new_n446
* NET   772 = abc_6876_new_n445
* NET   773 = abc_6876_new_n444
* NET   774 = abc_6876_new_n442
* NET   775 = abc_6876_new_n441
* NET   776 = abc_6876_new_n439
* NET   777 = abc_6876_new_n438
* NET   778 = abc_6876_new_n436
* NET   779 = abc_6876_new_n435
* NET   780 = abc_6876_new_n433
* NET   781 = abc_6876_new_n432
* NET   782 = abc_6876_new_n430
* NET   783 = abc_6876_new_n429
* NET   784 = abc_6876_new_n427
* NET   785 = abc_6876_new_n426
* NET   786 = abc_6876_new_n424
* NET   787 = abc_6876_new_n423
* NET   788 = abc_6876_new_n421
* NET   789 = abc_6876_new_n420
* NET   790 = abc_6876_new_n419
* NET   791 = abc_6876_new_n418
* NET   792 = abc_6876_new_n417
* NET   793 = abc_6876_new_n416
* NET   794 = abc_6876_new_n415
* NET   795 = abc_6876_new_n414
* NET   796 = abc_6876_new_n413
* NET   797 = abc_6876_new_n412
* NET   798 = abc_6876_new_n411
* NET   799 = abc_6876_new_n410
* NET   800 = abc_6876_new_n409
* NET   801 = abc_6876_new_n408
* NET   802 = abc_6876_new_n407
* NET   803 = abc_6876_new_n406
* NET   804 = abc_6876_new_n405
* NET   805 = abc_6876_new_n404
* NET   806 = abc_6876_new_n403
* NET   807 = abc_6876_new_n402
* NET   808 = abc_6876_new_n401
* NET   809 = abc_6876_new_n400
* NET   810 = abc_6876_new_n399
* NET   811 = abc_6876_new_n398
* NET   812 = abc_6876_new_n397
* NET   813 = abc_6876_new_n396
* NET   814 = abc_6876_new_n395
* NET   815 = abc_6876_new_n394
* NET   816 = abc_6876_new_n393
* NET   817 = abc_6876_new_n392
* NET   818 = abc_6876_new_n391
* NET   819 = abc_6876_new_n390
* NET   820 = abc_6876_new_n389
* NET   821 = abc_6876_new_n388
* NET   822 = abc_6876_new_n387
* NET   823 = abc_6876_new_n386
* NET   824 = abc_6876_new_n385
* NET   825 = abc_6876_new_n384
* NET   826 = abc_6876_new_n383
* NET   827 = abc_6876_new_n382
* NET   828 = abc_6876_new_n381
* NET   829 = abc_6876_new_n380
* NET   830 = abc_6876_new_n379
* NET   831 = abc_6876_new_n378
* NET   832 = abc_6876_new_n377
* NET   833 = abc_6876_new_n376
* NET   834 = abc_6876_new_n375
* NET   835 = abc_6876_new_n374
* NET   836 = abc_6876_new_n373
* NET   837 = abc_6876_new_n372
* NET   838 = abc_6876_new_n371
* NET   839 = abc_6876_new_n370
* NET   840 = abc_6876_new_n369
* NET   841 = abc_6876_new_n368
* NET   842 = abc_6876_new_n367
* NET   843 = abc_6876_new_n366
* NET   844 = abc_6876_new_n365
* NET   845 = abc_6876_new_n364
* NET   846 = abc_6876_new_n363
* NET   847 = abc_6876_new_n362
* NET   848 = abc_6876_new_n361
* NET   849 = abc_6876_new_n360
* NET   850 = abc_6876_new_n359
* NET   851 = abc_6876_new_n358
* NET   852 = abc_6876_new_n357
* NET   853 = abc_6876_new_n356
* NET   854 = abc_6876_new_n355
* NET   855 = abc_6876_new_n354
* NET   856 = abc_6876_new_n353
* NET   857 = abc_6876_new_n352
* NET   858 = abc_6876_new_n351
* NET   859 = abc_6876_new_n350
* NET   860 = abc_6876_new_n349
* NET   861 = abc_6876_new_n348
* NET   862 = abc_6876_new_n347
* NET   863 = abc_6876_new_n346
* NET   864 = abc_6876_new_n345
* NET   865 = abc_6876_new_n344
* NET   866 = abc_6876_new_n343
* NET   867 = abc_6876_new_n342
* NET   868 = abc_6876_new_n341
* NET   869 = abc_6876_new_n340
* NET   870 = abc_6876_new_n339
* NET   871 = abc_6876_new_n338
* NET   872 = abc_6876_new_n337
* NET   873 = abc_6876_new_n336
* NET   874 = abc_6876_new_n335
* NET   875 = abc_6876_new_n334
* NET   876 = abc_6876_new_n333
* NET   877 = abc_6876_new_n332
* NET   878 = abc_6876_new_n331
* NET   879 = abc_6876_new_n330
* NET   880 = abc_6876_new_n329
* NET   881 = abc_6876_new_n328
* NET   882 = abc_6876_new_n327
* NET   883 = abc_6876_new_n326
* NET   884 = abc_6876_new_n325
* NET   885 = abc_6876_new_n324
* NET   886 = abc_6876_new_n323
* NET   887 = abc_6876_new_n322
* NET   888 = abc_6876_new_n321
* NET   889 = abc_6876_new_n320
* NET   890 = abc_6876_new_n319
* NET   891 = abc_6876_new_n318
* NET   892 = abc_6876_new_n317
* NET   893 = abc_6876_new_n316
* NET   894 = abc_6876_new_n315
* NET   895 = abc_6876_new_n314
* NET   896 = abc_6876_new_n313
* NET   897 = abc_6876_new_n312
* NET   898 = abc_6876_new_n311
* NET   899 = abc_6876_new_n310
* NET   900 = abc_6876_new_n309
* NET   901 = abc_6876_new_n308
* NET   902 = abc_6876_new_n307
* NET   903 = abc_6876_new_n306
* NET   904 = abc_6876_new_n305
* NET   905 = abc_6876_new_n304
* NET   906 = abc_6876_new_n303
* NET   907 = abc_6876_new_n302
* NET   908 = abc_6876_new_n301
* NET   909 = abc_6876_new_n300
* NET   910 = abc_6876_new_n299
* NET   911 = abc_6876_new_n298
* NET   912 = abc_6876_new_n297
* NET   913 = abc_6876_new_n296
* NET   914 = abc_6876_new_n295
* NET   915 = abc_6876_new_n2850
* NET   916 = abc_6876_new_n2848
* NET   917 = abc_6876_new_n2846
* NET   918 = abc_6876_new_n2844
* NET   919 = abc_6876_new_n2842
* NET   920 = abc_6876_new_n2841
* NET   921 = abc_6876_new_n2840
* NET   922 = abc_6876_new_n2839
* NET   923 = abc_6876_new_n2837
* NET   924 = abc_6876_new_n2835
* NET   925 = abc_6876_new_n2833
* NET   926 = abc_6876_new_n2831
* NET   927 = abc_6876_new_n2829
* NET   928 = abc_6876_new_n2827
* NET   929 = abc_6876_new_n2825
* NET   930 = abc_6876_new_n2823
* NET   931 = abc_6876_new_n2821
* NET   932 = abc_6876_new_n2819
* NET   933 = abc_6876_new_n2817
* NET   934 = abc_6876_new_n2815
* NET   935 = abc_6876_new_n2813
* NET   936 = abc_6876_new_n2811
* NET   937 = abc_6876_new_n2809
* NET   938 = abc_6876_new_n2807
* NET   939 = abc_6876_new_n2805
* NET   940 = abc_6876_new_n2804
* NET   941 = abc_6876_new_n2802
* NET   942 = abc_6876_new_n2801
* NET   943 = abc_6876_new_n2800
* NET   944 = abc_6876_new_n2798
* NET   945 = abc_6876_new_n2797
* NET   946 = abc_6876_new_n2795
* NET   947 = abc_6876_new_n2794
* NET   948 = abc_6876_new_n2791
* NET   949 = abc_6876_new_n2789
* NET   950 = abc_6876_new_n2788
* NET   951 = abc_6876_new_n2787
* NET   952 = abc_6876_new_n2786
* NET   953 = abc_6876_new_n2785
* NET   954 = abc_6876_new_n2784
* NET   955 = abc_6876_new_n2783
* NET   956 = abc_6876_new_n2782
* NET   957 = abc_6876_new_n2781
* NET   958 = abc_6876_new_n2780
* NET   959 = abc_6876_new_n2779
* NET   960 = abc_6876_new_n2778
* NET   961 = abc_6876_new_n2777
* NET   962 = abc_6876_new_n2776
* NET   963 = abc_6876_new_n2774
* NET   964 = abc_6876_new_n2773
* NET   965 = abc_6876_new_n2772
* NET   966 = abc_6876_new_n2771
* NET   967 = abc_6876_new_n2770
* NET   968 = abc_6876_new_n2769
* NET   969 = abc_6876_new_n2768
* NET   970 = abc_6876_new_n2767
* NET   971 = abc_6876_new_n2766
* NET   972 = abc_6876_new_n2765
* NET   973 = abc_6876_new_n2764
* NET   974 = abc_6876_new_n2763
* NET   975 = abc_6876_new_n2762
* NET   976 = abc_6876_new_n2761
* NET   977 = abc_6876_new_n2760
* NET   978 = abc_6876_new_n2759
* NET   979 = abc_6876_new_n2758
* NET   980 = abc_6876_new_n2757
* NET   981 = abc_6876_new_n2756
* NET   982 = abc_6876_new_n2755
* NET   983 = abc_6876_new_n2754
* NET   984 = abc_6876_new_n2753
* NET   985 = abc_6876_new_n2752
* NET   986 = abc_6876_new_n2751
* NET   987 = abc_6876_new_n2750
* NET   988 = abc_6876_new_n2748
* NET   989 = abc_6876_new_n2747
* NET   990 = abc_6876_new_n2746
* NET   991 = abc_6876_new_n2745
* NET   992 = abc_6876_new_n2744
* NET   993 = abc_6876_new_n2743
* NET   994 = abc_6876_new_n2742
* NET   995 = abc_6876_new_n2741
* NET   996 = abc_6876_new_n2740
* NET   997 = abc_6876_new_n2739
* NET   998 = abc_6876_new_n2738
* NET   999 = abc_6876_new_n2737
* NET  1000 = abc_6876_new_n2736
* NET  1001 = abc_6876_new_n2735
* NET  1002 = abc_6876_new_n2734
* NET  1003 = abc_6876_new_n2733
* NET  1004 = abc_6876_new_n2732
* NET  1005 = abc_6876_new_n2731
* NET  1006 = abc_6876_new_n2730
* NET  1007 = abc_6876_new_n2729
* NET  1008 = abc_6876_new_n2728
* NET  1009 = abc_6876_new_n2727
* NET  1010 = abc_6876_new_n2726
* NET  1011 = abc_6876_new_n2725
* NET  1012 = abc_6876_new_n2724
* NET  1013 = abc_6876_new_n2723
* NET  1014 = abc_6876_new_n2722
* NET  1015 = abc_6876_new_n2721
* NET  1016 = abc_6876_new_n2720
* NET  1017 = abc_6876_new_n2719
* NET  1018 = abc_6876_new_n2718
* NET  1019 = abc_6876_new_n2716
* NET  1020 = abc_6876_new_n2715
* NET  1021 = abc_6876_new_n2714
* NET  1022 = abc_6876_new_n2713
* NET  1023 = abc_6876_new_n2712
* NET  1024 = abc_6876_new_n2711
* NET  1025 = abc_6876_new_n2710
* NET  1026 = abc_6876_new_n2709
* NET  1027 = abc_6876_new_n2708
* NET  1028 = abc_6876_new_n2707
* NET  1029 = abc_6876_new_n2706
* NET  1030 = abc_6876_new_n2705
* NET  1031 = abc_6876_new_n2704
* NET  1032 = abc_6876_new_n2703
* NET  1033 = abc_6876_new_n2702
* NET  1034 = abc_6876_new_n2701
* NET  1035 = abc_6876_new_n2700
* NET  1036 = abc_6876_new_n2699
* NET  1037 = abc_6876_new_n2698
* NET  1038 = abc_6876_new_n2697
* NET  1039 = abc_6876_new_n2696
* NET  1040 = abc_6876_new_n2695
* NET  1041 = abc_6876_new_n2694
* NET  1042 = abc_6876_new_n2693
* NET  1043 = abc_6876_new_n2692
* NET  1044 = abc_6876_new_n2691
* NET  1045 = abc_6876_new_n2690
* NET  1046 = abc_6876_new_n2689
* NET  1047 = abc_6876_new_n2687
* NET  1048 = abc_6876_new_n2686
* NET  1049 = abc_6876_new_n2685
* NET  1050 = abc_6876_new_n2684
* NET  1051 = abc_6876_new_n2683
* NET  1052 = abc_6876_new_n2682
* NET  1053 = abc_6876_new_n2681
* NET  1054 = abc_6876_new_n2680
* NET  1055 = abc_6876_new_n2679
* NET  1056 = abc_6876_new_n2678
* NET  1057 = abc_6876_new_n2677
* NET  1058 = abc_6876_new_n2676
* NET  1059 = abc_6876_new_n2675
* NET  1060 = abc_6876_new_n2674
* NET  1061 = abc_6876_new_n2673
* NET  1062 = abc_6876_new_n2672
* NET  1063 = abc_6876_new_n2671
* NET  1064 = abc_6876_new_n2670
* NET  1065 = abc_6876_new_n2669
* NET  1066 = abc_6876_new_n2668
* NET  1067 = abc_6876_new_n2667
* NET  1068 = abc_6876_new_n2666
* NET  1069 = abc_6876_new_n2665
* NET  1070 = abc_6876_new_n2664
* NET  1071 = abc_6876_new_n2663
* NET  1072 = abc_6876_new_n2662
* NET  1073 = abc_6876_new_n2661
* NET  1074 = abc_6876_new_n2660
* NET  1075 = abc_6876_new_n2659
* NET  1076 = abc_6876_new_n2658
* NET  1077 = abc_6876_new_n2657
* NET  1078 = abc_6876_new_n2656
* NET  1079 = abc_6876_new_n2655
* NET  1080 = abc_6876_new_n2654
* NET  1081 = abc_6876_new_n2653
* NET  1082 = abc_6876_new_n2651
* NET  1083 = abc_6876_new_n2650
* NET  1084 = abc_6876_new_n2649
* NET  1085 = abc_6876_new_n2648
* NET  1086 = abc_6876_new_n2647
* NET  1087 = abc_6876_new_n2646
* NET  1088 = abc_6876_new_n2645
* NET  1089 = abc_6876_new_n2644
* NET  1090 = abc_6876_new_n2643
* NET  1091 = abc_6876_new_n2642
* NET  1092 = abc_6876_new_n2641
* NET  1093 = abc_6876_new_n2640
* NET  1094 = abc_6876_new_n2639
* NET  1095 = abc_6876_new_n2638
* NET  1096 = abc_6876_new_n2637
* NET  1097 = abc_6876_new_n2636
* NET  1098 = abc_6876_new_n2635
* NET  1099 = abc_6876_new_n2634
* NET  1100 = abc_6876_new_n2633
* NET  1101 = abc_6876_new_n2632
* NET  1102 = abc_6876_new_n2631
* NET  1103 = abc_6876_new_n2630
* NET  1104 = abc_6876_new_n2629
* NET  1105 = abc_6876_new_n2628
* NET  1106 = abc_6876_new_n2627
* NET  1107 = abc_6876_new_n2626
* NET  1108 = abc_6876_new_n2625
* NET  1109 = abc_6876_new_n2624
* NET  1110 = abc_6876_new_n2623
* NET  1111 = abc_6876_new_n2622
* NET  1112 = abc_6876_new_n2621
* NET  1113 = abc_6876_new_n2620
* NET  1114 = abc_6876_new_n2619
* NET  1115 = abc_6876_new_n2618
* NET  1116 = abc_6876_new_n2617
* NET  1117 = abc_6876_new_n2616
* NET  1118 = abc_6876_new_n2615
* NET  1119 = abc_6876_new_n2614
* NET  1120 = abc_6876_new_n2613
* NET  1121 = abc_6876_new_n2612
* NET  1122 = abc_6876_new_n2611
* NET  1123 = abc_6876_new_n2610
* NET  1124 = abc_6876_new_n2608
* NET  1125 = abc_6876_new_n2607
* NET  1126 = abc_6876_new_n2606
* NET  1127 = abc_6876_new_n2605
* NET  1128 = abc_6876_new_n2604
* NET  1129 = abc_6876_new_n2603
* NET  1130 = abc_6876_new_n2602
* NET  1131 = abc_6876_new_n2601
* NET  1132 = abc_6876_new_n2600
* NET  1133 = abc_6876_new_n2599
* NET  1134 = abc_6876_new_n2598
* NET  1135 = abc_6876_new_n2597
* NET  1136 = abc_6876_new_n2596
* NET  1137 = abc_6876_new_n2595
* NET  1138 = abc_6876_new_n2594
* NET  1139 = abc_6876_new_n2593
* NET  1140 = abc_6876_new_n2592
* NET  1141 = abc_6876_new_n2591
* NET  1142 = abc_6876_new_n2590
* NET  1143 = abc_6876_new_n2589
* NET  1144 = abc_6876_new_n2588
* NET  1145 = abc_6876_new_n2587
* NET  1146 = abc_6876_new_n2586
* NET  1147 = abc_6876_new_n2585
* NET  1148 = abc_6876_new_n2584
* NET  1149 = abc_6876_new_n2583
* NET  1150 = abc_6876_new_n2582
* NET  1151 = abc_6876_new_n2581
* NET  1152 = abc_6876_new_n2580
* NET  1153 = abc_6876_new_n2579
* NET  1154 = abc_6876_new_n2578
* NET  1155 = abc_6876_new_n2577
* NET  1156 = abc_6876_new_n2576
* NET  1157 = abc_6876_new_n2575
* NET  1158 = abc_6876_new_n2574
* NET  1159 = abc_6876_new_n2573
* NET  1160 = abc_6876_new_n2572
* NET  1161 = abc_6876_new_n2571
* NET  1162 = abc_6876_new_n2570
* NET  1163 = abc_6876_new_n2569
* NET  1164 = abc_6876_new_n2568
* NET  1165 = abc_6876_new_n2567
* NET  1166 = abc_6876_new_n2566
* NET  1167 = abc_6876_new_n2565
* NET  1168 = abc_6876_new_n2564
* NET  1169 = abc_6876_new_n2562
* NET  1170 = abc_6876_new_n2561
* NET  1171 = abc_6876_new_n2560
* NET  1172 = abc_6876_new_n2559
* NET  1173 = abc_6876_new_n2558
* NET  1174 = abc_6876_new_n2557
* NET  1175 = abc_6876_new_n2556
* NET  1176 = abc_6876_new_n2555
* NET  1177 = abc_6876_new_n2554
* NET  1178 = abc_6876_new_n2553
* NET  1179 = abc_6876_new_n2552
* NET  1180 = abc_6876_new_n2551
* NET  1181 = abc_6876_new_n2550
* NET  1182 = abc_6876_new_n2549
* NET  1183 = abc_6876_new_n2548
* NET  1184 = abc_6876_new_n2547
* NET  1185 = abc_6876_new_n2546
* NET  1186 = abc_6876_new_n2545
* NET  1187 = abc_6876_new_n2544
* NET  1188 = abc_6876_new_n2543
* NET  1189 = abc_6876_new_n2542
* NET  1190 = abc_6876_new_n2541
* NET  1191 = abc_6876_new_n2540
* NET  1192 = abc_6876_new_n2539
* NET  1193 = abc_6876_new_n2538
* NET  1194 = abc_6876_new_n2537
* NET  1195 = abc_6876_new_n2536
* NET  1196 = abc_6876_new_n2535
* NET  1197 = abc_6876_new_n2534
* NET  1198 = abc_6876_new_n2533
* NET  1199 = abc_6876_new_n2532
* NET  1200 = abc_6876_new_n2531
* NET  1201 = abc_6876_new_n2530
* NET  1202 = abc_6876_new_n2529
* NET  1203 = abc_6876_new_n2528
* NET  1204 = abc_6876_new_n2527
* NET  1205 = abc_6876_new_n2526
* NET  1206 = abc_6876_new_n2525
* NET  1207 = abc_6876_new_n2524
* NET  1208 = abc_6876_new_n2523
* NET  1209 = abc_6876_new_n2522
* NET  1210 = abc_6876_new_n2521
* NET  1211 = abc_6876_new_n2519
* NET  1212 = abc_6876_new_n2518
* NET  1213 = abc_6876_new_n2517
* NET  1214 = abc_6876_new_n2516
* NET  1215 = abc_6876_new_n2515
* NET  1216 = abc_6876_new_n2514
* NET  1217 = abc_6876_new_n2513
* NET  1218 = abc_6876_new_n2512
* NET  1219 = abc_6876_new_n2511
* NET  1220 = abc_6876_new_n2510
* NET  1221 = abc_6876_new_n2509
* NET  1222 = abc_6876_new_n2508
* NET  1223 = abc_6876_new_n2507
* NET  1224 = abc_6876_new_n2506
* NET  1225 = abc_6876_new_n2505
* NET  1226 = abc_6876_new_n2504
* NET  1227 = abc_6876_new_n2503
* NET  1228 = abc_6876_new_n2502
* NET  1229 = abc_6876_new_n2501
* NET  1230 = abc_6876_new_n2500
* NET  1231 = abc_6876_new_n2499
* NET  1232 = abc_6876_new_n2498
* NET  1233 = abc_6876_new_n2497
* NET  1234 = abc_6876_new_n2496
* NET  1235 = abc_6876_new_n2495
* NET  1236 = abc_6876_new_n2494
* NET  1237 = abc_6876_new_n2493
* NET  1238 = abc_6876_new_n2492
* NET  1239 = abc_6876_new_n2491
* NET  1240 = abc_6876_new_n2490
* NET  1241 = abc_6876_new_n2489
* NET  1242 = abc_6876_new_n2488
* NET  1243 = abc_6876_new_n2487
* NET  1244 = abc_6876_new_n2486
* NET  1245 = abc_6876_new_n2485
* NET  1246 = abc_6876_new_n2484
* NET  1247 = abc_6876_new_n2483
* NET  1248 = abc_6876_new_n2482
* NET  1249 = abc_6876_new_n2481
* NET  1250 = abc_6876_new_n2480
* NET  1251 = abc_6876_new_n2479
* NET  1252 = abc_6876_new_n2478
* NET  1253 = abc_6876_new_n2477
* NET  1254 = abc_6876_new_n2476
* NET  1255 = abc_6876_new_n2475
* NET  1256 = abc_6876_new_n2474
* NET  1257 = abc_6876_new_n2473
* NET  1258 = abc_6876_new_n2471
* NET  1259 = abc_6876_new_n2470
* NET  1260 = abc_6876_new_n2469
* NET  1261 = abc_6876_new_n2468
* NET  1262 = abc_6876_new_n2467
* NET  1263 = abc_6876_new_n2466
* NET  1264 = abc_6876_new_n2465
* NET  1265 = abc_6876_new_n2464
* NET  1266 = abc_6876_new_n2463
* NET  1267 = abc_6876_new_n2462
* NET  1268 = abc_6876_new_n2461
* NET  1269 = abc_6876_new_n2460
* NET  1270 = abc_6876_new_n2459
* NET  1271 = abc_6876_new_n2458
* NET  1272 = abc_6876_new_n2457
* NET  1273 = abc_6876_new_n2456
* NET  1274 = abc_6876_new_n2455
* NET  1275 = abc_6876_new_n2454
* NET  1276 = abc_6876_new_n2453
* NET  1277 = abc_6876_new_n2452
* NET  1278 = abc_6876_new_n2451
* NET  1279 = abc_6876_new_n2450
* NET  1280 = abc_6876_new_n2449
* NET  1281 = abc_6876_new_n2448
* NET  1282 = abc_6876_new_n2447
* NET  1283 = abc_6876_new_n2446
* NET  1284 = abc_6876_new_n2445
* NET  1285 = abc_6876_new_n2444
* NET  1286 = abc_6876_new_n2443
* NET  1287 = abc_6876_new_n2442
* NET  1288 = abc_6876_new_n2441
* NET  1289 = abc_6876_new_n2440
* NET  1290 = abc_6876_new_n2439
* NET  1291 = abc_6876_new_n2438
* NET  1292 = abc_6876_new_n2437
* NET  1293 = abc_6876_new_n2436
* NET  1294 = abc_6876_new_n2435
* NET  1295 = abc_6876_new_n2434
* NET  1296 = abc_6876_new_n2433
* NET  1297 = abc_6876_new_n2432
* NET  1298 = abc_6876_new_n2431
* NET  1299 = abc_6876_new_n2430
* NET  1300 = abc_6876_new_n2428
* NET  1301 = abc_6876_new_n2427
* NET  1302 = abc_6876_new_n2426
* NET  1303 = abc_6876_new_n2425
* NET  1304 = abc_6876_new_n2424
* NET  1305 = abc_6876_new_n2423
* NET  1306 = abc_6876_new_n2422
* NET  1307 = abc_6876_new_n2421
* NET  1308 = abc_6876_new_n2420
* NET  1309 = abc_6876_new_n2419
* NET  1310 = abc_6876_new_n2418
* NET  1311 = abc_6876_new_n2417
* NET  1312 = abc_6876_new_n2416
* NET  1313 = abc_6876_new_n2415
* NET  1314 = abc_6876_new_n2414
* NET  1315 = abc_6876_new_n2413
* NET  1316 = abc_6876_new_n2412
* NET  1317 = abc_6876_new_n2411
* NET  1318 = abc_6876_new_n2410
* NET  1319 = abc_6876_new_n2409
* NET  1320 = abc_6876_new_n2408
* NET  1321 = abc_6876_new_n2407
* NET  1322 = abc_6876_new_n2406
* NET  1323 = abc_6876_new_n2405
* NET  1324 = abc_6876_new_n2404
* NET  1325 = abc_6876_new_n2403
* NET  1326 = abc_6876_new_n2402
* NET  1327 = abc_6876_new_n2401
* NET  1328 = abc_6876_new_n2400
* NET  1329 = abc_6876_new_n2399
* NET  1330 = abc_6876_new_n2398
* NET  1331 = abc_6876_new_n2397
* NET  1332 = abc_6876_new_n2396
* NET  1333 = abc_6876_new_n2395
* NET  1334 = abc_6876_new_n2394
* NET  1335 = abc_6876_new_n2393
* NET  1336 = abc_6876_new_n2392
* NET  1337 = abc_6876_new_n2391
* NET  1338 = abc_6876_new_n2390
* NET  1339 = abc_6876_new_n2389
* NET  1340 = abc_6876_new_n2388
* NET  1341 = abc_6876_new_n2387
* NET  1342 = abc_6876_new_n2385
* NET  1343 = abc_6876_new_n2384
* NET  1344 = abc_6876_new_n2383
* NET  1345 = abc_6876_new_n2382
* NET  1346 = abc_6876_new_n2381
* NET  1347 = abc_6876_new_n2380
* NET  1348 = abc_6876_new_n2379
* NET  1349 = abc_6876_new_n2378
* NET  1350 = abc_6876_new_n2377
* NET  1351 = abc_6876_new_n2376
* NET  1352 = abc_6876_new_n2375
* NET  1353 = abc_6876_new_n2374
* NET  1354 = abc_6876_new_n2373
* NET  1355 = abc_6876_new_n2372
* NET  1356 = abc_6876_new_n2371
* NET  1357 = abc_6876_new_n2370
* NET  1358 = abc_6876_new_n2369
* NET  1359 = abc_6876_new_n2368
* NET  1360 = abc_6876_new_n2367
* NET  1361 = abc_6876_new_n2366
* NET  1362 = abc_6876_new_n2365
* NET  1363 = abc_6876_new_n2364
* NET  1364 = abc_6876_new_n2363
* NET  1365 = abc_6876_new_n2362
* NET  1366 = abc_6876_new_n2361
* NET  1367 = abc_6876_new_n2360
* NET  1368 = abc_6876_new_n2359
* NET  1369 = abc_6876_new_n2358
* NET  1370 = abc_6876_new_n2357
* NET  1371 = abc_6876_new_n2356
* NET  1372 = abc_6876_new_n2355
* NET  1373 = abc_6876_new_n2354
* NET  1374 = abc_6876_new_n2353
* NET  1375 = abc_6876_new_n2352
* NET  1376 = abc_6876_new_n2351
* NET  1377 = abc_6876_new_n2350
* NET  1378 = abc_6876_new_n2349
* NET  1379 = abc_6876_new_n2348
* NET  1380 = abc_6876_new_n2347
* NET  1381 = abc_6876_new_n2346
* NET  1382 = abc_6876_new_n2345
* NET  1383 = abc_6876_new_n2344
* NET  1384 = abc_6876_new_n2343
* NET  1385 = abc_6876_new_n2342
* NET  1386 = abc_6876_new_n2341
* NET  1387 = abc_6876_new_n2340
* NET  1388 = abc_6876_new_n2339
* NET  1389 = abc_6876_new_n2338
* NET  1390 = abc_6876_new_n2337
* NET  1391 = abc_6876_new_n2335
* NET  1392 = abc_6876_new_n2334
* NET  1393 = abc_6876_new_n2333
* NET  1394 = abc_6876_new_n2332
* NET  1395 = abc_6876_new_n2331
* NET  1396 = abc_6876_new_n2330
* NET  1397 = abc_6876_new_n2329
* NET  1398 = abc_6876_new_n2328
* NET  1399 = abc_6876_new_n2327
* NET  1400 = abc_6876_new_n2326
* NET  1401 = abc_6876_new_n2325
* NET  1402 = abc_6876_new_n2324
* NET  1403 = abc_6876_new_n2323
* NET  1404 = abc_6876_new_n2322
* NET  1405 = abc_6876_new_n2321
* NET  1406 = abc_6876_new_n2320
* NET  1407 = abc_6876_new_n2319
* NET  1408 = abc_6876_new_n2318
* NET  1409 = abc_6876_new_n2317
* NET  1410 = abc_6876_new_n2316
* NET  1411 = abc_6876_new_n2315
* NET  1412 = abc_6876_new_n2314
* NET  1413 = abc_6876_new_n2313
* NET  1414 = abc_6876_new_n2312
* NET  1415 = abc_6876_new_n2311
* NET  1416 = abc_6876_new_n2310
* NET  1417 = abc_6876_new_n2309
* NET  1418 = abc_6876_new_n2308
* NET  1419 = abc_6876_new_n2307
* NET  1420 = abc_6876_new_n2306
* NET  1421 = abc_6876_new_n2305
* NET  1422 = abc_6876_new_n2304
* NET  1423 = abc_6876_new_n2303
* NET  1424 = abc_6876_new_n2302
* NET  1425 = abc_6876_new_n2301
* NET  1426 = abc_6876_new_n2300
* NET  1427 = abc_6876_new_n2299
* NET  1428 = abc_6876_new_n2298
* NET  1429 = abc_6876_new_n2297
* NET  1430 = abc_6876_new_n2296
* NET  1431 = abc_6876_new_n2295
* NET  1432 = abc_6876_new_n2294
* NET  1433 = abc_6876_new_n2293
* NET  1434 = abc_6876_new_n2292
* NET  1435 = abc_6876_new_n2291
* NET  1436 = abc_6876_new_n2290
* NET  1437 = abc_6876_new_n2289
* NET  1438 = abc_6876_new_n2288
* NET  1439 = abc_6876_new_n2287
* NET  1440 = abc_6876_new_n2286
* NET  1441 = abc_6876_new_n2285
* NET  1442 = abc_6876_new_n2284
* NET  1443 = abc_6876_new_n2283
* NET  1444 = abc_6876_new_n2281
* NET  1445 = abc_6876_new_n2280
* NET  1446 = abc_6876_new_n2279
* NET  1447 = abc_6876_new_n2278
* NET  1448 = abc_6876_new_n2277
* NET  1449 = abc_6876_new_n2276
* NET  1450 = abc_6876_new_n2275
* NET  1451 = abc_6876_new_n2274
* NET  1452 = abc_6876_new_n2273
* NET  1453 = abc_6876_new_n2272
* NET  1454 = abc_6876_new_n2271
* NET  1455 = abc_6876_new_n2270
* NET  1456 = abc_6876_new_n2269
* NET  1457 = abc_6876_new_n2268
* NET  1458 = abc_6876_new_n2267
* NET  1459 = abc_6876_new_n2266
* NET  1460 = abc_6876_new_n2265
* NET  1461 = abc_6876_new_n2264
* NET  1462 = abc_6876_new_n2263
* NET  1463 = abc_6876_new_n2262
* NET  1464 = abc_6876_new_n2261
* NET  1465 = abc_6876_new_n2260
* NET  1466 = abc_6876_new_n2259
* NET  1467 = abc_6876_new_n2258
* NET  1468 = abc_6876_new_n2257
* NET  1469 = abc_6876_new_n2256
* NET  1470 = abc_6876_new_n2255
* NET  1471 = abc_6876_new_n2254
* NET  1472 = abc_6876_new_n2253
* NET  1473 = abc_6876_new_n2252
* NET  1474 = abc_6876_new_n2251
* NET  1475 = abc_6876_new_n2250
* NET  1476 = abc_6876_new_n2249
* NET  1477 = abc_6876_new_n2248
* NET  1478 = abc_6876_new_n2247
* NET  1479 = abc_6876_new_n2246
* NET  1480 = abc_6876_new_n2245
* NET  1481 = abc_6876_new_n2244
* NET  1482 = abc_6876_new_n2243
* NET  1483 = abc_6876_new_n2242
* NET  1484 = abc_6876_new_n2241
* NET  1485 = abc_6876_new_n2240
* NET  1486 = abc_6876_new_n2239
* NET  1487 = abc_6876_new_n2238
* NET  1488 = abc_6876_new_n2237
* NET  1489 = abc_6876_new_n2236
* NET  1490 = abc_6876_new_n2235
* NET  1491 = abc_6876_new_n2234
* NET  1492 = abc_6876_new_n2232
* NET  1493 = abc_6876_new_n2231
* NET  1494 = abc_6876_new_n2230
* NET  1495 = abc_6876_new_n2229
* NET  1496 = abc_6876_new_n2228
* NET  1497 = abc_6876_new_n2227
* NET  1498 = abc_6876_new_n2226
* NET  1499 = abc_6876_new_n2225
* NET  1500 = abc_6876_new_n2224
* NET  1501 = abc_6876_new_n2223
* NET  1502 = abc_6876_new_n2222
* NET  1503 = abc_6876_new_n2221
* NET  1504 = abc_6876_new_n2220
* NET  1505 = abc_6876_new_n2219
* NET  1506 = abc_6876_new_n2218
* NET  1507 = abc_6876_new_n2217
* NET  1508 = abc_6876_new_n2216
* NET  1509 = abc_6876_new_n2215
* NET  1510 = abc_6876_new_n2214
* NET  1511 = abc_6876_new_n2213
* NET  1512 = abc_6876_new_n2212
* NET  1513 = abc_6876_new_n2211
* NET  1514 = abc_6876_new_n2210
* NET  1515 = abc_6876_new_n2209
* NET  1516 = abc_6876_new_n2208
* NET  1517 = abc_6876_new_n2207
* NET  1518 = abc_6876_new_n2206
* NET  1519 = abc_6876_new_n2205
* NET  1520 = abc_6876_new_n2204
* NET  1521 = abc_6876_new_n2203
* NET  1522 = abc_6876_new_n2202
* NET  1523 = abc_6876_new_n2201
* NET  1524 = abc_6876_new_n2200
* NET  1525 = abc_6876_new_n2199
* NET  1526 = abc_6876_new_n2198
* NET  1527 = abc_6876_new_n2197
* NET  1528 = abc_6876_new_n2196
* NET  1529 = abc_6876_new_n2195
* NET  1530 = abc_6876_new_n2194
* NET  1531 = abc_6876_new_n2193
* NET  1532 = abc_6876_new_n2192
* NET  1533 = abc_6876_new_n2191
* NET  1534 = abc_6876_new_n2190
* NET  1535 = abc_6876_new_n2189
* NET  1536 = abc_6876_new_n2188
* NET  1537 = abc_6876_new_n2187
* NET  1538 = abc_6876_new_n2186
* NET  1539 = abc_6876_new_n2185
* NET  1540 = abc_6876_new_n2184
* NET  1541 = abc_6876_new_n2183
* NET  1542 = abc_6876_new_n2181
* NET  1543 = abc_6876_new_n2180
* NET  1544 = abc_6876_new_n2179
* NET  1545 = abc_6876_new_n2178
* NET  1546 = abc_6876_new_n2177
* NET  1547 = abc_6876_new_n2176
* NET  1548 = abc_6876_new_n2175
* NET  1549 = abc_6876_new_n2174
* NET  1550 = abc_6876_new_n2173
* NET  1551 = abc_6876_new_n2172
* NET  1552 = abc_6876_new_n2171
* NET  1553 = abc_6876_new_n2170
* NET  1554 = abc_6876_new_n2169
* NET  1555 = abc_6876_new_n2168
* NET  1556 = abc_6876_new_n2167
* NET  1557 = abc_6876_new_n2166
* NET  1558 = abc_6876_new_n2165
* NET  1559 = abc_6876_new_n2164
* NET  1560 = abc_6876_new_n2163
* NET  1561 = abc_6876_new_n2162
* NET  1562 = abc_6876_new_n2161
* NET  1563 = abc_6876_new_n2160
* NET  1564 = abc_6876_new_n2159
* NET  1565 = abc_6876_new_n2158
* NET  1566 = abc_6876_new_n2157
* NET  1567 = abc_6876_new_n2155
* NET  1568 = abc_6876_new_n2154
* NET  1569 = abc_6876_new_n2153
* NET  1570 = abc_6876_new_n2152
* NET  1571 = abc_6876_new_n2151
* NET  1572 = abc_6876_new_n2150
* NET  1573 = abc_6876_new_n2149
* NET  1574 = abc_6876_new_n2148
* NET  1575 = abc_6876_new_n2147
* NET  1576 = abc_6876_new_n2146
* NET  1577 = abc_6876_new_n2145
* NET  1578 = abc_6876_new_n2144
* NET  1579 = abc_6876_new_n2143
* NET  1580 = abc_6876_new_n2142
* NET  1581 = abc_6876_new_n2141
* NET  1582 = abc_6876_new_n2140
* NET  1583 = abc_6876_new_n2139
* NET  1584 = abc_6876_new_n2138
* NET  1585 = abc_6876_new_n2137
* NET  1586 = abc_6876_new_n2136
* NET  1587 = abc_6876_new_n2134
* NET  1588 = abc_6876_new_n2133
* NET  1589 = abc_6876_new_n2132
* NET  1590 = abc_6876_new_n2131
* NET  1591 = abc_6876_new_n2130
* NET  1592 = abc_6876_new_n2129
* NET  1593 = abc_6876_new_n2128
* NET  1594 = abc_6876_new_n2127
* NET  1595 = abc_6876_new_n2126
* NET  1596 = abc_6876_new_n2125
* NET  1597 = abc_6876_new_n2124
* NET  1598 = abc_6876_new_n2123
* NET  1599 = abc_6876_new_n2122
* NET  1600 = abc_6876_new_n2121
* NET  1601 = abc_6876_new_n2120
* NET  1602 = abc_6876_new_n2119
* NET  1603 = abc_6876_new_n2118
* NET  1604 = abc_6876_new_n2117
* NET  1605 = abc_6876_new_n2116
* NET  1606 = abc_6876_new_n2115
* NET  1607 = abc_6876_new_n2114
* NET  1608 = abc_6876_new_n2113
* NET  1609 = abc_6876_new_n2112
* NET  1610 = abc_6876_new_n2111
* NET  1611 = abc_6876_new_n2110
* NET  1612 = abc_6876_new_n2109
* NET  1613 = abc_6876_new_n2108
* NET  1614 = abc_6876_new_n2107
* NET  1615 = abc_6876_new_n2105
* NET  1616 = abc_6876_new_n2104
* NET  1617 = abc_6876_new_n2103
* NET  1618 = abc_6876_new_n2102
* NET  1619 = abc_6876_new_n2101
* NET  1620 = abc_6876_new_n2100
* NET  1621 = abc_6876_new_n2099
* NET  1622 = abc_6876_new_n2098
* NET  1623 = abc_6876_new_n2097
* NET  1624 = abc_6876_new_n2096
* NET  1625 = abc_6876_new_n2095
* NET  1626 = abc_6876_new_n2094
* NET  1627 = abc_6876_new_n2093
* NET  1628 = abc_6876_new_n2092
* NET  1629 = abc_6876_new_n2091
* NET  1630 = abc_6876_new_n2090
* NET  1631 = abc_6876_new_n2089
* NET  1632 = abc_6876_new_n2088
* NET  1633 = abc_6876_new_n2087
* NET  1634 = abc_6876_new_n2086
* NET  1635 = abc_6876_new_n2085
* NET  1636 = abc_6876_new_n2084
* NET  1637 = abc_6876_new_n2083
* NET  1638 = abc_6876_new_n2082
* NET  1639 = abc_6876_new_n2081
* NET  1640 = abc_6876_new_n2080
* NET  1641 = abc_6876_new_n2079
* NET  1642 = abc_6876_new_n2078
* NET  1643 = abc_6876_new_n2077
* NET  1644 = abc_6876_new_n2076
* NET  1645 = abc_6876_new_n2075
* NET  1646 = abc_6876_new_n2074
* NET  1647 = abc_6876_new_n2073
* NET  1648 = abc_6876_new_n2072
* NET  1649 = abc_6876_new_n2071
* NET  1650 = abc_6876_new_n2070
* NET  1651 = abc_6876_new_n2069
* NET  1652 = abc_6876_new_n2068
* NET  1653 = abc_6876_new_n2066
* NET  1654 = abc_6876_new_n2065
* NET  1655 = abc_6876_new_n2064
* NET  1656 = abc_6876_new_n2063
* NET  1657 = abc_6876_new_n2062
* NET  1658 = abc_6876_new_n2061
* NET  1659 = abc_6876_new_n2060
* NET  1660 = abc_6876_new_n2059
* NET  1661 = abc_6876_new_n2058
* NET  1662 = abc_6876_new_n2057
* NET  1663 = abc_6876_new_n2056
* NET  1664 = abc_6876_new_n2055
* NET  1665 = abc_6876_new_n2054
* NET  1666 = abc_6876_new_n2053
* NET  1667 = abc_6876_new_n2052
* NET  1668 = abc_6876_new_n2051
* NET  1669 = abc_6876_new_n2050
* NET  1670 = abc_6876_new_n2049
* NET  1671 = abc_6876_new_n2048
* NET  1672 = abc_6876_new_n2047
* NET  1673 = abc_6876_new_n2046
* NET  1674 = abc_6876_new_n2045
* NET  1675 = abc_6876_new_n2044
* NET  1676 = abc_6876_new_n2043
* NET  1677 = abc_6876_new_n2042
* NET  1678 = abc_6876_new_n2041
* NET  1679 = abc_6876_new_n2040
* NET  1680 = abc_6876_new_n2039
* NET  1681 = abc_6876_new_n2038
* NET  1682 = abc_6876_new_n2037
* NET  1683 = abc_6876_new_n2036
* NET  1684 = abc_6876_new_n2035
* NET  1685 = abc_6876_new_n2034
* NET  1686 = abc_6876_new_n2033
* NET  1687 = abc_6876_new_n2032
* NET  1688 = abc_6876_new_n2030
* NET  1689 = abc_6876_new_n2029
* NET  1690 = abc_6876_new_n2028
* NET  1691 = abc_6876_new_n2027
* NET  1692 = abc_6876_new_n2026
* NET  1693 = abc_6876_new_n2025
* NET  1694 = abc_6876_new_n2024
* NET  1695 = abc_6876_new_n2023
* NET  1696 = abc_6876_new_n2022
* NET  1697 = abc_6876_new_n2021
* NET  1698 = abc_6876_new_n2020
* NET  1699 = abc_6876_new_n2019
* NET  1700 = abc_6876_new_n2018
* NET  1701 = abc_6876_new_n2017
* NET  1702 = abc_6876_new_n2016
* NET  1703 = abc_6876_new_n2015
* NET  1704 = abc_6876_new_n2014
* NET  1705 = abc_6876_new_n2013
* NET  1706 = abc_6876_new_n2012
* NET  1707 = abc_6876_new_n2011
* NET  1708 = abc_6876_new_n2010
* NET  1709 = abc_6876_new_n2009
* NET  1710 = abc_6876_new_n2008
* NET  1711 = abc_6876_new_n2007
* NET  1712 = abc_6876_new_n2006
* NET  1713 = abc_6876_new_n2005
* NET  1714 = abc_6876_new_n2004
* NET  1715 = abc_6876_new_n2003
* NET  1716 = abc_6876_new_n2002
* NET  1717 = abc_6876_new_n2001
* NET  1718 = abc_6876_new_n2000
* NET  1719 = abc_6876_new_n1999
* NET  1720 = abc_6876_new_n1998
* NET  1721 = abc_6876_new_n1997
* NET  1722 = abc_6876_new_n1996
* NET  1723 = abc_6876_new_n1995
* NET  1724 = abc_6876_new_n1994
* NET  1725 = abc_6876_new_n1993
* NET  1726 = abc_6876_new_n1992
* NET  1727 = abc_6876_new_n1991
* NET  1728 = abc_6876_new_n1990
* NET  1729 = abc_6876_new_n1989
* NET  1730 = abc_6876_new_n1988
* NET  1731 = abc_6876_new_n1987
* NET  1732 = abc_6876_new_n1986
* NET  1733 = abc_6876_new_n1984
* NET  1734 = abc_6876_new_n1983
* NET  1735 = abc_6876_new_n1982
* NET  1736 = abc_6876_new_n1981
* NET  1737 = abc_6876_new_n1980
* NET  1738 = abc_6876_new_n1979
* NET  1739 = abc_6876_new_n1978
* NET  1740 = abc_6876_new_n1977
* NET  1741 = abc_6876_new_n1976
* NET  1742 = abc_6876_new_n1975
* NET  1743 = abc_6876_new_n1974
* NET  1744 = abc_6876_new_n1973
* NET  1745 = abc_6876_new_n1972
* NET  1746 = abc_6876_new_n1971
* NET  1747 = abc_6876_new_n1970
* NET  1748 = abc_6876_new_n1969
* NET  1749 = abc_6876_new_n1968
* NET  1750 = abc_6876_new_n1967
* NET  1751 = abc_6876_new_n1966
* NET  1752 = abc_6876_new_n1965
* NET  1753 = abc_6876_new_n1964
* NET  1754 = abc_6876_new_n1963
* NET  1755 = abc_6876_new_n1962
* NET  1756 = abc_6876_new_n1961
* NET  1757 = abc_6876_new_n1960
* NET  1758 = abc_6876_new_n1959
* NET  1759 = abc_6876_new_n1958
* NET  1760 = abc_6876_new_n1957
* NET  1761 = abc_6876_new_n1956
* NET  1762 = abc_6876_new_n1955
* NET  1763 = abc_6876_new_n1954
* NET  1764 = abc_6876_new_n1953
* NET  1765 = abc_6876_new_n1952
* NET  1766 = abc_6876_new_n1951
* NET  1767 = abc_6876_new_n1950
* NET  1768 = abc_6876_new_n1949
* NET  1769 = abc_6876_new_n1948
* NET  1770 = abc_6876_new_n1947
* NET  1771 = abc_6876_new_n1946
* NET  1772 = abc_6876_new_n1945
* NET  1773 = abc_6876_new_n1944
* NET  1774 = abc_6876_new_n1943
* NET  1775 = abc_6876_new_n1942
* NET  1776 = abc_6876_new_n1941
* NET  1777 = abc_6876_new_n1940
* NET  1778 = abc_6876_new_n1939
* NET  1779 = abc_6876_new_n1938
* NET  1780 = abc_6876_new_n1937
* NET  1781 = abc_6876_new_n1936
* NET  1782 = abc_6876_new_n1935
* NET  1783 = abc_6876_new_n1934
* NET  1784 = abc_6876_new_n1933
* NET  1785 = abc_6876_new_n1932
* NET  1786 = abc_6876_new_n1930
* NET  1787 = abc_6876_new_n1929
* NET  1788 = abc_6876_new_n1928
* NET  1789 = abc_6876_new_n1927
* NET  1790 = abc_6876_new_n1926
* NET  1791 = abc_6876_new_n1925
* NET  1792 = abc_6876_new_n1924
* NET  1793 = abc_6876_new_n1923
* NET  1794 = abc_6876_new_n1922
* NET  1795 = abc_6876_new_n1921
* NET  1796 = abc_6876_new_n1920
* NET  1797 = abc_6876_new_n1919
* NET  1798 = abc_6876_new_n1918
* NET  1799 = abc_6876_new_n1917
* NET  1800 = abc_6876_new_n1916
* NET  1801 = abc_6876_new_n1915
* NET  1802 = abc_6876_new_n1914
* NET  1803 = abc_6876_new_n1913
* NET  1804 = abc_6876_new_n1912
* NET  1805 = abc_6876_new_n1911
* NET  1806 = abc_6876_new_n1910
* NET  1807 = abc_6876_new_n1909
* NET  1808 = abc_6876_new_n1908
* NET  1809 = abc_6876_new_n1907
* NET  1810 = abc_6876_new_n1906
* NET  1811 = abc_6876_new_n1905
* NET  1812 = abc_6876_new_n1904
* NET  1813 = abc_6876_new_n1903
* NET  1814 = abc_6876_new_n1902
* NET  1815 = abc_6876_new_n1901
* NET  1816 = abc_6876_new_n1900
* NET  1817 = abc_6876_new_n1899
* NET  1818 = abc_6876_new_n1898
* NET  1819 = abc_6876_new_n1897
* NET  1820 = abc_6876_new_n1896
* NET  1821 = abc_6876_new_n1895
* NET  1822 = abc_6876_new_n1894
* NET  1823 = abc_6876_new_n1893
* NET  1824 = abc_6876_new_n1892
* NET  1825 = abc_6876_new_n1891
* NET  1826 = abc_6876_new_n1890
* NET  1827 = abc_6876_new_n1889
* NET  1828 = abc_6876_new_n1888
* NET  1829 = abc_6876_new_n1887
* NET  1830 = abc_6876_new_n1886
* NET  1831 = abc_6876_new_n1885
* NET  1832 = abc_6876_new_n1884
* NET  1833 = abc_6876_new_n1883
* NET  1834 = abc_6876_new_n1882
* NET  1835 = abc_6876_new_n1880
* NET  1836 = abc_6876_new_n1879
* NET  1837 = abc_6876_new_n1878
* NET  1838 = abc_6876_new_n1877
* NET  1839 = abc_6876_new_n1876
* NET  1840 = abc_6876_new_n1875
* NET  1841 = abc_6876_new_n1874
* NET  1842 = abc_6876_new_n1873
* NET  1843 = abc_6876_new_n1872
* NET  1844 = abc_6876_new_n1871
* NET  1845 = abc_6876_new_n1870
* NET  1846 = abc_6876_new_n1869
* NET  1847 = abc_6876_new_n1868
* NET  1848 = abc_6876_new_n1867
* NET  1849 = abc_6876_new_n1866
* NET  1850 = abc_6876_new_n1865
* NET  1851 = abc_6876_new_n1864
* NET  1852 = abc_6876_new_n1863
* NET  1853 = abc_6876_new_n1862
* NET  1854 = abc_6876_new_n1861
* NET  1855 = abc_6876_new_n1860
* NET  1856 = abc_6876_new_n1859
* NET  1857 = abc_6876_new_n1858
* NET  1858 = abc_6876_new_n1857
* NET  1859 = abc_6876_new_n1856
* NET  1860 = abc_6876_new_n1855
* NET  1861 = abc_6876_new_n1854
* NET  1862 = abc_6876_new_n1853
* NET  1863 = abc_6876_new_n1852
* NET  1864 = abc_6876_new_n1851
* NET  1865 = abc_6876_new_n1850
* NET  1866 = abc_6876_new_n1849
* NET  1867 = abc_6876_new_n1848
* NET  1868 = abc_6876_new_n1847
* NET  1869 = abc_6876_new_n1846
* NET  1870 = abc_6876_new_n1845
* NET  1871 = abc_6876_new_n1844
* NET  1872 = abc_6876_new_n1843
* NET  1873 = abc_6876_new_n1842
* NET  1874 = abc_6876_new_n1841
* NET  1875 = abc_6876_new_n1840
* NET  1876 = abc_6876_new_n1839
* NET  1877 = abc_6876_new_n1838
* NET  1878 = abc_6876_new_n1837
* NET  1879 = abc_6876_new_n1836
* NET  1880 = abc_6876_new_n1835
* NET  1881 = abc_6876_new_n1834
* NET  1882 = abc_6876_new_n1833
* NET  1883 = abc_6876_new_n1832
* NET  1884 = abc_6876_new_n1831
* NET  1885 = abc_6876_new_n1830
* NET  1886 = abc_6876_new_n1829
* NET  1887 = abc_6876_new_n1828
* NET  1888 = abc_6876_new_n1827
* NET  1889 = abc_6876_new_n1825
* NET  1890 = abc_6876_new_n1824
* NET  1891 = abc_6876_new_n1823
* NET  1892 = abc_6876_new_n1822
* NET  1893 = abc_6876_new_n1821
* NET  1894 = abc_6876_new_n1820
* NET  1895 = abc_6876_new_n1819
* NET  1896 = abc_6876_new_n1818
* NET  1897 = abc_6876_new_n1817
* NET  1898 = abc_6876_new_n1816
* NET  1899 = abc_6876_new_n1815
* NET  1900 = abc_6876_new_n1814
* NET  1901 = abc_6876_new_n1813
* NET  1902 = abc_6876_new_n1812
* NET  1903 = abc_6876_new_n1811
* NET  1904 = abc_6876_new_n1810
* NET  1905 = abc_6876_new_n1809
* NET  1906 = abc_6876_new_n1808
* NET  1907 = abc_6876_new_n1807
* NET  1908 = abc_6876_new_n1806
* NET  1909 = abc_6876_new_n1805
* NET  1910 = abc_6876_new_n1804
* NET  1911 = abc_6876_new_n1803
* NET  1912 = abc_6876_new_n1802
* NET  1913 = abc_6876_new_n1801
* NET  1914 = abc_6876_new_n1800
* NET  1915 = abc_6876_new_n1799
* NET  1916 = abc_6876_new_n1798
* NET  1917 = abc_6876_new_n1797
* NET  1918 = abc_6876_new_n1796
* NET  1919 = abc_6876_new_n1795
* NET  1920 = abc_6876_new_n1794
* NET  1921 = abc_6876_new_n1793
* NET  1922 = abc_6876_new_n1792
* NET  1923 = abc_6876_new_n1791
* NET  1924 = abc_6876_new_n1790
* NET  1925 = abc_6876_new_n1789
* NET  1926 = abc_6876_new_n1788
* NET  1927 = abc_6876_new_n1787
* NET  1928 = abc_6876_new_n1786
* NET  1929 = abc_6876_new_n1785
* NET  1930 = abc_6876_new_n1784
* NET  1931 = abc_6876_new_n1783
* NET  1932 = abc_6876_new_n1782
* NET  1933 = abc_6876_new_n1781
* NET  1934 = abc_6876_new_n1780
* NET  1935 = abc_6876_new_n1779
* NET  1936 = abc_6876_new_n1778
* NET  1937 = abc_6876_new_n1777
* NET  1938 = abc_6876_new_n1775
* NET  1939 = abc_6876_new_n1774
* NET  1940 = abc_6876_new_n1773
* NET  1941 = abc_6876_new_n1772
* NET  1942 = abc_6876_new_n1771
* NET  1943 = abc_6876_new_n1770
* NET  1944 = abc_6876_new_n1769
* NET  1945 = abc_6876_new_n1768
* NET  1946 = abc_6876_new_n1767
* NET  1947 = abc_6876_new_n1766
* NET  1948 = abc_6876_new_n1765
* NET  1949 = abc_6876_new_n1764
* NET  1950 = abc_6876_new_n1763
* NET  1951 = abc_6876_new_n1762
* NET  1952 = abc_6876_new_n1761
* NET  1953 = abc_6876_new_n1760
* NET  1954 = abc_6876_new_n1759
* NET  1955 = abc_6876_new_n1758
* NET  1956 = abc_6876_new_n1757
* NET  1957 = abc_6876_new_n1756
* NET  1958 = abc_6876_new_n1755
* NET  1959 = abc_6876_new_n1754
* NET  1960 = abc_6876_new_n1753
* NET  1961 = abc_6876_new_n1752
* NET  1962 = abc_6876_new_n1751
* NET  1963 = abc_6876_new_n1750
* NET  1964 = abc_6876_new_n1749
* NET  1965 = abc_6876_new_n1748
* NET  1966 = abc_6876_new_n1747
* NET  1967 = abc_6876_new_n1746
* NET  1968 = abc_6876_new_n1745
* NET  1969 = abc_6876_new_n1744
* NET  1970 = abc_6876_new_n1743
* NET  1971 = abc_6876_new_n1742
* NET  1972 = abc_6876_new_n1741
* NET  1973 = abc_6876_new_n1740
* NET  1974 = abc_6876_new_n1739
* NET  1975 = abc_6876_new_n1738
* NET  1976 = abc_6876_new_n1737
* NET  1977 = abc_6876_new_n1736
* NET  1978 = abc_6876_new_n1735
* NET  1979 = abc_6876_new_n1734
* NET  1980 = abc_6876_new_n1733
* NET  1981 = abc_6876_new_n1732
* NET  1982 = abc_6876_new_n1731
* NET  1983 = abc_6876_new_n1730
* NET  1984 = abc_6876_new_n1729
* NET  1985 = abc_6876_new_n1728
* NET  1986 = abc_6876_new_n1726
* NET  1987 = abc_6876_new_n1725
* NET  1988 = abc_6876_new_n1724
* NET  1989 = abc_6876_new_n1723
* NET  1990 = abc_6876_new_n1722
* NET  1991 = abc_6876_new_n1721
* NET  1992 = abc_6876_new_n1720
* NET  1993 = abc_6876_new_n1719
* NET  1994 = abc_6876_new_n1718
* NET  1995 = abc_6876_new_n1717
* NET  1996 = abc_6876_new_n1716
* NET  1997 = abc_6876_new_n1715
* NET  1998 = abc_6876_new_n1714
* NET  1999 = abc_6876_new_n1713
* NET  2000 = abc_6876_new_n1712
* NET  2001 = abc_6876_new_n1711
* NET  2002 = abc_6876_new_n1710
* NET  2003 = abc_6876_new_n1709
* NET  2004 = abc_6876_new_n1708
* NET  2005 = abc_6876_new_n1707
* NET  2006 = abc_6876_new_n1706
* NET  2007 = abc_6876_new_n1705
* NET  2008 = abc_6876_new_n1704
* NET  2009 = abc_6876_new_n1703
* NET  2010 = abc_6876_new_n1702
* NET  2011 = abc_6876_new_n1701
* NET  2012 = abc_6876_new_n1700
* NET  2013 = abc_6876_new_n1699
* NET  2014 = abc_6876_new_n1698
* NET  2015 = abc_6876_new_n1697
* NET  2016 = abc_6876_new_n1696
* NET  2017 = abc_6876_new_n1695
* NET  2018 = abc_6876_new_n1694
* NET  2019 = abc_6876_new_n1693
* NET  2020 = abc_6876_new_n1692
* NET  2021 = abc_6876_new_n1691
* NET  2022 = abc_6876_new_n1690
* NET  2023 = abc_6876_new_n1689
* NET  2024 = abc_6876_new_n1688
* NET  2025 = abc_6876_new_n1687
* NET  2026 = abc_6876_new_n1686
* NET  2027 = abc_6876_new_n1685
* NET  2028 = abc_6876_new_n1684
* NET  2029 = abc_6876_new_n1683
* NET  2030 = abc_6876_new_n1682
* NET  2031 = abc_6876_new_n1681
* NET  2032 = abc_6876_new_n1679
* NET  2033 = abc_6876_new_n1678
* NET  2034 = abc_6876_new_n1677
* NET  2035 = abc_6876_new_n1676
* NET  2036 = abc_6876_new_n1675
* NET  2037 = abc_6876_new_n1674
* NET  2038 = abc_6876_new_n1673
* NET  2039 = abc_6876_new_n1672
* NET  2040 = abc_6876_new_n1671
* NET  2041 = abc_6876_new_n1670
* NET  2042 = abc_6876_new_n1669
* NET  2043 = abc_6876_new_n1668
* NET  2044 = abc_6876_new_n1667
* NET  2045 = abc_6876_new_n1666
* NET  2046 = abc_6876_new_n1665
* NET  2047 = abc_6876_new_n1664
* NET  2048 = abc_6876_new_n1663
* NET  2049 = abc_6876_new_n1662
* NET  2050 = abc_6876_new_n1661
* NET  2051 = abc_6876_new_n1660
* NET  2052 = abc_6876_new_n1659
* NET  2053 = abc_6876_new_n1658
* NET  2054 = abc_6876_new_n1657
* NET  2055 = abc_6876_new_n1656
* NET  2056 = abc_6876_new_n1655
* NET  2057 = abc_6876_new_n1654
* NET  2058 = abc_6876_new_n1653
* NET  2059 = abc_6876_new_n1652
* NET  2060 = abc_6876_new_n1651
* NET  2061 = abc_6876_new_n1650
* NET  2062 = abc_6876_new_n1649
* NET  2063 = abc_6876_new_n1648
* NET  2064 = abc_6876_new_n1647
* NET  2065 = abc_6876_new_n1646
* NET  2066 = abc_6876_new_n1645
* NET  2067 = abc_6876_new_n1644
* NET  2068 = abc_6876_new_n1643
* NET  2069 = abc_6876_new_n1642
* NET  2070 = abc_6876_new_n1641
* NET  2071 = abc_6876_new_n1640
* NET  2072 = abc_6876_new_n1639
* NET  2073 = abc_6876_new_n1638
* NET  2074 = abc_6876_new_n1637
* NET  2075 = abc_6876_new_n1636
* NET  2076 = abc_6876_new_n1635
* NET  2077 = abc_6876_new_n1634
* NET  2078 = abc_6876_new_n1633
* NET  2079 = abc_6876_new_n1632
* NET  2080 = abc_6876_new_n1631
* NET  2081 = abc_6876_new_n1630
* NET  2082 = abc_6876_new_n1629
* NET  2083 = abc_6876_new_n1628
* NET  2084 = abc_6876_new_n1627
* NET  2085 = abc_6876_new_n1626
* NET  2086 = abc_6876_new_n1625
* NET  2087 = abc_6876_new_n1624
* NET  2088 = abc_6876_new_n1622
* NET  2089 = abc_6876_new_n1621
* NET  2090 = abc_6876_new_n1620
* NET  2091 = abc_6876_new_n1619
* NET  2092 = abc_6876_new_n1618
* NET  2093 = abc_6876_new_n1617
* NET  2094 = abc_6876_new_n1616
* NET  2095 = abc_6876_new_n1615
* NET  2096 = abc_6876_new_n1614
* NET  2097 = abc_6876_new_n1613
* NET  2098 = abc_6876_new_n1612
* NET  2099 = abc_6876_new_n1611
* NET  2100 = abc_6876_new_n1610
* NET  2101 = abc_6876_new_n1609
* NET  2102 = abc_6876_new_n1608
* NET  2103 = abc_6876_new_n1607
* NET  2104 = abc_6876_new_n1606
* NET  2105 = abc_6876_new_n1605
* NET  2106 = abc_6876_new_n1604
* NET  2107 = abc_6876_new_n1603
* NET  2108 = abc_6876_new_n1602
* NET  2109 = abc_6876_new_n1601
* NET  2110 = abc_6876_new_n1600
* NET  2111 = abc_6876_new_n1599
* NET  2112 = abc_6876_new_n1598
* NET  2113 = abc_6876_new_n1597
* NET  2114 = abc_6876_new_n1596
* NET  2115 = abc_6876_new_n1595
* NET  2116 = abc_6876_new_n1594
* NET  2117 = abc_6876_new_n1593
* NET  2118 = abc_6876_new_n1592
* NET  2119 = abc_6876_new_n1591
* NET  2120 = abc_6876_new_n1590
* NET  2121 = abc_6876_new_n1589
* NET  2122 = abc_6876_new_n1588
* NET  2123 = abc_6876_new_n1587
* NET  2124 = abc_6876_new_n1586
* NET  2125 = abc_6876_new_n1585
* NET  2126 = abc_6876_new_n1584
* NET  2127 = abc_6876_new_n1583
* NET  2128 = abc_6876_new_n1582
* NET  2129 = abc_6876_new_n1581
* NET  2130 = abc_6876_new_n1580
* NET  2131 = abc_6876_new_n1579
* NET  2132 = abc_6876_new_n1578
* NET  2133 = abc_6876_new_n1577
* NET  2134 = abc_6876_new_n1576
* NET  2135 = abc_6876_new_n1575
* NET  2136 = abc_6876_new_n1574
* NET  2137 = abc_6876_new_n1573
* NET  2138 = abc_6876_new_n1572
* NET  2139 = abc_6876_new_n1571
* NET  2140 = abc_6876_new_n1570
* NET  2141 = abc_6876_new_n1568
* NET  2142 = abc_6876_new_n1567
* NET  2143 = abc_6876_new_n1566
* NET  2144 = abc_6876_new_n1565
* NET  2145 = abc_6876_new_n1564
* NET  2146 = abc_6876_new_n1563
* NET  2147 = abc_6876_new_n1562
* NET  2148 = abc_6876_new_n1561
* NET  2149 = abc_6876_new_n1560
* NET  2150 = abc_6876_new_n1559
* NET  2151 = abc_6876_new_n1558
* NET  2152 = abc_6876_new_n1557
* NET  2153 = abc_6876_new_n1556
* NET  2154 = abc_6876_new_n1555
* NET  2155 = abc_6876_new_n1554
* NET  2156 = abc_6876_new_n1553
* NET  2157 = abc_6876_new_n1552
* NET  2158 = abc_6876_new_n1551
* NET  2159 = abc_6876_new_n1550
* NET  2160 = abc_6876_new_n1549
* NET  2161 = abc_6876_new_n1548
* NET  2162 = abc_6876_new_n1547
* NET  2163 = abc_6876_new_n1546
* NET  2164 = abc_6876_new_n1545
* NET  2165 = abc_6876_new_n1544
* NET  2166 = abc_6876_new_n1543
* NET  2167 = abc_6876_new_n1542
* NET  2168 = abc_6876_new_n1541
* NET  2169 = abc_6876_new_n1540
* NET  2170 = abc_6876_new_n1539
* NET  2171 = abc_6876_new_n1538
* NET  2172 = abc_6876_new_n1537
* NET  2173 = abc_6876_new_n1536
* NET  2174 = abc_6876_new_n1535
* NET  2175 = abc_6876_new_n1534
* NET  2176 = abc_6876_new_n1533
* NET  2177 = abc_6876_new_n1532
* NET  2178 = abc_6876_new_n1531
* NET  2179 = abc_6876_new_n1530
* NET  2180 = abc_6876_new_n1529
* NET  2181 = abc_6876_new_n1528
* NET  2182 = abc_6876_new_n1527
* NET  2183 = abc_6876_new_n1526
* NET  2184 = abc_6876_new_n1525
* NET  2185 = abc_6876_new_n1524
* NET  2186 = abc_6876_new_n1523
* NET  2187 = abc_6876_new_n1522
* NET  2188 = abc_6876_new_n1521
* NET  2189 = abc_6876_new_n1520
* NET  2190 = abc_6876_new_n1519
* NET  2191 = abc_6876_new_n1518
* NET  2192 = abc_6876_new_n1517
* NET  2193 = abc_6876_new_n1515
* NET  2194 = abc_6876_new_n1514
* NET  2195 = abc_6876_new_n1513
* NET  2196 = abc_6876_new_n1512
* NET  2197 = abc_6876_new_n1511
* NET  2198 = abc_6876_new_n1510
* NET  2199 = abc_6876_new_n1509
* NET  2200 = abc_6876_new_n1508
* NET  2201 = abc_6876_new_n1507
* NET  2202 = abc_6876_new_n1506
* NET  2203 = abc_6876_new_n1505
* NET  2204 = abc_6876_new_n1504
* NET  2205 = abc_6876_new_n1503
* NET  2206 = abc_6876_new_n1502
* NET  2207 = abc_6876_new_n1501
* NET  2208 = abc_6876_new_n1500
* NET  2209 = abc_6876_new_n1499
* NET  2210 = abc_6876_new_n1498
* NET  2211 = abc_6876_new_n1497
* NET  2212 = abc_6876_new_n1496
* NET  2213 = abc_6876_new_n1495
* NET  2214 = abc_6876_new_n1494
* NET  2215 = abc_6876_new_n1493
* NET  2216 = abc_6876_new_n1492
* NET  2217 = abc_6876_new_n1491
* NET  2218 = abc_6876_new_n1490
* NET  2219 = abc_6876_new_n1489
* NET  2220 = abc_6876_new_n1488
* NET  2221 = abc_6876_new_n1487
* NET  2222 = abc_6876_new_n1486
* NET  2223 = abc_6876_new_n1485
* NET  2224 = abc_6876_new_n1484
* NET  2225 = abc_6876_new_n1483
* NET  2226 = abc_6876_new_n1482
* NET  2227 = abc_6876_new_n1481
* NET  2228 = abc_6876_new_n1480
* NET  2229 = abc_6876_new_n1479
* NET  2230 = abc_6876_new_n1478
* NET  2231 = abc_6876_new_n1477
* NET  2232 = abc_6876_new_n1476
* NET  2233 = abc_6876_new_n1475
* NET  2234 = abc_6876_new_n1474
* NET  2235 = abc_6876_new_n1473
* NET  2236 = abc_6876_new_n1472
* NET  2237 = abc_6876_new_n1471
* NET  2238 = abc_6876_new_n1470
* NET  2239 = abc_6876_new_n1469
* NET  2240 = abc_6876_new_n1468
* NET  2241 = abc_6876_new_n1467
* NET  2242 = abc_6876_new_n1466
* NET  2243 = abc_6876_new_n1465
* NET  2244 = abc_6876_new_n1464
* NET  2245 = abc_6876_new_n1463
* NET  2246 = abc_6876_new_n1462
* NET  2247 = abc_6876_new_n1461
* NET  2248 = abc_6876_new_n1459
* NET  2249 = abc_6876_new_n1458
* NET  2250 = abc_6876_new_n1457
* NET  2251 = abc_6876_new_n1456
* NET  2252 = abc_6876_new_n1455
* NET  2253 = abc_6876_new_n1454
* NET  2254 = abc_6876_new_n1453
* NET  2255 = abc_6876_new_n1452
* NET  2256 = abc_6876_new_n1451
* NET  2257 = abc_6876_new_n1450
* NET  2258 = abc_6876_new_n1449
* NET  2259 = abc_6876_new_n1448
* NET  2260 = abc_6876_new_n1447
* NET  2261 = abc_6876_new_n1446
* NET  2262 = abc_6876_new_n1445
* NET  2263 = abc_6876_new_n1444
* NET  2264 = abc_6876_new_n1443
* NET  2265 = abc_6876_new_n1442
* NET  2266 = abc_6876_new_n1441
* NET  2267 = abc_6876_new_n1440
* NET  2268 = abc_6876_new_n1439
* NET  2269 = abc_6876_new_n1438
* NET  2270 = abc_6876_new_n1437
* NET  2271 = abc_6876_new_n1436
* NET  2272 = abc_6876_new_n1435
* NET  2273 = abc_6876_new_n1434
* NET  2274 = abc_6876_new_n1433
* NET  2275 = abc_6876_new_n1432
* NET  2276 = abc_6876_new_n1431
* NET  2277 = abc_6876_new_n1430
* NET  2278 = abc_6876_new_n1429
* NET  2279 = abc_6876_new_n1428
* NET  2280 = abc_6876_new_n1427
* NET  2281 = abc_6876_new_n1426
* NET  2282 = abc_6876_new_n1425
* NET  2283 = abc_6876_new_n1424
* NET  2284 = abc_6876_new_n1423
* NET  2285 = abc_6876_new_n1422
* NET  2286 = abc_6876_new_n1421
* NET  2287 = abc_6876_new_n1420
* NET  2288 = abc_6876_new_n1419
* NET  2289 = abc_6876_new_n1418
* NET  2290 = abc_6876_new_n1417
* NET  2291 = abc_6876_new_n1415
* NET  2292 = abc_6876_new_n1414
* NET  2293 = abc_6876_new_n1413
* NET  2294 = abc_6876_new_n1412
* NET  2295 = abc_6876_new_n1411
* NET  2296 = abc_6876_new_n1410
* NET  2297 = abc_6876_new_n1409
* NET  2298 = abc_6876_new_n1408
* NET  2299 = abc_6876_new_n1407
* NET  2300 = abc_6876_new_n1406
* NET  2301 = abc_6876_new_n1405
* NET  2302 = abc_6876_new_n1403
* NET  2303 = abc_6876_new_n1402
* NET  2304 = abc_6876_new_n1401
* NET  2305 = abc_6876_new_n1400
* NET  2306 = abc_6876_new_n1399
* NET  2307 = abc_6876_new_n1398
* NET  2308 = abc_6876_new_n1397
* NET  2309 = abc_6876_new_n1396
* NET  2310 = abc_6876_new_n1395
* NET  2311 = abc_6876_new_n1394
* NET  2312 = abc_6876_new_n1393
* NET  2313 = abc_6876_new_n1392
* NET  2314 = abc_6876_new_n1391
* NET  2315 = abc_6876_new_n1390
* NET  2316 = abc_6876_new_n1389
* NET  2317 = abc_6876_new_n1388
* NET  2318 = abc_6876_new_n1386
* NET  2319 = abc_6876_new_n1385
* NET  2320 = abc_6876_new_n1384
* NET  2321 = abc_6876_new_n1383
* NET  2322 = abc_6876_new_n1382
* NET  2323 = abc_6876_new_n1381
* NET  2324 = abc_6876_new_n1380
* NET  2325 = abc_6876_new_n1379
* NET  2326 = abc_6876_new_n1378
* NET  2327 = abc_6876_new_n1377
* NET  2328 = abc_6876_new_n1376
* NET  2329 = abc_6876_new_n1375
* NET  2330 = abc_6876_new_n1374
* NET  2331 = abc_6876_new_n1373
* NET  2332 = abc_6876_new_n1372
* NET  2333 = abc_6876_new_n1370
* NET  2334 = abc_6876_new_n1369
* NET  2335 = abc_6876_new_n1368
* NET  2336 = abc_6876_new_n1367
* NET  2337 = abc_6876_new_n1366
* NET  2338 = abc_6876_new_n1365
* NET  2339 = abc_6876_new_n1364
* NET  2340 = abc_6876_new_n1363
* NET  2341 = abc_6876_new_n1362
* NET  2342 = abc_6876_new_n1361
* NET  2343 = abc_6876_new_n1360
* NET  2344 = abc_6876_new_n1359
* NET  2345 = abc_6876_new_n1358
* NET  2346 = abc_6876_new_n1357
* NET  2347 = abc_6876_new_n1356
* NET  2348 = abc_6876_new_n1355
* NET  2349 = abc_6876_new_n1354
* NET  2350 = abc_6876_new_n1352
* NET  2351 = abc_6876_new_n1351
* NET  2352 = abc_6876_new_n1350
* NET  2353 = abc_6876_new_n1349
* NET  2354 = abc_6876_new_n1348
* NET  2355 = abc_6876_new_n1347
* NET  2356 = abc_6876_new_n1346
* NET  2357 = abc_6876_new_n1345
* NET  2358 = abc_6876_new_n1344
* NET  2359 = abc_6876_new_n1343
* NET  2360 = abc_6876_new_n1342
* NET  2361 = abc_6876_new_n1341
* NET  2362 = abc_6876_new_n1340
* NET  2363 = abc_6876_new_n1339
* NET  2364 = abc_6876_new_n1338
* NET  2365 = abc_6876_new_n1337
* NET  2366 = abc_6876_new_n1335
* NET  2367 = abc_6876_new_n1334
* NET  2368 = abc_6876_new_n1333
* NET  2369 = abc_6876_new_n1332
* NET  2370 = abc_6876_new_n1331
* NET  2371 = abc_6876_new_n1330
* NET  2372 = abc_6876_new_n1329
* NET  2373 = abc_6876_new_n1328
* NET  2374 = abc_6876_new_n1327
* NET  2375 = abc_6876_new_n1326
* NET  2376 = abc_6876_new_n1325
* NET  2377 = abc_6876_new_n1324
* NET  2378 = abc_6876_new_n1323
* NET  2379 = abc_6876_new_n1322
* NET  2380 = abc_6876_new_n1321
* NET  2381 = abc_6876_new_n1320
* NET  2382 = abc_6876_new_n1319
* NET  2383 = abc_6876_new_n1317
* NET  2384 = abc_6876_new_n1316
* NET  2385 = abc_6876_new_n1315
* NET  2386 = abc_6876_new_n1314
* NET  2387 = abc_6876_new_n1313
* NET  2388 = abc_6876_new_n1312
* NET  2389 = abc_6876_new_n1311
* NET  2390 = abc_6876_new_n1310
* NET  2391 = abc_6876_new_n1309
* NET  2392 = abc_6876_new_n1308
* NET  2393 = abc_6876_new_n1307
* NET  2394 = abc_6876_new_n1306
* NET  2395 = abc_6876_new_n1305
* NET  2396 = abc_6876_new_n1304
* NET  2397 = abc_6876_new_n1303
* NET  2398 = abc_6876_new_n1302
* NET  2399 = abc_6876_new_n1301
* NET  2400 = abc_6876_new_n1300
* NET  2401 = abc_6876_new_n1298
* NET  2402 = abc_6876_new_n1297
* NET  2403 = abc_6876_new_n1296
* NET  2404 = abc_6876_new_n1295
* NET  2405 = abc_6876_new_n1294
* NET  2406 = abc_6876_new_n1293
* NET  2407 = abc_6876_new_n1292
* NET  2408 = abc_6876_new_n1291
* NET  2409 = abc_6876_new_n1290
* NET  2410 = abc_6876_new_n1289
* NET  2411 = abc_6876_new_n1288
* NET  2412 = abc_6876_new_n1287
* NET  2413 = abc_6876_new_n1286
* NET  2414 = abc_6876_new_n1285
* NET  2415 = abc_6876_new_n1284
* NET  2416 = abc_6876_new_n1283
* NET  2417 = abc_6876_new_n1282
* NET  2418 = abc_6876_new_n1281
* NET  2419 = abc_6876_new_n1280
* NET  2420 = abc_6876_new_n1279
* NET  2421 = abc_6876_new_n1278
* NET  2422 = abc_6876_new_n1277
* NET  2423 = abc_6876_new_n1276
* NET  2424 = abc_6876_new_n1275
* NET  2425 = abc_6876_new_n1274
* NET  2426 = abc_6876_new_n1272
* NET  2427 = abc_6876_new_n1271
* NET  2428 = abc_6876_new_n1270
* NET  2429 = abc_6876_new_n1269
* NET  2430 = abc_6876_new_n1268
* NET  2431 = abc_6876_new_n1267
* NET  2432 = abc_6876_new_n1266
* NET  2433 = abc_6876_new_n1265
* NET  2434 = abc_6876_new_n1264
* NET  2435 = abc_6876_new_n1263
* NET  2436 = abc_6876_new_n1262
* NET  2437 = abc_6876_new_n1261
* NET  2438 = abc_6876_new_n1260
* NET  2439 = abc_6876_new_n1259
* NET  2440 = abc_6876_new_n1258
* NET  2441 = abc_6876_new_n1257
* NET  2442 = abc_6876_new_n1256
* NET  2443 = abc_6876_new_n1255
* NET  2444 = abc_6876_new_n1253
* NET  2445 = abc_6876_new_n1252
* NET  2446 = abc_6876_new_n1251
* NET  2447 = abc_6876_new_n1250
* NET  2448 = abc_6876_new_n1249
* NET  2449 = abc_6876_new_n1248
* NET  2450 = abc_6876_new_n1247
* NET  2451 = abc_6876_new_n1246
* NET  2452 = abc_6876_new_n1245
* NET  2453 = abc_6876_new_n1244
* NET  2454 = abc_6876_new_n1243
* NET  2455 = abc_6876_new_n1242
* NET  2456 = abc_6876_new_n1241
* NET  2457 = abc_6876_new_n1240
* NET  2458 = abc_6876_new_n1239
* NET  2459 = abc_6876_new_n1238
* NET  2460 = abc_6876_new_n1237
* NET  2461 = abc_6876_new_n1236
* NET  2462 = abc_6876_new_n1235
* NET  2463 = abc_6876_new_n1234
* NET  2464 = abc_6876_new_n1233
* NET  2465 = abc_6876_new_n1232
* NET  2466 = abc_6876_new_n1231
* NET  2467 = abc_6876_new_n1230
* NET  2468 = abc_6876_new_n1229
* NET  2469 = abc_6876_new_n1228
* NET  2470 = abc_6876_new_n1226
* NET  2471 = abc_6876_new_n1225
* NET  2472 = abc_6876_new_n1224
* NET  2473 = abc_6876_new_n1223
* NET  2474 = abc_6876_new_n1222
* NET  2475 = abc_6876_new_n1221
* NET  2476 = abc_6876_new_n1220
* NET  2477 = abc_6876_new_n1219
* NET  2478 = abc_6876_new_n1218
* NET  2479 = abc_6876_new_n1217
* NET  2480 = abc_6876_new_n1216
* NET  2481 = abc_6876_new_n1215
* NET  2482 = abc_6876_new_n1214
* NET  2483 = abc_6876_new_n1213
* NET  2484 = abc_6876_new_n1212
* NET  2485 = abc_6876_new_n1211
* NET  2486 = abc_6876_new_n1210
* NET  2487 = abc_6876_new_n1209
* NET  2488 = abc_6876_new_n1208
* NET  2489 = abc_6876_new_n1207
* NET  2490 = abc_6876_new_n1205
* NET  2491 = abc_6876_new_n1204
* NET  2492 = abc_6876_new_n1203
* NET  2493 = abc_6876_new_n1202
* NET  2494 = abc_6876_new_n1201
* NET  2495 = abc_6876_new_n1200
* NET  2496 = abc_6876_new_n1199
* NET  2497 = abc_6876_new_n1198
* NET  2498 = abc_6876_new_n1197
* NET  2499 = abc_6876_new_n1196
* NET  2500 = abc_6876_new_n1195
* NET  2501 = abc_6876_new_n1194
* NET  2502 = abc_6876_new_n1193
* NET  2503 = abc_6876_new_n1192
* NET  2504 = abc_6876_new_n1191
* NET  2505 = abc_6876_new_n1190
* NET  2506 = abc_6876_new_n1189
* NET  2507 = abc_6876_new_n1188
* NET  2508 = abc_6876_new_n1187
* NET  2509 = abc_6876_new_n1186
* NET  2510 = abc_6876_new_n1185
* NET  2511 = abc_6876_new_n1183
* NET  2512 = abc_6876_new_n1182
* NET  2513 = abc_6876_new_n1181
* NET  2514 = abc_6876_new_n1180
* NET  2515 = abc_6876_new_n1179
* NET  2516 = abc_6876_new_n1178
* NET  2517 = abc_6876_new_n1177
* NET  2518 = abc_6876_new_n1176
* NET  2519 = abc_6876_new_n1175
* NET  2520 = abc_6876_new_n1174
* NET  2521 = abc_6876_new_n1173
* NET  2522 = abc_6876_new_n1172
* NET  2523 = abc_6876_new_n1171
* NET  2524 = abc_6876_new_n1170
* NET  2525 = abc_6876_new_n1169
* NET  2526 = abc_6876_new_n1168
* NET  2527 = abc_6876_new_n1167
* NET  2528 = abc_6876_new_n1166
* NET  2529 = abc_6876_new_n1165
* NET  2530 = abc_6876_new_n1164
* NET  2531 = abc_6876_new_n1163
* NET  2532 = abc_6876_new_n1161
* NET  2533 = abc_6876_new_n1160
* NET  2534 = abc_6876_new_n1159
* NET  2535 = abc_6876_new_n1158
* NET  2536 = abc_6876_new_n1157
* NET  2537 = abc_6876_new_n1156
* NET  2538 = abc_6876_new_n1155
* NET  2539 = abc_6876_new_n1154
* NET  2540 = abc_6876_new_n1153
* NET  2541 = abc_6876_new_n1152
* NET  2542 = abc_6876_new_n1151
* NET  2543 = abc_6876_new_n1150
* NET  2544 = abc_6876_new_n1149
* NET  2545 = abc_6876_new_n1148
* NET  2546 = abc_6876_new_n1147
* NET  2547 = abc_6876_new_n1146
* NET  2548 = abc_6876_new_n1145
* NET  2549 = abc_6876_new_n1144
* NET  2550 = abc_6876_new_n1142
* NET  2551 = abc_6876_new_n1141
* NET  2552 = abc_6876_new_n1140
* NET  2553 = abc_6876_new_n1139
* NET  2554 = abc_6876_new_n1138
* NET  2555 = abc_6876_new_n1137
* NET  2556 = abc_6876_new_n1136
* NET  2557 = abc_6876_new_n1135
* NET  2558 = abc_6876_new_n1134
* NET  2559 = abc_6876_new_n1133
* NET  2560 = abc_6876_new_n1132
* NET  2561 = abc_6876_new_n1131
* NET  2562 = abc_6876_new_n1130
* NET  2563 = abc_6876_new_n1129
* NET  2564 = abc_6876_new_n1128
* NET  2565 = abc_6876_new_n1127
* NET  2566 = abc_6876_new_n1126
* NET  2567 = abc_6876_new_n1124
* NET  2568 = abc_6876_new_n1123
* NET  2569 = abc_6876_new_n1122
* NET  2570 = abc_6876_new_n1121
* NET  2571 = abc_6876_new_n1120
* NET  2572 = abc_6876_new_n1119
* NET  2573 = abc_6876_new_n1118
* NET  2574 = abc_6876_new_n1117
* NET  2575 = abc_6876_new_n1115
* NET  2576 = abc_6876_new_n1114
* NET  2577 = abc_6876_new_n1113
* NET  2578 = abc_6876_new_n1112
* NET  2579 = abc_6876_new_n1111
* NET  2580 = abc_6876_new_n1110
* NET  2581 = abc_6876_new_n1109
* NET  2582 = abc_6876_new_n1108
* NET  2583 = abc_6876_new_n1107
* NET  2584 = abc_6876_new_n1106
* NET  2585 = abc_6876_new_n1105
* NET  2586 = abc_6876_new_n1103
* NET  2587 = abc_6876_new_n1102
* NET  2588 = abc_6876_new_n1101
* NET  2589 = abc_6876_new_n1100
* NET  2590 = abc_6876_new_n1099
* NET  2591 = abc_6876_new_n1098
* NET  2592 = abc_6876_new_n1097
* NET  2593 = abc_6876_new_n1096
* NET  2594 = abc_6876_new_n1095
* NET  2595 = abc_6876_new_n1094
* NET  2596 = abc_6876_new_n1093
* NET  2597 = abc_6876_new_n1092
* NET  2598 = abc_6876_new_n1091
* NET  2599 = abc_6876_new_n1090
* NET  2600 = abc_6876_new_n1089
* NET  2601 = abc_6876_new_n1088
* NET  2602 = abc_6876_new_n1086
* NET  2603 = abc_6876_new_n1085
* NET  2604 = abc_6876_new_n1084
* NET  2605 = abc_6876_new_n1083
* NET  2606 = abc_6876_new_n1082
* NET  2607 = abc_6876_new_n1081
* NET  2608 = abc_6876_new_n1080
* NET  2609 = abc_6876_new_n1079
* NET  2610 = abc_6876_new_n1078
* NET  2611 = abc_6876_new_n1077
* NET  2612 = abc_6876_new_n1076
* NET  2613 = abc_6876_new_n1075
* NET  2614 = abc_6876_new_n1074
* NET  2615 = abc_6876_new_n1073
* NET  2616 = abc_6876_new_n1072
* NET  2617 = abc_6876_new_n1070
* NET  2618 = abc_6876_new_n1069
* NET  2619 = abc_6876_new_n1068
* NET  2620 = abc_6876_new_n1067
* NET  2621 = abc_6876_new_n1066
* NET  2622 = abc_6876_new_n1065
* NET  2623 = abc_6876_new_n1064
* NET  2624 = abc_6876_new_n1063
* NET  2625 = abc_6876_new_n1062
* NET  2626 = abc_6876_new_n1061
* NET  2627 = abc_6876_new_n1060
* NET  2628 = abc_6876_new_n1059
* NET  2629 = abc_6876_new_n1058
* NET  2630 = abc_6876_new_n1057
* NET  2631 = abc_6876_new_n1056
* NET  2632 = abc_6876_new_n1055
* NET  2633 = abc_6876_new_n1054
* NET  2634 = abc_6876_new_n1052
* NET  2635 = abc_6876_new_n1051
* NET  2636 = abc_6876_new_n1050
* NET  2637 = abc_6876_new_n1049
* NET  2638 = abc_6876_new_n1048
* NET  2639 = abc_6876_new_n1047
* NET  2640 = abc_6876_new_n1046
* NET  2641 = abc_6876_new_n1045
* NET  2642 = abc_6876_new_n1044
* NET  2643 = abc_6876_new_n1043
* NET  2644 = abc_6876_new_n1042
* NET  2645 = abc_6876_new_n1041
* NET  2646 = abc_6876_new_n1040
* NET  2647 = abc_6876_new_n1039
* NET  2648 = abc_6876_new_n1038
* NET  2649 = abc_6876_new_n1037
* NET  2650 = abc_6876_new_n1035
* NET  2651 = abc_6876_new_n1034
* NET  2652 = abc_6876_new_n1033
* NET  2653 = abc_6876_new_n1032
* NET  2654 = abc_6876_new_n1031
* NET  2655 = abc_6876_new_n1030
* NET  2656 = abc_6876_new_n1029
* NET  2657 = abc_6876_new_n1028
* NET  2658 = abc_6876_new_n1027
* NET  2659 = abc_6876_new_n1026
* NET  2660 = abc_6876_new_n1025
* NET  2661 = abc_6876_new_n1024
* NET  2662 = abc_6876_new_n1023
* NET  2663 = abc_6876_new_n1022
* NET  2664 = abc_6876_new_n1021
* NET  2665 = abc_6876_new_n1020
* NET  2666 = abc_6876_new_n1019
* NET  2667 = abc_6876_new_n1017
* NET  2668 = abc_6876_new_n1016
* NET  2669 = abc_6876_new_n1015
* NET  2670 = abc_6876_new_n1014
* NET  2671 = abc_6876_new_n1013
* NET  2672 = abc_6876_new_n1012
* NET  2673 = abc_6876_new_n1011
* NET  2674 = abc_6876_new_n1010
* NET  2675 = abc_6876_new_n1009
* NET  2676 = abc_6876_new_n1008
* NET  2677 = abc_6876_new_n1007
* NET  2678 = abc_6876_new_n1006
* NET  2679 = abc_6876_new_n1005
* NET  2680 = abc_6876_new_n1004
* NET  2681 = abc_6876_new_n1003
* NET  2682 = abc_6876_new_n1002
* NET  2683 = abc_6876_new_n1001
* NET  2684 = abc_6876_new_n1000
* NET  2685 = a_reg[7]
* NET  2686 = a_reg[6]
* NET  2687 = a_reg[5]
* NET  2688 = a_reg[4]
* NET  2689 = a_reg[3]
* NET  2690 = a_reg[2]
* NET  2691 = a_reg[1]
* NET  2692 = a_reg[0]
* NET  2693 = a[9]
* NET  2694 = a[8]
* NET  2695 = a[7]
* NET  2696 = a[6]
* NET  2697 = a[5]
* NET  2698 = a[4]
* NET  2699 = a[3]
* NET  2700 = a[2]
* NET  2701 = a[15]
* NET  2702 = a[14]
* NET  2703 = a[13]
* NET  2704 = a[12]
* NET  2705 = a[11]
* NET  2706 = a[10]
* NET  2707 = a[1]
* NET  2708 = a[0]
* NET  2709 = reset_root_tr_tr_0
* NET  2710 = reset_root_tr_tl_0
* NET  2711 = reset_root_tr_br_0
* NET  2712 = reset_root_tr_bl_0
* NET  2713 = reset_root_tr_0
* NET  2714 = reset_root_tl_tr_0
* NET  2715 = reset_root_tl_tl_0
* NET  2716 = reset_root_tl_br_0
* NET  2717 = reset_root_tl_bl_0
* NET  2718 = reset_root_tl_0
* NET  2719 = reset_root_br_tr_0
* NET  2720 = reset_root_br_tl_0
* NET  2721 = reset_root_br_br_0
* NET  2722 = reset_root_br_bl_0
* NET  2723 = reset_root_br_0
* NET  2724 = reset_root_bl_tr_0
* NET  2725 = reset_root_bl_tl_0
* NET  2726 = reset_root_bl_br_0
* NET  2727 = reset_root_bl_bl_0
* NET  2728 = reset_root_bl_0
* NET  2729 = reset_root_0
* NET  2730 = clk_root_tr_tr_2
* NET  2731 = clk_root_tr_tr_1
* NET  2732 = clk_root_tr_tr_0
* NET  2733 = clk_root_tr_tl_2
* NET  2734 = clk_root_tr_tl_1
* NET  2735 = clk_root_tr_tl_0
* NET  2736 = clk_root_tr_br_2
* NET  2737 = clk_root_tr_br_1
* NET  2738 = clk_root_tr_br_0
* NET  2739 = clk_root_tr_bl_2
* NET  2740 = clk_root_tr_bl_1
* NET  2741 = clk_root_tr_bl_0
* NET  2742 = clk_root_tr_0
* NET  2743 = clk_root_tl_tr_2
* NET  2744 = clk_root_tl_tr_1
* NET  2745 = clk_root_tl_tr_0
* NET  2746 = clk_root_tl_tl_2
* NET  2747 = clk_root_tl_tl_1
* NET  2748 = clk_root_tl_tl_0
* NET  2749 = clk_root_tl_br_2
* NET  2750 = clk_root_tl_br_1
* NET  2751 = clk_root_tl_br_0
* NET  2752 = clk_root_tl_bl_2
* NET  2753 = clk_root_tl_bl_1
* NET  2754 = clk_root_tl_bl_0
* NET  2755 = clk_root_tl_0
* NET  2756 = clk_root_br_tr_2
* NET  2757 = clk_root_br_tr_1
* NET  2758 = clk_root_br_tr_0
* NET  2759 = clk_root_br_tl_2
* NET  2760 = clk_root_br_tl_1
* NET  2761 = clk_root_br_tl_0
* NET  2762 = clk_root_br_br_2
* NET  2763 = clk_root_br_br_1
* NET  2764 = clk_root_br_br_0
* NET  2765 = clk_root_br_bl_2
* NET  2766 = clk_root_br_bl_1
* NET  2767 = clk_root_br_bl_0
* NET  2768 = clk_root_br_0
* NET  2769 = clk_root_bl_tr_2
* NET  2770 = clk_root_bl_tr_1
* NET  2771 = clk_root_bl_tr_0
* NET  2772 = clk_root_bl_tl_2
* NET  2773 = clk_root_bl_tl_1
* NET  2774 = clk_root_bl_tl_0
* NET  2775 = clk_root_bl_br_2
* NET  2776 = clk_root_bl_br_1
* NET  2777 = clk_root_bl_br_0
* NET  2778 = clk_root_bl_bl_2
* NET  2779 = clk_root_bl_bl_1
* NET  2780 = clk_root_bl_bl_0
* NET  2781 = clk_root_bl_0
* NET  2782 = clk_root_0
* NET  2783 = blockagenet

xfeed_408 83 82 tie
xfeed_264 83 82 decap_w0
xsubckt_1081_nexor2_x0 83 82 10 33 2329 nexor2_x0
xsubckt_712_and2_x1 83 82 2678 40 77 and2_x1
xsubckt_1767_nand2_x0 83 82 1658 1659 674 nand2_x0
xsubckt_1939_and2_x1 83 82 141 1492 1494 and2_x1
xsubckt_1987_or21nand_x0 83 82 1444 866 1454 1445 or21nand_x0
xsubckt_2015_nand3_x0 83 82 1417 1420 1442 821 nand3_x0
xsubckt_2067_mux2_x1 83 82 68 1371 671 1366 mux2_x1
xfeed_409 83 82 tie
xfeed_265 83 82 decap_w0
xsubckt_1646_nand3_x0 83 82 1777 626 808 248 nand3_x0
xsubckt_2121_and21nor_x0 83 82 1313 1353 1360 1363 and21nor_x0
xsubckt_2231_nand4_x0 83 82 1206 72 250 249 248 nand4_x0
xsubckt_2318_nand2_x0 83 82 1121 1207 625 nand2_x0
xsubckt_2445_nexor2_x0 83 82 1007 34 997 nexor2_x0
xsubckt_2509_nand2_x0 83 82 235 941 942 nand2_x0
xfeed_859 83 82 decap_w0
xfeed_266 83 82 decap_w0
xsubckt_242_or4_x1 83 82 705 2694 2693 2706 2705 or4_x1
xsubckt_611_and2_x1 83 82 361 45 65 and2_x1
xsubckt_1524_nexor2_x0 83 82 1947 2 1896 nexor2_x0
xfeed_858 83 82 decap_w0
xfeed_267 83 82 decap_w0
xsubckt_774_and21nor_x0 83 82 2619 2623 2624 441 and21nor_x0
xfeed_329 83 82 tie
xspare_buffer_68 83 82 2742 2741 buf_x4
xsubckt_1059_nand2_x0 83 82 123 2350 2364 nand2_x0
xsubckt_34_inv_x0 83 82 2704 881 inv_x0
xsubckt_1465_and4_x1 83 82 1954 2106 844 846 848 and4_x1
xsubckt_1613_and21nor_x0 83 82 1809 1858 1860 1864 and21nor_x0
xfeed_261 83 82 tie
xspare_buffer_69 83 82 2742 2740 buf_x4
xsubckt_1139_nand2_x0 83 82 2274 2284 868 nand2_x0
xsubckt_24_inv_x0 83 82 57 891 inv_x0
xsubckt_422_nand4_x0 83 82 533 535 694 709 110 nand4_x0
xsubckt_1447_or21nand_x0 83 82 1972 1976 1974 1973 or21nand_x0
xsubckt_1691_and2_x1 83 82 172 1733 1785 and2_x1
xfeed_262 83 82 tie
xsubckt_1127_and3_x1 83 82 2286 93 867 91 and3_x1
xsubckt_217_nand3_x0 83 82 725 106 885 85 nand3_x0
xsubckt_406_nand3_x0 83 82 549 551 553 578 nand3_x0
xsubckt_1372_nand2_x0 83 82 2045 2046 2275 nand2_x0
xsubckt_1659_or21nand_x0 83 82 1764 1771 1765 1767 or21nand_x0
xsubckt_1956_or21nand_x0 83 82 1475 1484 1480 1478 or21nand_x0
xfeed_263 83 82 tie
xsubckt_2620_dff_x1 83 82 184 2752 2697 dff_x1
xsubckt_981_nand2_x0 83 82 2424 1 24 nand2_x0
xsubckt_886_and21nor_x0 83 82 2514 6 435 442 and21nor_x0
xsubckt_834_and2_x1 83 82 2564 38 15 and2_x1
xsubckt_229_nand3_x0 83 82 717 102 885 85 nand3_x0
xsubckt_44_inv_x0 83 82 2699 871 inv_x0
xsubckt_508_and2_x1 83 82 456 457 585 and2_x1
xsubckt_1419_and2_x1 83 82 1999 2000 2001 and2_x1
xsubckt_2069_nand3_x0 83 82 1364 1367 1389 29 nand3_x0
xsubckt_2260_and3_x1 83 82 1177 1178 1179 658 and3_x1
xfeed_853 83 82 tie
xfeed_400 83 82 tie
xfeed_325 83 82 tie
xspare_buffer_64 83 82 2755 2745 buf_x4
xsubckt_950_nexor2_x0 83 82 2454 2457 2453 nexor2_x0
xsubckt_579_nand2_x0 83 82 392 393 396 nand2_x0
xsubckt_1416_nexor2_x0 83 82 2047 846 2002 nexor2_x0
xsubckt_1842_or21nand_x0 83 82 1586 1608 1610 1611 or21nand_x0
xsubckt_2168_nand2_x0 83 82 1267 2283 27 nand2_x0
xfeed_852 83 82 tie
xfeed_401 83 82 tie
xfeed_324 83 82 tie
xspare_buffer_65 83 82 2755 2744 buf_x4
xsubckt_906_and2_x1 83 82 2495 5 25 and2_x1
xsubckt_758_or21nand_x0 83 82 2634 2635 2641 446 or21nand_x0
xsubckt_194_nand2_x0 83 82 741 753 19 nand2_x0
xsubckt_484_or21nand_x0 83 82 478 479 480 691 or21nand_x0
xsubckt_1731_and21nor_x0 83 82 1693 659 1694 1719 and21nor_x0
xsubckt_2481_or2_x1 83 82 136 963 964 or2_x1
xfeed_851 83 82 tie
xfeed_402 83 82 tie
xspare_buffer_66 83 82 2755 2743 buf_x4
xsubckt_1109_and21nor_x0 83 82 2302 2303 2310 447 and21nor_x0
xsubckt_490_and3_x1 83 82 473 474 487 2706 and3_x1
xsubckt_2204_and2_x1 83 82 1232 1237 26 and2_x1
xsubckt_2301_nexor2_x0 83 82 1139 1141 1137 nexor2_x0
xfeed_850 83 82 decap_w0
xfeed_403 83 82 decap_w0
xfeed_326 83 82 tie
xspare_buffer_67 83 82 2718 2714 buf_x4
xsubckt_1262_nexor2_x0 83 82 2207 822 2153 nexor2_x0
xsubckt_1036_xor2_x0 83 82 13 33 2371 xor2_x0
xsubckt_1961_and2_x1 83 82 1470 1471 671 and2_x1
xfeed_857 83 82 decap_w0
xfeed_404 83 82 decap_w0
xfeed_321 83 82 tie
xfeed_268 83 82 tie
xspare_buffer_60 83 82 2755 2748 buf_x4
xsubckt_1238_nand3_x0 83 82 2177 2179 2181 671 nand3_x0
xsubckt_881_or21nand_x0 83 82 2519 2544 2543 2542 or21nand_x0
xsubckt_144_or21nand_x0 83 82 777 269 790 897 or21nand_x0
xfeed_856 83 82 decap_w0
xfeed_405 83 82 decap_w0
xfeed_320 83 82 tie
xfeed_269 83 82 tie
xspare_buffer_61 83 82 2755 2747 buf_x4
xsubckt_2644_dff_x1 83 82 169 2778 74 dff_x1
xsubckt_951_and2_x1 83 82 2452 2453 436 and2_x1
xsubckt_1952_nand3_x0 83 82 1479 626 67 248 nand3_x0
xsubckt_2358_mux2_x1 83 82 20 1082 884 140 mux2_x1
xfeed_855 83 82 tie
xfeed_406 83 82 tie
xfeed_323 83 82 tie
xspare_buffer_62 83 82 2755 2746 buf_x4
xsubckt_1203_nand3_x0 83 82 2211 2212 2284 868 nand3_x0
xsubckt_69_inv_x0 83 82 44 846 inv_x0
xsubckt_1917_nand3_x0 83 82 1513 1519 1540 38 nand3_x0
xfeed_854 83 82 tie
xfeed_407 83 82 tie
xfeed_322 83 82 tie
xspare_buffer_63 83 82 2718 2715 buf_x4
xsubckt_857_nand2_x0 83 82 2542 30 7 nand2_x0
xsubckt_662_and21nor_x0 83 82 313 335 334 333 and21nor_x0
xsubckt_456_and2_x1 83 82 503 504 527 and2_x1
xsubckt_1519_nand2_x0 83 82 1901 2283 854 nand2_x0
xsubckt_1856_or21nand_x0 83 82 1572 1577 1575 1573 or21nand_x0
xdiode_70 83 82 250 diode_w1
xsubckt_1120_nand3_x0 83 82 2292 2293 2294 442 nand3_x0
xsubckt_676_nand2_x0 83 82 299 42 76 nand2_x0
xsubckt_378_nexor2_x0 83 82 673 876 576 nexor2_x0
xsubckt_1310_nor4_x0 83 82 2106 46 47 54 55 nor4_x0
xsubckt_1311_nexor2_x0 83 82 2162 850 2105 nexor2_x0
xsubckt_1604_nand2_x0 83 82 1818 1820 849 nand2_x0
xsubckt_1631_or21nand_x0 83 82 1791 1799 1794 1792 or21nand_x0
xsubckt_1743_mux2_x1 83 82 810 1683 671 1682 mux2_x1
xsubckt_1930_nand4_x0 83 82 1500 1501 1502 1503 2285 nand4_x0
xsubckt_2530_and2_x1 83 82 232 930 2719 and2_x1
xdiode_71 83 82 250 diode_w1
xsubckt_1232_nand2_x0 83 82 2183 2184 683 nand2_x0
xsubckt_911_and2_x1 83 82 2490 2491 2497 and2_x1
xsubckt_158_mux2_x1 83 82 767 768 772 210 mux2_x1
xdiode_98 83 82 674 diode_w1
xdiode_72 83 82 250 diode_w1
xsubckt_182_nand2_x0 83 82 749 751 267 nand2_x0
xsubckt_1304_nexor2_x0 83 82 2118 852 2112 nexor2_x0
xsubckt_2180_and3_x1 83 82 1256 673 851 250 and3_x1
xsubckt_2470_nand2_x0 83 82 973 1597 2275 nand2_x0
xsubckt_2519_mux2_x1 83 82 98 37 943 935 mux2_x1
xdiode_99 83 82 674 diode_w1
xdiode_73 83 82 865 diode_w1
xsubckt_415_and21nor_x0 83 82 540 542 553 674 and21nor_x0
xsubckt_625_nexor2_x0 83 82 44 67 348 nexor2_x0
xsubckt_1684_and2_x1 83 82 1739 1798 805 and2_x1
xsubckt_2119_nexor2_x0 83 82 1317 1318 1315 nexor2_x0
xsubckt_2222_or3_x1 83 82 1214 1215 1216 271 or3_x1
xsubckt_2271_mux2_x1 83 82 849 837 2269 1167 mux2_x1
xdiode_74 83 82 865 diode_w1
xfeed_758 83 82 decap_w0
xsubckt_994_and2_x1 83 82 2411 2441 2460 and2_x1
xsubckt_150_and2_x1 83 82 773 269 2725 and2_x1
xsubckt_1665_nexor2_x0 83 82 1764 77 1758 nexor2_x0
xsubckt_1781_nand2_x0 83 82 1645 1647 841 nand2_x0
xdiode_75 83 82 865 diode_w1
xfeed_759 83 82 decap_w0
xsubckt_1111_or21nand_x0 83 82 2301 2313 2314 2316 or21nand_x0
xsubckt_1057_and2_x1 83 82 2351 2352 442 and2_x1
xsubckt_369_or21nand_x0 83 82 584 693 869 884 or21nand_x0
xdiode_76 83 82 867 diode_w1
xspare_feed_59 83 82 tie
xsubckt_2670_dff_x1 83 82 145 2738 42 dff_x1
xsubckt_2586_dff_x1 83 82 214 2780 86 dff_x1
xsubckt_2568_dff_x1 83 82 240 2754 2686 dff_x1
xsubckt_307_and2_x1 83 82 644 645 647 and2_x1
xsubckt_147_nand3_x0 83 82 775 791 896 913 nand3_x0
xsubckt_2203_nand2_x0 83 82 1233 1238 26 nand2_x0
xsubckt_2532_and2_x1 83 82 231 929 2719 and2_x1
xdiode_77 83 82 867 diode_w1
xspare_feed_58 83 82 tie
xsubckt_1124_nand2_x0 83 82 2289 93 867 nand2_x0
xsubckt_792_and21nor_x0 83 82 2602 2603 2610 447 and21nor_x0
xsubckt_1694_and21nor_x0 83 82 1730 90 93 76 and21nor_x0
xsubckt_1815_and2_x1 83 82 1612 1613 73 and2_x1
xsubckt_2088_nand4_x0 83 82 1345 93 5 867 868 nand4_x0
xdiode_92 83 82 673 diode_w1
xdiode_78 83 82 867 diode_w1
xfeed_754 83 82 decap_w0
xspare_feed_57 83 82 tie
xsubckt_1556_mux2_x1 83 82 24 1869 671 1865 mux2_x1
xsubckt_1971_nexor2_x0 83 82 1466 824 1460 nexor2_x0
xsubckt_2205_nand2_x0 83 82 1231 1237 26 nand2_x0
xsubckt_2396_nand3_x0 83 82 1045 646 73 249 nand3_x0
xsubckt_2437_and4_x1 83 82 1005 1008 1009 1010 810 and4_x1
xdiode_93 83 82 673 diode_w1
xdiode_79 83 82 867 diode_w1
xfeed_755 83 82 decap_w0
xspare_feed_56 83 82 tie
xsubckt_1256_nand4_x0 83 82 2159 93 7 90 91 nand4_x0
xsubckt_95_inv_x0 83 82 25 820 inv_x0
xsubckt_1985_and2_x1 83 82 1446 1447 658 and2_x1
xsubckt_2349_and3_x1 83 82 1090 1091 1092 658 and3_x1
xdiode_90 83 82 673 diode_w1
xfeed_756 83 82 decap_w0
xspare_feed_55 83 82 tie
xsubckt_649_nand2_x0 83 82 325 43 66 nand2_x0
xsubckt_313_and21nor_x0 83 82 638 657 665 668 and21nor_x0
xsubckt_327_or2_x1 83 82 625 250 249 or2_x1
xsubckt_1300_and2_x1 83 82 2116 2117 852 and2_x1
xsubckt_1538_nand2_x0 83 82 1883 806 248 nand2_x0
xsubckt_1574_or21nand_x0 83 82 1847 2 1946 1 or21nand_x0
xsubckt_2050_nand4_x0 83 82 1383 849 250 864 248 nand4_x0
xdiode_91 83 82 673 diode_w1
xfeed_757 83 82 decap_w0
xspare_feed_54 83 82 tie
xsubckt_746_or2_x1 83 82 2646 52 75 or2_x1
xsubckt_17_inv_x0 83 82 261 898 inv_x0
xsubckt_1452_and3_x1 83 82 1967 1970 1985 67 and3_x1
xsubckt_1666_nexor2_x0 83 82 1764 847 1757 nexor2_x0
xsubckt_2209_nexor2_x0 83 82 1238 26 1227 nexor2_x0
xdiode_96 83 82 673 diode_w1
xfeed_750 83 82 tie
xsubckt_276_nand2_x0 83 82 674 271 883 nand2_x0
xsubckt_67_inv_x0 83 82 45 848 inv_x0
xsubckt_1915_nand3_x0 83 82 1515 1519 1540 829 nand3_x0
xsubckt_2177_and21nor_x0 83 82 1258 659 1269 1259 and21nor_x0
xsubckt_2428_and4_x1 83 82 1014 93 802 867 868 and4_x1
xdiode_97 83 82 673 diode_w1
xfeed_751 83 82 tie
xspare_feed_52 83 82 tie
xsubckt_2657_dff_x1 83 82 140 2777 37 dff_x1
xsubckt_991_nexor2_x0 83 82 2415 2416 2414 nexor2_x0
xsubckt_873_nand2_x0 83 82 2527 2528 2531 nand2_x0
xsubckt_181_nand4_x0 83 82 750 754 80 913 81 nand4_x0
xsubckt_1964_or21nand_x0 83 82 1467 1476 1472 1470 or21nand_x0
xsubckt_2338_or21nand_x0 83 82 1101 1107 1111 37 or21nand_x0
xdiode_94 83 82 673 diode_w1
xfeed_752 83 82 decap_w0
xspare_feed_51 83 82 tie
xsubckt_937_nand2_x0 83 82 2466 2488 2507 nand2_x0
xsubckt_292_nand2_x0 83 82 658 271 2701 nand2_x0
xsubckt_447_and21nor_x0 83 82 511 883 271 2694 and21nor_x0
xsubckt_566_mux2_x1 83 82 47 405 436 404 mux2_x1
xsubckt_1400_or21nand_x0 83 82 2018 2022 2020 2019 or21nand_x0
xsubckt_2016_and21nor_x0 83 82 1416 1420 1442 821 and21nor_x0
xdiode_95 83 82 673 diode_w1
xfeed_753 83 82 decap_w0
xspare_feed_50 83 82 tie
xsubckt_2686_dff_x1 83 82 113 2738 2 dff_x1
xsubckt_539_and2_x1 83 82 158 430 443 and2_x1
xsubckt_1544_and3_x1 83 82 1877 1878 1879 683 and3_x1
xsubckt_1734_nexor2_x0 83 82 1692 1698 1690 nexor2_x0
xsubckt_2033_nand2_x0 83 82 1399 2095 2275 nand2_x0
xsubckt_2149_or21nand_x0 83 82 1286 1290 1288 1287 or21nand_x0
xsubckt_2313_or2_x1 83 82 1125 1126 251 or2_x1
xfeed_1050 83 82 decap_w0
xfeed_596 83 82 tie
xfeed_457 83 82 decap_w0
xsubckt_1349_or21nand_x0 83 82 2068 2074 2070 2069 or21nand_x0
xsubckt_1569_and21nor_x0 83 82 1852 809 2282 1853 and21nor_x0
xsubckt_2025_or21nand_x0 83 82 1407 1491 1461 1462 or21nand_x0
xsubckt_2167_and2_x1 83 82 1268 1953 2282 and2_x1
xfeed_1051 83 82 decap_w0
xfeed_597 83 82 tie
xfeed_456 83 82 tie
xfeed_162 83 82 tie
xsubckt_860_mux2_x1 83 82 7 2540 436 2539 mux2_x1
xsubckt_586_nexor2_x0 83 82 386 389 385 nexor2_x0
xsubckt_1534_nand3_x0 83 82 1887 646 37 249 nand3_x0
xsubckt_1982_or21nand_x0 83 82 1449 868 853 2290 or21nand_x0
xsubckt_2429_and4_x1 83 82 1013 93 833 867 91 and4_x1
xfeed_1052 83 82 decap_w0
xfeed_828 83 82 decap_w0
xfeed_594 83 82 tie
xfeed_455 83 82 tie
xfeed_161 83 82 tie
xsubckt_1237_and3_x1 83 82 2178 2179 2181 671 and3_x1
xsubckt_1215_nand2_x0 83 82 2199 2200 2214 nand2_x0
xsubckt_784_or21nand_x0 83 82 2610 435 2612 2611 or21nand_x0
xsubckt_329_and2_x1 83 82 623 625 865 and2_x1
xsubckt_357_and21nor_x0 83 82 596 615 616 618 and21nor_x0
xsubckt_1909_nand2_x0 83 82 1521 1523 671 nand2_x0
xsubckt_2197_nand2_x0 83 82 1239 1241 671 nand2_x0
xsubckt_2235_and2_x1 83 82 1202 1203 1204 and2_x1
xfeed_1053 83 82 decap_w0
xfeed_829 83 82 decap_w0
xfeed_595 83 82 tie
xfeed_454 83 82 decap_w0
xfeed_160 83 82 tie
xsubckt_1188_and21nor_x0 83 82 2226 2233 2231 2227 and21nor_x0
xsubckt_754_nand2_x0 83 82 2638 52 72 nand2_x0
xsubckt_711_or2_x1 83 82 2679 40 77 or2_x1
xsubckt_35_inv_x0 83 82 2706 880 inv_x0
xsubckt_1590_nand3_x0 83 82 1832 806 249 248 nand3_x0
xsubckt_1969_nand3_x0 83 82 1462 1467 1488 31 nand3_x0
xsubckt_2270_and2_x1 83 82 1168 251 889 and2_x1
xfeed_1054 83 82 decap_w0
xfeed_592 83 82 tie
xfeed_453 83 82 tie
xfeed_189 83 82 tie
xsubckt_2658_dff_x1 83 82 139 2777 36 dff_x1
xsubckt_1102_nand3_x0 83 82 2309 2325 2339 2340 nand3_x0
xsubckt_1011_or21nand_x0 83 82 2395 2425 2422 2424 or21nand_x0
xsubckt_681_mux2_x1 83 82 295 309 447 145 mux2_x1
xsubckt_1865_nand3_x0 83 82 1564 2269 67 863 nand3_x0
xfeed_1055 83 82 decap_w0
xfeed_593 83 82 tie
xfeed_452 83 82 decap_w0
xfeed_188 83 82 tie
xsubckt_2600_dff_x1 83 82 220 2763 97 dff_x1
xsubckt_842_nand2_x0 83 82 2556 29 15 nand2_x0
xsubckt_793_or2_x1 83 82 153 2602 2649 or2_x1
xsubckt_1497_and2_x1 83 82 1923 1924 671 and2_x1
xsubckt_1645_and3_x1 83 82 1778 626 808 248 and3_x1
xsubckt_2312_and21nor_x0 83 82 1126 1132 1130 1127 and21nor_x0
xfeed_1056 83 82 decap_w0
xfeed_590 83 82 tie
xfeed_451 83 82 decap_w0
xfeed_165 83 82 tie
xsubckt_2616_dff_x1 83 82 194 2747 2707 dff_x1
xsubckt_525_nand3_x0 83 82 443 444 558 247 nand3_x0
xsubckt_634_nand2_x0 83 82 339 340 442 nand2_x0
xsubckt_640_or2_x1 83 82 334 75 76 or2_x1
xsubckt_1392_nand4_x0 83 82 2026 816 250 864 248 nand4_x0
xsubckt_1399_nand3_x0 83 82 2019 646 26 249 nand3_x0
xsubckt_1589_nand2_x0 83 82 1833 2268 818 nand2_x0
xsubckt_2001_nand2_x0 83 82 1431 1433 683 nand2_x0
xfeed_1057 83 82 decap_w0
xfeed_591 83 82 tie
xfeed_450 83 82 decap_w0
xsubckt_761_nand2_x0 83 82 2632 51 74 nand2_x0
xsubckt_325_mux2_x1 83 82 2692 627 884 187 mux2_x1
xsubckt_405_or2_x1 83 82 550 574 579 or2_x1
xsubckt_1491_nand3_x0 83 82 1929 626 36 248 nand3_x0
xsubckt_1547_and2_x1 83 82 1874 1875 437 and2_x1
xfeed_1058 83 82 decap_w0
xfeed_822 83 82 decap_w0
xfeed_185 83 82 tie
xsubckt_2618_dff_x1 83 82 186 2752 2699 dff_x1
xsubckt_999_xor2_x0 83 82 33 34 2406 xor2_x0
xsubckt_858_xor2_x0 83 82 30 7 2541 xor2_x0
xsubckt_275_and2_x1 83 82 675 271 883 and2_x1
xsubckt_1348_nand3_x0 83 82 2069 646 27 249 nand3_x0
xsubckt_1653_or21nand_x0 83 82 1770 684 1775 1773 or21nand_x0
xfeed_1059 83 82 decap_w0
xfeed_823 83 82 tie
xfeed_184 83 82 tie
xsubckt_1185_nand3_x0 83 82 2229 646 30 249 nand3_x0
xsubckt_589_and21nor_x0 83 82 382 403 402 401 and21nor_x0
xsubckt_1375_nor2_x0 83 82 2042 2043 2044 nor2_x0
xsubckt_1394_nand3_x0 83 82 2024 626 24 248 nand3_x0
xsubckt_1599_and3_x1 83 82 1823 1824 863 249 and3_x1
xsubckt_1832_nand4_x0 83 82 1595 93 832 867 868 nand4_x0
xsubckt_1887_and21nor_x0 83 82 1542 1543 866 251 and21nor_x0
xsubckt_2523_mux2_x1 83 82 96 35 943 933 mux2_x1
xfeed_820 83 82 tie
xfeed_187 83 82 tie
xfeed_169 83 82 tie
xsubckt_583_or2_x1 83 82 388 46 69 or2_x1
xsubckt_1782_and4_x1 83 82 1644 1649 1650 1651 74 and4_x1
xsubckt_1977_nexor2_x0 83 82 1456 1461 1454 nexor2_x0
xsubckt_2283_and3_x1 83 82 1155 673 847 250 and3_x1
xsubckt_2537_mux2_x1 83 82 105 76 943 926 mux2_x1
xfeed_821 83 82 decap_w0
xfeed_186 83 82 tie
xsubckt_686_xor2_x0 83 82 73 74 290 xor2_x0
xsubckt_167_mux2_x1 83 82 761 762 772 207 mux2_x1
xsubckt_423_and2_x1 83 82 532 533 884 and2_x1
xsubckt_554_and21nor_x0 83 82 415 441 423 416 and21nor_x0
xsubckt_1378_nexor2_x0 83 82 2097 5 2039 nexor2_x0
xsubckt_1504_and3_x1 83 82 1916 1922 1936 66 and3_x1
xsubckt_2105_and21nor_x0 83 82 1329 1333 1332 1330 and21nor_x0
xsubckt_2339_nexor2_x0 83 82 1105 37 1100 nexor2_x0
xfeed_826 83 82 decap_w0
xfeed_181 83 82 tie
xsubckt_401_nand2_x0 83 82 554 558 2696 nand2_x0
xsubckt_546_mux2_x1 83 82 856 424 436 423 mux2_x1
xsubckt_1417_nand4_x0 83 82 2001 93 4 90 91 nand4_x0
xsubckt_1536_nand2_x0 83 82 1885 2268 25 nand2_x0
xsubckt_1830_nexor2_x0 83 82 1623 9 1597 nexor2_x0
xsubckt_2269_mux2_x1 83 82 22 1169 884 128 mux2_x1
xsubckt_2499_and4_x1 83 82 216 646 247 249 2712 and4_x1
xfeed_827 83 82 decap_w0
xfeed_180 83 82 decap_w0
xsubckt_1264_and2_x1 83 82 2151 2152 2157 and2_x1
xsubckt_1035_and2_x1 83 82 2372 13 33 and2_x1
xsubckt_277_nor2_x0 83 82 673 249 248 nor2_x0
xsubckt_388_and2_x1 83 82 566 866 2697 and2_x1
xsubckt_1443_and21nor_x0 83 82 1976 1981 1979 1977 and21nor_x0
xsubckt_1885_nand2_x0 83 82 1544 1545 2287 nand2_x0
xsubckt_1995_nand4_x0 83 82 1437 1439 1440 1441 647 nand4_x0
xfeed_824 83 82 tie
xfeed_598 83 82 decap_w0
xfeed_459 83 82 decap_w0
xfeed_183 83 82 tie
xsubckt_1126_nand3_x0 83 82 2287 93 867 868 nand3_x0
xsubckt_1031_or21nand_x0 83 82 2376 2395 2393 2394 or21nand_x0
xsubckt_362_or21nand_x0 83 82 591 611 616 619 or21nand_x0
xsubckt_420_nand3_x0 83 82 535 712 876 877 nand3_x0
xsubckt_1468_nand4_x0 83 82 1951 93 3 90 91 nand4_x0
xsubckt_1630_and2_x1 83 82 1792 1793 866 and2_x1
xsubckt_2414_nand4_x0 83 82 1027 93 803 867 868 nand4_x0
xfeed_825 83 82 tie
xfeed_599 83 82 decap_w0
xfeed_458 83 82 decap_w0
xfeed_182 83 82 tie
xsubckt_0_inv_x0 83 82 84 81 inv_x0
xsubckt_553_and2_x1 83 82 416 417 442 and2_x1
xsubckt_1463_or21nand_x0 83 82 1956 2007 2009 2010 or21nand_x0
xsubckt_1746_nor2_x0 83 82 1679 1682 843 nor2_x0
xsubckt_1752_nexor2_x0 83 82 1675 1676 1673 nexor2_x0
xsubckt_2080_and21nor_x0 83 82 1353 1404 1415 1418 and21nor_x0
xsubckt_2102_nand3_x0 83 82 1332 1335 1339 624 nand3_x0
xdiode_106 83 82 675 diode_w1
xfeed_1234 83 82 tie
xfeed_299 83 82 tie
xsubckt_926_nor2_x0 83 82 2476 4 24 nor2_x0
xsubckt_108_inv_x0 83 82 0 807 inv_x0
xsubckt_548_nand2_x0 83 82 421 69 55 nand2_x0
xsubckt_1297_nand2_x0 83 82 2119 2121 671 nand2_x0
xsubckt_1785_nand2_x0 83 82 1641 1647 74 nand2_x0
xsubckt_2036_and3_x1 83 82 1396 1397 1399 2289 and3_x1
xsubckt_2267_nand2_x0 83 82 1170 1171 675 nand2_x0
xsubckt_2498_and21nor_x0 83 82 215 948 798 914 and21nor_x0
xdiode_107 83 82 675 diode_w1
xfeed_1235 83 82 tie
xsubckt_280_mux2_x1 83 82 864 672 250 670 mux2_x1
xsubckt_1319_nor4_x0 83 82 2097 6 7 14 15 nor4_x0
xsubckt_1715_nand2_x0 83 82 1709 1713 671 nand2_x0
xsubckt_2361_mux2_x1 83 82 76 72 248 1079 mux2_x1
xdiode_104 83 82 675 diode_w1
xfeed_1236 83 82 tie
xfeed_789 83 82 decap_w0
xsubckt_1072_and2_x1 83 82 2337 2339 2340 and2_x1
xsubckt_692_nand2_x0 83 82 284 41 64 nand2_x0
xsubckt_591_nand2_x0 83 82 380 46 66 nand2_x0
xsubckt_1541_nand2_x0 83 82 1880 1882 649 nand2_x0
xsubckt_2140_nand2_x0 83 82 1295 2268 858 nand2_x0
xsubckt_2214_and21nor_x0 83 82 1222 1270 1277 1281 and21nor_x0
xdiode_105 83 82 675 diode_w1
xfeed_1237 83 82 tie
xfeed_788 83 82 decap_w0
xsubckt_1278_nand2_x0 83 82 2138 2266 816 nand2_x0
xsubckt_988_and2_x1 83 82 2417 1 35 and2_x1
xsubckt_394_nand2_x0 83 82 560 251 2689 nand2_x0
xsubckt_578_xor2_x0 83 82 64 65 393 xor2_x0
xsubckt_590_nor2_x0 83 82 381 46 66 nor2_x0
xdiode_102 83 82 671 diode_w1
xfeed_1230 83 82 decap_w0
xsubckt_1019_nor2_x0 83 82 2387 0 34 nor2_x0
xsubckt_262_and2_x1 83 82 175 687 884 and2_x1
xsubckt_236_or21nand_x0 83 82 711 715 871 875 or21nand_x0
xsubckt_467_or21nand_x0 83 82 493 501 692 880 or21nand_x0
xsubckt_2065_and21nor_x0 83 82 1368 1376 1374 1369 and21nor_x0
xdiode_103 83 82 671 diode_w1
xfeed_1231 83 82 decap_w0
xsubckt_2_inv_x0 83 82 269 913 inv_x0
xsubckt_343_or21nand_x0 83 82 609 642 633 617 or21nand_x0
xsubckt_1523_and2_x1 83 82 1897 1947 811 and2_x1
xsubckt_1699_nand3_x0 83 82 1725 1798 804 805 nand3_x0
xsubckt_1874_nand2_x0 83 82 1555 1556 437 nand2_x0
xsubckt_1881_or3_x1 83 82 1548 1550 1551 866 or3_x1
xsubckt_1919_or21nand_x0 83 82 1511 1520 1541 829 or21nand_x0
xsubckt_2365_mux2_x1 83 82 841 1077 437 1075 mux2_x1
xdiode_100 83 82 671 diode_w1
xfeed_1232 83 82 tie
xsubckt_498_or21nand_x0 83 82 465 467 471 2702 or21nand_x0
xsubckt_2514_and2_x1 83 82 224 938 2719 and2_x1
xdiode_101 83 82 671 diode_w1
xfeed_1233 83 82 tie
xsubckt_2659_dff_x1 83 82 138 2777 35 dff_x1
xsubckt_1279_nand3_x0 83 82 2137 2269 818 863 nand3_x0
xsubckt_1029_nand2_x0 83 82 2378 13 36 nand2_x0
xsubckt_990_and21nor_x0 83 82 2415 2432 2430 2431 and21nor_x0
xsubckt_900_nexor2_x0 83 82 5 28 2501 nexor2_x0
xsubckt_350_mux2_x1 83 82 2691 603 884 186 mux2_x1
xsubckt_1849_and21nor_x0 83 82 1579 800 2282 1580 and21nor_x0
xsubckt_2094_nand3_x0 83 82 1340 673 67 250 nand3_x0
xsubckt_2155_nand3_x0 83 82 1280 1284 1299 27 nand3_x0
xsubckt_2542_and2_x1 83 82 226 924 2727 and2_x1
xsubckt_2543_mux2_x1 83 82 102 73 943 923 mux2_x1
xfeed_783 83 82 tie
xfeed_291 83 82 decap_w0
xsubckt_1248_or21nand_x0 83 82 2167 2250 2222 2223 or21nand_x0
xsubckt_1312_nand2_x0 83 82 2104 2105 2275 nand2_x0
xsubckt_1436_nand3_x0 83 82 1983 2269 35 863 nand3_x0
xsubckt_1588_and2_x1 83 82 1834 251 893 and2_x1
xsubckt_2000_and2_x1 83 82 1432 1433 683 and2_x1
xfeed_782 83 82 decap_w0
xfeed_290 83 82 decap_w0
xsubckt_880_nor2_x0 83 82 2520 2521 441 nor2_x0
xsubckt_495_nand2_x0 83 82 468 520 698 nand2_x0
xsubckt_1818_or21nand_x0 83 82 1609 1632 1640 1641 or21nand_x0
xsubckt_1825_and21nor_x0 83 82 1602 90 93 73 and21nor_x0
xfeed_781 83 82 decap_w0
xfeed_293 83 82 decap_w0
xsubckt_36_inv_x0 83 82 2694 879 inv_x0
xsubckt_638_or21nand_x0 83 82 336 64 76 77 or21nand_x0
xsubckt_1284_nand4_x0 83 82 2132 2135 2137 2138 647 nand4_x0
xsubckt_1757_nexor2_x0 83 82 1732 834 1668 nexor2_x0
xsubckt_2452_or21nand_x0 83 82 990 1022 1035 1039 or21nand_x0
xfeed_780 83 82 decap_w0
xfeed_292 83 82 decap_w0
xsubckt_2397_or2_x1 83 82 1044 1718 837 or2_x1
xfeed_1238 83 82 tie
xfeed_787 83 82 decap_w0
xfeed_295 83 82 tie
xsubckt_1176_nand2_x0 83 82 2238 2240 624 nand2_x0
xsubckt_962_nand2_x0 83 82 2442 34 35 nand2_x0
xsubckt_748_xor2_x0 83 82 52 75 2644 xor2_x0
xsubckt_207_nand2_x0 83 82 732 885 85 nand2_x0
xsubckt_1525_nand2_x0 83 82 1895 1896 2290 nand2_x0
xsubckt_1770_and21nor_x0 83 82 1655 1692 1703 1706 and21nor_x0
xsubckt_1833_nand2_x0 83 82 1594 1595 658 nand2_x0
xsubckt_2047_nand2_x0 83 82 1386 2268 69 nand2_x0
xfeed_1239 83 82 decap_w0
xfeed_786 83 82 tie
xfeed_294 83 82 decap_w0
xsubckt_1260_nor3_x0 83 82 2155 7 14 15 nor3_x0
xsubckt_818_nand3_x0 83 82 2578 2583 2590 2600 nand3_x0
xsubckt_550_nand2_x0 83 82 419 54 68 nand2_x0
xsubckt_1582_or21nand_x0 83 82 1839 1909 1918 1919 or21nand_x0
xdiode_108 83 82 446 diode_w1
xfeed_785 83 82 tie
xsubckt_458_and3_x1 83 82 501 520 675 707 and3_x1
xsubckt_1477_nand4_x0 83 82 1942 93 43 867 868 nand4_x0
xsubckt_1732_and21nor_x0 83 82 1692 1751 1757 1760 and21nor_x0
xsubckt_1884_or21nand_x0 83 82 1545 39 2277 1546 or21nand_x0
xdiode_109 83 82 446 diode_w1
xfeed_784 83 82 tie
xfeed_296 83 82 tie
xsubckt_2574_dff_x1 83 82 207 2774 59 dff_x1
xsubckt_874_or2_x1 83 82 2526 2528 2531 or2_x1
xsubckt_202_nand2_x0 83 82 736 751 260 nand2_x0
xsubckt_1469_nand2_x0 83 82 1950 2283 67 nand2_x0
xsubckt_1520_nand2_x0 83 82 1900 2282 811 nand2_x0
xsubckt_2227_nand3_x0 83 82 1210 673 849 250 nand3_x0
xsubckt_2493_and21nor_x0 83 82 951 981 984 986 and21nor_x0
xdiode_133 83 82 436 diode_w1
xfeed_1241 83 82 decap_w0
xfeed_798 83 82 decap_w0
xfeed_286 83 82 tie
xsubckt_1051_and21nor_x0 83 82 2357 436 2359 2358 and21nor_x0
xsubckt_817_or2_x1 83 82 2579 2580 2581 or2_x1
xsubckt_302_nand2_x0 83 82 649 864 248 nand2_x0
xsubckt_2291_and2_x1 83 82 1147 1150 24 and2_x1
xdiode_132 83 82 436 diode_w1
xfeed_1240 83 82 decap_w0
xfeed_799 83 82 decap_w0
xfeed_287 83 82 tie
xsubckt_1252_or21nand_x0 83 82 2163 55 54 47 or21nand_x0
xsubckt_244_nand2_x0 83 82 703 706 881 nand2_x0
xsubckt_542_or2_x1 83 82 427 71 54 or2_x1
xsubckt_631_nand2_x0 83 82 342 44 64 nand2_x0
xsubckt_1619_nexor2_x0 83 82 1855 838 1803 nexor2_x0
xdiode_131 83 82 436 diode_w1
xfeed_1243 83 82 decap_w0
xfeed_284 83 82 tie
xspare_feed_99 83 82 decap_w0
xsubckt_987_or2_x1 83 82 2418 1 35 or2_x1
xsubckt_869_or21nand_x0 83 82 2531 2549 2547 2548 or21nand_x0
xsubckt_1374_mux2_x1 83 82 867 859 798 2043 mux2_x1
xdiode_130 83 82 64 diode_w1
xfeed_1242 83 82 decap_w0
xfeed_285 83 82 tie
xspare_feed_98 83 82 tie
xsubckt_84_inv_x0 83 82 48 831 inv_x0
xsubckt_2007_nand3_x0 83 82 1425 646 68 249 nand3_x0
xsubckt_2062_or21nand_x0 83 82 1371 1377 1373 1372 or21nand_x0
xsubckt_2212_nexor2_x0 83 82 1226 1228 1224 nexor2_x0
xsubckt_2431_or21nand_x0 83 82 1011 1017 1015 1012 or21nand_x0
xdiode_137 83 82 91 diode_w1
xfeed_1245 83 82 decap_w0
xfeed_282 83 82 tie
xsubckt_1150_and21nor_x0 83 82 2263 39 2268 2264 and21nor_x0
xsubckt_808_or2_x1 83 82 2587 2588 2591 or2_x1
xsubckt_130_nand3_x0 83 82 786 791 908 913 nand3_x0
xsubckt_2128_nand2_x0 83 82 1306 1307 2285 nand2_x0
xdiode_136 83 82 91 diode_w1
xfeed_1244 83 82 decap_w0
xfeed_283 83 82 tie
xsubckt_934_nor2_x0 83 82 2469 2486 2505 nor2_x0
xsubckt_300_nand3_x0 83 82 650 651 694 110 nand3_x0
xdiode_135 83 82 436 diode_w1
xfeed_1247 83 82 decap_w0
xfeed_389 83 82 decap_w0
xfeed_280 83 82 tie
xsubckt_459_nand3_x0 83 82 500 520 675 707 nand3_x0
xsubckt_487_and3_x1 83 82 475 477 478 882 and3_x1
xsubckt_1620_and21nor_x0 83 82 1802 90 93 64 and21nor_x0
xdiode_134 83 82 436 diode_w1
xfeed_1246 83 82 decap_w0
xfeed_388 83 82 decap_w0
xfeed_281 83 82 tie
xsubckt_819_or21nand_x0 83 82 2577 2601 2591 2584 or21nand_x0
xsubckt_319_nexor2_x0 83 82 635 640 632 nexor2_x0
xsubckt_204_and21nor_x0 83 82 196 735 736 914 and21nor_x0
xsubckt_477_and21nor_x0 83 82 484 486 527 692 and21nor_x0
xsubckt_497_nand2_x0 83 82 466 468 675 nand2_x0
xsubckt_1773_or21nand_x0 83 82 170 1653 1657 1687 or21nand_x0
xfeed_1249 83 82 decap_w0
xfeed_790 83 82 decap_w0
xfeed_387 83 82 decap_w0
xspare_feed_93 83 82 decap_w0
xsubckt_451_nexor2_x0 83 82 508 2693 507 nexor2_x0
xsubckt_588_and21nor_x0 83 82 383 436 385 384 and21nor_x0
xsubckt_618_nand2_x0 83 82 355 371 373 nand2_x0
xfeed_1248 83 82 decap_w0
xfeed_386 83 82 decap_w0
xspare_feed_92 83 82 tie
xsubckt_274_and2_x1 83 82 195 676 677 and2_x1
xsubckt_223_nand3_x0 83 82 721 104 885 85 nand3_x0
xsubckt_454_nand3_x0 83 82 505 702 110 883 nand3_x0
xsubckt_627_and2_x1 83 82 346 347 436 and2_x1
xsubckt_1511_or21nand_x0 83 82 1909 1961 1963 1964 or21nand_x0
xsubckt_1970_nexor2_x0 83 82 1466 31 1461 nexor2_x0
xsubckt_2359_and2_x1 83 82 1081 251 888 and2_x1
xdiode_139 83 82 91 diode_w1
xfeed_792 83 82 decap_w0
xfeed_385 83 82 decap_w0
xspare_feed_91 83 82 tie
xsubckt_2630_dff_x1 83 82 188 2746 2701 dff_x1
xsubckt_973_nor2_x0 83 82 2431 2 36 nor2_x0
xsubckt_861_or21nand_x0 83 82 2538 2556 2555 2554 or21nand_x0
xsubckt_436_or21nand_x0 83 82 521 558 877 878 or21nand_x0
xsubckt_468_nand3_x0 83 82 492 504 527 2706 nand3_x0
xdiode_138 83 82 91 diode_w1
xfeed_793 83 82 decap_w0
xfeed_384 83 82 tie
xspare_feed_90 83 82 decap_w0
xsubckt_1236_or21nand_x0 83 82 2179 2183 2182 2180 or21nand_x0
xsubckt_504_and2_x1 83 82 189 460 463 and2_x1
xsubckt_2141_nand4_x0 83 82 1294 1295 1296 1297 647 nand4_x0
xsubckt_2479_and21nor_x0 83 82 964 965 974 251 and21nor_x0
xfeed_794 83 82 decap_w0
xfeed_383 83 82 tie
xspare_feed_97 83 82 tie
xsubckt_1202_xor2_x0 83 82 54 55 2212 xor2_x0
xsubckt_70_inv_x0 83 82 76 845 inv_x0
xsubckt_522_nand2_x0 83 82 446 558 247 nand2_x0
xsubckt_1837_or21nand_x0 83 82 1590 1635 1644 1645 or21nand_x0
xfeed_795 83 82 decap_w0
xfeed_382 83 82 tie
xspare_feed_96 83 82 decap_w0
xsubckt_2565_dff_x1 83 82 243 2754 2689 dff_x1
xsubckt_1230_nand4_x0 83 82 2185 2186 2187 2188 647 nand4_x0
xsubckt_332_and3_x1 83 82 620 622 624 2699 and3_x1
xsubckt_374_nand2_x0 83 82 185 580 602 nand2_x0
xsubckt_448_and21nor_x0 83 82 510 110 694 511 and21nor_x0
xsubckt_493_or21nand_x0 83 82 470 472 529 674 or21nand_x0
xsubckt_1453_nand3_x0 83 82 1966 1970 1985 67 nand3_x0
xsubckt_1667_or21nand_x0 83 82 1756 1815 1808 1812 or21nand_x0
xfeed_796 83 82 decap_w0
xfeed_381 83 82 tie
xfeed_288 83 82 tie
xspare_feed_95 83 82 tie
xsubckt_1610_or2_x1 83 82 1812 1820 64 or2_x1
xsubckt_2315_and21nor_x0 83 82 127 1124 1136 1168 and21nor_x0
xsubckt_2559_dff_x1 83 82 212 2772 84 dff_x1
xfeed_797 83 82 decap_w0
xfeed_380 83 82 tie
xfeed_289 83 82 tie
xspare_feed_94 83 82 tie
xsubckt_943_and21nor_x0 83 82 2460 2468 2467 2462 and21nor_x0
xsubckt_305_nor2_x0 83 82 646 250 248 nor2_x0
xsubckt_162_and2_x1 83 82 764 264 912 and2_x1
xsubckt_88_inv_x0 83 82 27 827 inv_x0
xsubckt_333_nand3_x0 83 82 619 622 624 2699 nand3_x0
xsubckt_500_nand3_x0 83 82 463 464 465 691 nand3_x0
xsubckt_1415_nexor2_x0 83 82 2047 44 2003 nexor2_x0
xsubckt_1449_or21nand_x0 83 82 1970 1976 1974 1971 or21nand_x0
xsubckt_1704_nand2_x0 83 82 1720 1721 658 nand2_x0
xsubckt_1755_nand4_x0 83 82 1670 1805 834 835 836 nand4_x0
xsubckt_1795_or21nand_x0 83 82 1631 1675 1677 1678 or21nand_x0
xsubckt_1820_nexor2_x0 83 82 1609 1610 1607 nexor2_x0
xsubckt_2058_nand3_x0 83 82 1375 686 854 865 nand3_x0
xsubckt_2233_nand4_x0 83 82 1204 841 250 864 248 nand4_x0
xfeed_985 83 82 decap_w0
xsubckt_446_and2_x1 83 82 512 520 879 and2_x1
xsubckt_1949_nand4_x0 83 82 1482 854 250 864 248 nand4_x0
xsubckt_2513_mux2_x1 83 82 101 26 943 938 mux2_x1
xfeed_1107 83 82 tie
xfeed_984 83 82 tie
xspare_buffer_3 83 82 88 2729 buf_x4
xsubckt_743_and3_x1 83 82 2649 558 72 247 and3_x1
xsubckt_524_nexor2_x0 83 82 68 67 444 nexor2_x0
xsubckt_1475_nexor2_x0 83 82 1997 813 1944 nexor2_x0
xsubckt_2127_nand2_x0 83 82 1307 2283 28 nand2_x0
xfeed_1104 83 82 tie
xfeed_987 83 82 decap_w0
xfeed_679 83 82 decap_w0
xspare_buffer_0 83 82 270 2782 buf_x4
xsubckt_755_xor2_x0 83 82 52 72 2637 xor2_x0
xsubckt_1729_or21nand_x0 83 82 1695 1756 1757 1761 or21nand_x0
xsubckt_1800_and21nor_x0 83 82 1626 802 2282 1627 and21nor_x0
xsubckt_2508_and21nor_x0 83 82 941 81 251 914 and21nor_x0
xfeed_986 83 82 decap_w0
xfeed_678 83 82 decap_w0
xsubckt_903_and21nor_x0 83 82 2498 5 435 442 and21nor_x0
xsubckt_398_or3_x1 83 82 557 250 249 248 or3_x1
xsubckt_1812_and21nor_x0 83 82 169 1615 1633 1652 and21nor_x0
xsubckt_2520_and2_x1 83 82 221 935 2721 and2_x1
xdiode_38 83 82 32 diode_w1
xfeed_1102 83 82 tie
xfeed_981 83 82 tie
xsubckt_1510_and21nor_x0 83 82 1910 1960 1962 1965 and21nor_x0
xsubckt_1760_nexor2_x0 83 82 1726 803 1665 nexor2_x0
xsubckt_2087_or21nand_x0 83 82 1346 1350 1349 1347 or21nand_x0
xdiode_39 83 82 74 diode_w1
xfeed_1103 83 82 tie
xfeed_980 83 82 tie
xspare_buffer_7 83 82 2729 2728 buf_x4
xsubckt_2639_dff_x1 83 82 160 2773 65 dff_x1
xsubckt_1241_and3_x1 83 82 2174 2177 2191 855 and3_x1
xsubckt_237_and21nor_x0 83 82 710 712 876 877 and21nor_x0
xsubckt_1440_and2_x1 83 82 1979 1980 624 and2_x1
xfeed_1100 83 82 tie
xfeed_983 83 82 tie
xspare_buffer_4 83 82 2782 2781 buf_x4
xsubckt_1208_xor2_x0 83 82 14 15 2206 xor2_x0
xsubckt_255_and2_x1 83 82 692 694 110 and2_x1
xsubckt_76_inv_x0 83 82 73 839 inv_x0
xsubckt_1480_nand2_x0 83 82 1939 1940 884 nand2_x0
xsubckt_2122_or21nand_x0 83 82 1312 1354 1361 1362 or21nand_x0
xfeed_1101 83 82 tie
xfeed_982 83 82 tie
xsubckt_1045_or21nand_x0 83 82 2363 2379 2376 2378 or21nand_x0
xsubckt_966_or2_x1 83 82 2438 2 25 or2_x1
xsubckt_841_and2_x1 83 82 2557 2558 2560 and2_x1
xsubckt_196_nand2_x0 83 82 740 751 262 nand2_x0
xsubckt_528_and4_x1 83 82 440 673 69 247 250 and4_x1
xsubckt_1289_nand2_x0 83 82 2127 2140 683 nand2_x0
xsubckt_1990_nand3_x0 83 82 1442 673 859 250 nand3_x0
xsubckt_2279_nand2_x0 83 82 1159 1161 437 nand2_x0
xdiode_34 83 82 249 diode_w1
xfeed_673 83 82 decap_w0
xsubckt_1190_and3_x1 83 82 2224 2225 2246 78 and3_x1
xsubckt_683_and21nor_x0 83 82 293 330 312 294 and21nor_x0
xsubckt_644_and2_x1 83 82 330 331 335 and2_x1
xsubckt_56_inv_x0 83 82 69 859 inv_x0
xsubckt_2116_nexor2_x0 83 82 1324 826 1318 nexor2_x0
xdiode_35 83 82 249 diode_w1
xfeed_672 83 82 tie
xsubckt_1261_or3_x1 83 82 2154 7 14 15 or3_x1
xsubckt_1137_or21nand_x0 83 82 2276 79 2277 2279 or21nand_x0
xsubckt_696_and2_x1 83 82 280 281 436 and2_x1
xsubckt_303_and3_x1 83 82 648 250 864 248 and3_x1
xsubckt_192_and21nor_x0 83 82 200 743 744 914 and21nor_x0
xsubckt_2286_nand2_x0 83 82 1152 1156 671 nand2_x0
xsubckt_2398_nand2_x0 83 82 1043 673 75 nand2_x0
xdiode_36 83 82 249 diode_w1
xfeed_671 83 82 decap_w0
xspare_buffer_8 83 82 2782 2768 buf_x4
xsubckt_227_nand2_x0 83 82 253 719 720 nand2_x0
xsubckt_87_inv_x0 83 82 29 828 inv_x0
xsubckt_573_or21nand_x0 83 82 397 442 404 398 or21nand_x0
xsubckt_1597_nand3_x0 83 82 1825 686 35 865 nand3_x0
xsubckt_2169_and2_x1 83 82 1266 1267 2285 and2_x1
xsubckt_2434_nand2_x0 83 82 1008 558 74 nand2_x0
xsubckt_2473_and2_x1 83 82 970 971 972 and2_x1
xdiode_37 83 82 32 diode_w1
xfeed_670 83 82 decap_w0
xsubckt_376_nand2_x0 83 82 578 673 2697 nand2_x0
xsubckt_2357_and2_x1 83 82 1082 1083 1087 and2_x1
xdiode_30 83 82 251 diode_w1
xfeed_989 83 82 decap_w0
xfeed_677 83 82 decap_w0
xsubckt_1113_nexor2_x0 83 82 8 32 2299 nexor2_x0
xsubckt_1320_nexor2_x0 83 82 2155 6 2096 nexor2_x0
xsubckt_1680_nand2_x0 83 82 1743 1744 1745 nand2_x0
xsubckt_1828_or21nand_x0 83 82 1599 2274 1603 1600 or21nand_x0
xdiode_31 83 82 249 diode_w1
xfeed_988 83 82 tie
xfeed_676 83 82 tie
xsubckt_2680_dff_x1 83 82 125 2735 14 dff_x1
xdiode_32 83 82 249 diode_w1
xfeed_1108 83 82 tie
xfeed_675 83 82 tie
xsubckt_230_nand2_x0 83 82 252 717 718 nand2_x0
xsubckt_151_and3_x1 83 82 772 773 80 81 and3_x1
xsubckt_461_nand2_x0 83 82 498 500 691 nand2_x0
xsubckt_1490_and2_x1 83 82 1930 1931 624 and2_x1
xdiode_33 83 82 249 diode_w1
xfeed_1109 83 82 decap_w0
xfeed_674 83 82 tie
xsubckt_949_xor2_x0 83 82 3 26 2454 xor2_x0
xsubckt_822_mux2_x1 83 82 72 2575 446 151 mux2_x1
xsubckt_1796_nexor2_x0 83 82 1632 1637 1630 nexor2_x0
xsubckt_2242_or21nand_x0 83 82 1195 1201 1199 1197 or21nand_x0
xsubckt_2441_and4_x1 83 82 1001 1008 1009 1010 34 and4_x1
xdiode_142 83 82 437 diode_w1
xsubckt_976_nexor2_x0 83 82 2429 2432 2428 nexor2_x0
xsubckt_27_inv_x0 83 82 19 888 inv_x0
xsubckt_342_or21nand_x0 83 82 610 635 640 641 or21nand_x0
xsubckt_534_and4_x1 83 82 434 646 78 247 249 and4_x1
xsubckt_1420_or21nand_x0 83 82 1998 2274 2002 1999 or21nand_x0
xsubckt_1474_nexor2_x0 83 82 1997 3 1945 nexor2_x0
xsubckt_1877_or21nand_x0 83 82 1552 1557 1555 1553 or21nand_x0
xsubckt_1972_nand2_x0 83 82 1459 1461 1491 nand2_x0
xsubckt_2308_and21nor_x0 83 82 1130 2282 1804 1131 and21nor_x0
xdiode_143 83 82 66 diode_w1
xsubckt_750_or21nand_x0 83 82 2642 52 436 441 or21nand_x0
xsubckt_605_nexor2_x0 83 82 45 68 367 nexor2_x0
xsubckt_616_and2_x1 83 82 356 357 363 and2_x1
xsubckt_2063_and2_x1 83 82 1370 1372 671 and2_x1
xdiode_140 83 82 437 diode_w1
xsubckt_2663_dff_x1 83 82 158 2735 55 dff_x1
xsubckt_2591_dff_x1 83 82 229 2757 106 dff_x1
xsubckt_1267_and2_x1 83 82 2148 2149 674 and2_x1
xsubckt_699_and2_x1 83 82 277 41 75 and2_x1
xsubckt_299_nexor2_x0 83 82 2708 2707 651 nexor2_x0
xsubckt_365_and2_x1 83 82 588 866 2698 and2_x1
xsubckt_596_nor3_x0 83 82 376 395 412 413 nor3_x0
xsubckt_2175_nand2_x0 83 82 1260 1261 1263 nand2_x0
xsubckt_2463_nand2_x0 83 82 980 982 983 nand2_x0
xdiode_141 83 82 437 diode_w1
xsubckt_386_nexor2_x0 83 82 570 575 568 nexor2_x0
xsubckt_2021_nand3_x0 83 82 1411 1420 1442 30 nand3_x0
xsubckt_2380_nexor2_x0 83 82 1062 1064 1060 nexor2_x0
xfeed_1018 83 82 decap_w0
xfeed_888 83 82 decap_w0
xsubckt_496_and21nor_x0 83 82 467 698 520 674 and21nor_x0
xsubckt_1998_nand2_x0 83 82 1434 1436 624 nand2_x0
xfeed_1019 83 82 decap_w0
xfeed_889 83 82 decap_w0
xsubckt_1199_or21nand_x0 83 82 2215 2218 2220 2251 or21nand_x0
xsubckt_239_nand2_x0 83 82 708 710 2695 nand2_x0
xsubckt_348_nexor2_x0 83 82 715 2699 604 nexor2_x0
xsubckt_1777_nand2_x0 83 82 1649 558 34 nand2_x0
xdiode_144 83 82 271 diode_w1
xfeed_378 83 82 decap_w0
xsubckt_845_xor2_x0 83 82 14 28 2553 xor2_x0
xsubckt_722_nand2_x0 83 82 2668 2669 442 nand2_x0
xsubckt_1848_and21nor_x0 83 82 1580 90 93 72 and21nor_x0
xsubckt_2059_and2_x1 83 82 1374 1375 437 and2_x1
xdiode_145 83 82 271 diode_w1
xfeed_379 83 82 decap_w0
xsubckt_1129_and2_x1 83 82 2284 93 90 and2_x1
xsubckt_1082_nexor2_x0 83 82 2329 2332 2328 nexor2_x0
xsubckt_132_or21nand_x0 83 82 785 269 790 905 or21nand_x0
xsubckt_157_and2_x1 83 82 767 62 2725 and2_x1
xsubckt_540_nexor2_x0 83 82 445 854 429 nexor2_x0
xsubckt_1380_nand2_x0 83 82 2037 2039 2286 nand2_x0
xsubckt_1973_nand2_x0 83 82 1458 1460 1490 nand2_x0
xsubckt_2156_and21nor_x0 83 82 1279 1284 1299 827 and21nor_x0
xsubckt_2394_and21nor_x0 83 82 139 1047 1059 1081 and21nor_x0
xsubckt_2510_nand2_x0 83 82 940 251 84 nand2_x0
xfeed_1014 83 82 decap_w0
xfeed_884 83 82 decap_w0
xfeed_376 83 82 tie
xfeed_127 83 82 tie
xsubckt_790_nand3_x0 83 82 2604 2606 2620 2625 nand3_x0
xsubckt_2555_nand2_x0 83 82 236 916 771 nand2_x0
xfeed_1015 83 82 decap_w0
xfeed_885 83 82 decap_w0
xfeed_377 83 82 decap_w0
xfeed_126 83 82 tie
xsubckt_2622_dff_x1 83 82 182 2748 2695 dff_x1
xsubckt_693_xor2_x0 83 82 41 64 283 xor2_x0
xsubckt_107_inv_x0 83 82 33 808 inv_x0
xsubckt_572_nand2_x0 83 82 398 399 442 nand2_x0
xsubckt_1344_or21nand_x0 83 82 2073 2082 2078 2076 or21nand_x0
xsubckt_2152_mux2_x1 83 82 854 1286 671 1283 mux2_x1
xsubckt_2161_or21nand_x0 83 82 1274 1317 1318 1322 or21nand_x0
xsubckt_2163_nand2_x0 83 82 1272 1273 675 nand2_x0
xfeed_1016 83 82 decap_w0
xfeed_886 83 82 decap_w0
xfeed_374 83 82 tie
xfeed_125 83 82 tie
xsubckt_941_nexor2_x0 83 82 35 36 2462 nexor2_x0
xsubckt_434_mux2_x1 83 82 2687 523 884 182 mux2_x1
xsubckt_2113_and3_x1 83 82 1321 1325 1340 28 and3_x1
xfeed_1017 83 82 decap_w0
xfeed_887 83 82 decap_w0
xfeed_375 83 82 tie
xfeed_124 83 82 decap_w0
xsubckt_2619_dff_x1 83 82 185 2752 2698 dff_x1
xsubckt_1180_and21nor_x0 83 82 2234 2241 2239 2235 and21nor_x0
xsubckt_745_or21nand_x0 83 82 2647 2663 2660 2662 or21nand_x0
xsubckt_675_nor2_x0 83 82 300 42 76 nor2_x0
xsubckt_225_nand3_x0 83 82 720 95 86 85 nand3_x0
xsubckt_112_inv_x0 83 82 11 803 inv_x0
xsubckt_1288_and2_x1 83 82 2128 2140 683 and2_x1
xsubckt_1809_and21nor_x0 83 82 1617 1624 1620 1618 and21nor_x0
xsubckt_2278_and2_x1 83 82 1160 1161 437 and2_x1
xsubckt_2408_and21nor_x0 83 82 1033 1067 1058 1066 and21nor_x0
xsubckt_2436_nand3_x0 83 82 1006 1008 1009 1010 nand3_x0
xfeed_1010 83 82 decap_w0
xfeed_880 83 82 decap_w0
xfeed_372 83 82 tie
xsubckt_888_nand3_x0 83 82 2512 2526 2527 447 nand3_x0
xsubckt_862_or2_x1 83 82 2537 7 27 or2_x1
xsubckt_1622_nand2_x0 83 82 1800 1801 2285 nand2_x0
xfeed_1011 83 82 decap_w0
xfeed_373 83 82 tie
xsubckt_1245_and21nor_x0 83 82 2170 2177 2191 71 and21nor_x0
xsubckt_660_or21nand_x0 83 82 314 322 321 315 or21nand_x0
xsubckt_159_and2_x1 83 82 766 265 912 and2_x1
xsubckt_1616_or21nand_x0 83 82 1806 1839 1860 1861 or21nand_x0
xfeed_1012 83 82 decap_w0
xfeed_882 83 82 tie
xfeed_121 83 82 tie
xsubckt_2634_dff_x1 83 82 165 2741 70 dff_x1
xsubckt_747_and2_x1 83 82 2645 52 75 and2_x1
xsubckt_1628_and21nor_x0 83 82 1794 91 1795 2289 and21nor_x0
xsubckt_2200_and2_x1 83 82 1236 1237 823 and2_x1
xsubckt_2266_nexor2_x0 83 82 1173 1187 1171 nexor2_x0
xfeed_1013 83 82 decap_w0
xfeed_883 83 82 decap_w0
xfeed_371 83 82 tie
xfeed_120 83 82 decap_w0
xsubckt_823_and2_x1 83 82 2574 826 27 and2_x1
xsubckt_672_and2_x1 83 82 303 304 436 and2_x1
xsubckt_62_inv_x0 83 82 47 853 inv_x0
xsubckt_143_and3_x1 83 82 241 778 779 792 and3_x1
xsubckt_1600_and2_x1 83 82 1822 1825 437 and2_x1
xfeed_1155 83 82 decap_w0
xfeed_934 83 82 decap_w0
xfeed_501 83 82 tie
xspare_feed_0 83 82 tie
xsubckt_2603_dff_x1 83 82 217 2779 94 dff_x1
xsubckt_904_or21nand_x0 83 82 2497 435 2499 2498 or21nand_x0
xsubckt_838_nand2_x0 83 82 2560 435 825 nand2_x0
xsubckt_419_and2_x1 83 82 536 537 539 and2_x1
xsubckt_481_nor2_x0 83 82 191 481 482 nor2_x0
xsubckt_1401_and2_x1 83 82 2017 2019 671 and2_x1
xsubckt_1918_and21nor_x0 83 82 1512 1519 1540 38 and21nor_x0
xsubckt_2322_or21nand_x0 83 82 1117 1123 1119 1118 or21nand_x0
xfeed_1154 83 82 tie
xfeed_935 83 82 decap_w0
xsubckt_1093_or2_x1 83 82 121 2318 2365 or2_x1
xsubckt_1079_or2_x1 83 82 2331 10 33 or2_x1
xsubckt_375_and2_x1 83 82 579 673 2697 and2_x1
xfeed_1157 83 82 decap_w0
xfeed_936 83 82 decap_w0
xfeed_608 83 82 decap_w0
xfeed_503 83 82 decap_w0
xspare_feed_2 83 82 tie
xsubckt_2601_dff_x1 83 82 219 2763 96 dff_x1
xsubckt_1167_and3_x1 83 82 2247 673 824 250 and3_x1
xsubckt_995_nand2_x0 83 82 2410 2442 2464 nand2_x0
xsubckt_695_nexor2_x0 83 82 282 283 281 nexor2_x0
xsubckt_2370_and2_x1 83 82 1070 1074 36 and2_x1
xsubckt_2482_and2_x1 83 82 962 1581 2282 and2_x1
xfeed_1156 83 82 decap_w0
xfeed_937 83 82 tie
xfeed_609 83 82 decap_w0
xfeed_502 83 82 decap_w0
xspare_feed_3 83 82 tie
xsubckt_1217_nand3_x0 83 82 2197 2252 2270 799 nand3_x0
xsubckt_885_nexor2_x0 83 82 2516 2519 2515 nexor2_x0
xsubckt_868_and21nor_x0 83 82 118 446 2532 2545 and21nor_x0
xsubckt_359_or2_x1 83 82 594 596 598 or2_x1
xsubckt_1391_nand4_x0 83 82 2027 2028 2029 2030 647 nand4_x0
xsubckt_1742_and3_x1 83 82 1683 1684 1685 1686 and3_x1
xsubckt_1944_nand4_x0 83 82 1487 64 250 249 248 nand4_x0
xsubckt_2017_or21nand_x0 83 82 1415 1421 1443 30 or21nand_x0
xsubckt_2195_nand3_x0 83 82 1241 646 64 249 nand3_x0
xsubckt_2422_or21nand_x0 83 82 1019 1020 674 884 or21nand_x0
xfeed_1151 83 82 tie
xfeed_930 83 82 tie
xfeed_505 83 82 tie
xspare_feed_4 83 82 tie
xsubckt_944_or21nand_x0 83 82 2459 2469 2466 2463 or21nand_x0
xsubckt_1852_nexor2_x0 83 82 1598 800 1576 nexor2_x0
xsubckt_1996_nand4_x0 83 82 1436 851 250 864 248 nand4_x0
xsubckt_2160_and21nor_x0 83 82 1275 1316 1319 1323 and21nor_x0
xsubckt_2258_nand4_x0 83 82 1179 93 840 867 91 nand4_x0
xsubckt_2292_nand2_x0 83 82 1146 1150 24 nand2_x0
xfeed_1150 83 82 decap_w0
xfeed_931 83 82 decap_w0
xfeed_504 83 82 tie
xspare_feed_5 83 82 tie
xsubckt_266_nand2_x0 83 82 683 686 865 nand2_x0
xsubckt_251_and21nor_x0 83 82 696 2695 710 697 and21nor_x0
xsubckt_187_nand2_x0 83 82 746 751 265 nand2_x0
xsubckt_60_inv_x0 83 82 71 855 inv_x0
xsubckt_617_mux2_x1 83 82 356 370 447 148 mux2_x1
xsubckt_2011_and21nor_x0 83 82 1421 1429 1427 1422 and21nor_x0
xsubckt_2026_nand2_x0 83 82 1406 1408 1409 nand2_x0
xfeed_1153 83 82 tie
xfeed_932 83 82 decap_w0
xfeed_507 83 82 decap_w0
xspare_feed_6 83 82 tie
xsubckt_2623_dff_x1 83 82 181 2748 2694 dff_x1
xsubckt_960_and21nor_x0 83 82 114 446 2444 2458 and21nor_x0
xsubckt_887_or21nand_x0 83 82 2513 435 2515 2514 or21nand_x0
xsubckt_291_and2_x1 83 82 659 271 2701 and2_x1
xsubckt_620_nexor2_x0 83 82 76 77 353 nexor2_x0
xsubckt_1441_nand3_x0 83 82 1978 626 37 248 nand3_x0
xsubckt_2110_and2_x1 83 82 1324 1325 1340 and2_x1
xsubckt_2274_mux2_x1 83 82 73 1166 647 1164 mux2_x1
xsubckt_2325_nand3_x0 83 82 1114 686 74 865 nand3_x0
xfeed_1152 83 82 tie
xfeed_933 83 82 decap_w0
xfeed_506 83 82 tie
xspare_feed_7 83 82 tie
xsubckt_1269_and21nor_x0 83 82 2146 2197 2217 2220 and21nor_x0
xsubckt_257_and3_x1 83 82 690 694 91 110 and3_x1
xsubckt_2145_and21nor_x0 83 82 1290 624 1293 1291 and21nor_x0
xsubckt_2215_or21nand_x0 83 82 1221 1271 1276 1280 or21nand_x0
xsubckt_2299_and21nor_x0 83 82 1139 1172 1186 1189 and21nor_x0
xsubckt_2411_mux2_x1 83 82 90 812 798 1030 mux2_x1
xfeed_602 83 82 decap_w0
xfeed_509 83 82 tie
xspare_feed_8 83 82 tie
xsubckt_1177_nand3_x0 83 82 2237 626 28 248 nand3_x0
xsubckt_816_or21nand_x0 83 82 2580 48 436 441 or21nand_x0
xsubckt_206_nand3_x0 83 82 733 101 86 85 nand3_x0
xsubckt_416_nand2_x0 83 82 539 540 541 nand2_x0
xsubckt_463_or21nand_x0 83 82 496 498 503 505 or21nand_x0
xsubckt_1507_nand2_x0 83 82 1913 1921 854 nand2_x0
xsubckt_1583_and21nor_x0 83 82 1838 1910 1917 1920 and21nor_x0
xsubckt_2046_nand3_x0 83 82 1387 2269 77 863 nand3_x0
xsubckt_2229_mux2_x1 83 82 851 249 248 1208 mux2_x1
xsubckt_2454_and21nor_x0 83 82 988 989 675 251 and21nor_x0
xfeed_603 83 82 decap_w0
xfeed_508 83 82 tie
xspare_feed_9 83 82 tie
xsubckt_42_inv_x0 83 82 2708 873 inv_x0
xsubckt_1429_and21nor_x0 83 82 1989 2055 2058 2062 and21nor_x0
xfeed_600 83 82 decap_w0
xsubckt_1228_nand2_x0 83 82 2187 2266 818 nand2_x0
xsubckt_1225_nand3_x0 83 82 2190 686 28 865 nand3_x0
xsubckt_1115_and2_x1 83 82 2297 2298 436 and2_x1
xsubckt_314_nexor2_x0 83 82 638 639 637 nexor2_x0
xsubckt_1931_nand3_x0 83 82 1499 93 856 867 nand3_x0
xfeed_601 83 82 decap_w0
xsubckt_866_nand2_x0 83 82 2533 2534 442 nand2_x0
xsubckt_301_and21nor_x0 83 82 194 650 652 251 and21nor_x0
xsubckt_4_inv_x0 83 82 267 911 inv_x0
xsubckt_2082_nand2_x0 83 82 1351 2283 29 nand2_x0
xfeed_1159 83 82 decap_w0
xfeed_938 83 82 tie
xfeed_606 83 82 tie
xsubckt_2562_dff_x1 83 82 246 2753 2692 dff_x1
xsubckt_16_inv_x0 83 82 2687 899 inv_x0
xsubckt_562_nor2_x0 83 82 408 70 47 nor2_x0
xsubckt_1423_nexor2_x0 83 82 2040 815 1995 nexor2_x0
xsubckt_1890_nand3_x0 83 82 1540 673 71 250 nand3_x0
xfeed_1158 83 82 decap_w0
xfeed_939 83 82 tie
xfeed_607 83 82 decap_w0
xsubckt_978_or21nand_x0 83 82 2426 2434 2433 2427 or21nand_x0
xsubckt_190_nand2_x0 83 82 744 751 264 nand2_x0
xsubckt_152_nand4_x0 83 82 771 773 80 912 81 nand4_x0
xsubckt_1422_nexor2_x0 83 82 2040 4 1996 nexor2_x0
xfeed_604 83 82 decap_w0
xsubckt_1276_nand3_x0 83 82 2140 626 823 248 nand3_x0
xsubckt_1001_nand3_x0 83 82 2404 2405 2409 2442 nand3_x0
xsubckt_256_nand2_x0 83 82 691 694 110 nand2_x0
xfeed_605 83 82 tie
xsubckt_1207_nor2_x0 83 82 2207 14 15 nor2_x0
xsubckt_1016_and21nor_x0 83 82 2390 807 435 442 and21nor_x0
xsubckt_26_inv_x0 83 82 21 889 inv_x0
xsubckt_1634_nand2_x0 83 82 1788 1789 659 nand2_x0
xsubckt_1823_or21nand_x0 83 82 1604 50 1670 49 or21nand_x0
xfeed_1142 83 82 tie
xfeed_941 83 82 tie
xfeed_637 83 82 decap_w0
xsubckt_1174_nand4_x0 83 82 2240 827 250 864 248 nand4_x0
xsubckt_993_or21nand_x0 83 82 2412 2420 2419 2413 or21nand_x0
xsubckt_889_nand2_x0 83 82 2511 2513 446 nand2_x0
xsubckt_117_inv_x0 83 82 93 798 inv_x0
xsubckt_1527_nand4_x0 83 82 1893 93 842 867 868 nand4_x0
xsubckt_1580_and2_x1 83 82 1841 1842 674 and2_x1
xsubckt_2045_nand4_x0 83 82 1388 76 250 249 248 nand4_x0
xsubckt_2101_and2_x1 83 82 1333 1334 683 and2_x1
xfeed_1143 83 82 tie
xfeed_940 83 82 tie
xfeed_636 83 82 decap_w0
xsubckt_1224_nand3_x0 83 82 2191 673 30 250 nand3_x0
xsubckt_1123_and2_x1 83 82 2290 93 867 and2_x1
xsubckt_783_and21nor_x0 83 82 2611 833 435 442 and21nor_x0
xsubckt_6_inv_x0 83 82 80 909 inv_x0
xsubckt_425_and2_x1 83 82 183 531 559 and2_x1
xsubckt_1681_and21nor_x0 83 82 1742 2275 1746 1743 and21nor_x0
xfeed_943 83 82 tie
xfeed_635 83 82 decap_w0
xsubckt_308_or21nand_x0 83 82 643 646 648 2700 or21nand_x0
xsubckt_137_and3_x1 83 82 243 782 783 792 and3_x1
xsubckt_1296_and2_x1 83 82 2120 2121 671 and2_x1
xsubckt_1784_and2_x1 83 82 1642 1647 74 and2_x1
xsubckt_1866_nand2_x0 83 82 1563 2268 79 nand2_x0
xsubckt_2092_and21nor_x0 83 82 132 1342 1355 251 and21nor_x0
xsubckt_2153_nand2_x0 83 82 1282 1284 1299 nand2_x0
xsubckt_2391_and21nor_x0 83 82 1049 1055 1053 1050 and21nor_x0
xsubckt_2416_or21nand_x0 83 82 1025 1031 1029 1026 or21nand_x0
xfeed_1141 83 82 tie
xfeed_942 83 82 tie
xfeed_634 83 82 decap_w0
xsubckt_264_nand2_x0 83 82 685 250 249 nand2_x0
xsubckt_185_nand2_x0 83 82 747 753 22 nand2_x0
xsubckt_183_and21nor_x0 83 82 203 749 752 914 and21nor_x0
xsubckt_1305_nexor2_x0 83 82 2118 70 2111 nexor2_x0
xsubckt_1412_or21nand_x0 83 82 2006 2050 2058 2059 or21nand_x0
xfeed_1209 83 82 decap_w0
xfeed_1146 83 82 decap_w0
xfeed_945 83 82 tie
xfeed_633 83 82 decap_w0
xsubckt_908_and21nor_x0 83 82 2493 2525 2523 2524 and21nor_x0
xsubckt_290_nand2_x0 83 82 660 661 675 nand2_x0
xsubckt_1819_and21nor_x0 83 82 1608 1631 1639 1642 and21nor_x0
xfeed_1208 83 82 decap_w0
xfeed_1147 83 82 decap_w0
xfeed_944 83 82 tie
xfeed_632 83 82 tie
xsubckt_1364_nand2_x0 83 82 2053 2054 675 nand2_x0
xsubckt_1421_and3_x1 83 82 1997 2097 815 817 and3_x1
xsubckt_1516_nexor2_x0 83 82 1906 1911 1904 nexor2_x0
xsubckt_1993_nand2_x0 83 82 1439 2268 70 nand2_x0
xsubckt_2085_nand3_x0 83 82 1348 93 848 867 nand3_x0
xfeed_1144 83 82 tie
xfeed_947 83 82 decap_w0
xfeed_631 83 82 decap_w0
xsubckt_1186_and2_x1 83 82 2228 2229 671 and2_x1
xsubckt_1141_and21nor_x0 83 82 2272 2276 2287 271 and21nor_x0
xsubckt_10_inv_x0 83 82 2690 905 inv_x0
xfeed_1145 83 82 decap_w0
xfeed_946 83 82 tie
xfeed_630 83 82 decap_w0
xsubckt_271_or21nand_x0 83 82 678 869 693 680 or21nand_x0
xsubckt_125_nand4_x0 83 82 790 80 912 2725 81 nand4_x0
xsubckt_352_and21nor_x0 83 82 601 625 865 875 and21nor_x0
xsubckt_622_or21nand_x0 83 82 351 369 366 368 or21nand_x0
xsubckt_632_nexor2_x0 83 82 44 64 341 nexor2_x0
xsubckt_1768_and21nor_x0 83 82 1657 659 1673 1658 and21nor_x0
xfeed_1205 83 82 decap_w0
xfeed_949 83 82 decap_w0
xsubckt_1062_xor2_x0 83 82 11 34 2347 xor2_x0
xfeed_1204 83 82 decap_w0
xfeed_948 83 82 decap_w0
xsubckt_2671_dff_x1 83 82 144 2756 41 dff_x1
xsubckt_2587_dff_x1 83 82 213 2780 85 dff_x1
xsubckt_2569_dff_x1 83 82 239 2754 2685 dff_x1
xsubckt_780_and2_x1 83 82 2614 50 73 and2_x1
xsubckt_691_nor2_x0 83 82 285 41 64 nor2_x0
xfeed_1207 83 82 decap_w0
xfeed_1148 83 82 tie
xsubckt_2599_dff_x1 83 82 221 2763 98 dff_x1
xsubckt_2573_dff_x1 83 82 208 2774 60 dff_x1
xsubckt_465_and21nor_x0 83 82 494 496 880 251 and21nor_x0
xsubckt_2208_nexor2_x0 83 82 1238 823 1228 nexor2_x0
xfeed_1206 83 82 decap_w0
xfeed_1149 83 82 decap_w0
xsubckt_677_xor2_x0 83 82 42 76 298 xor2_x0
xsubckt_1878_and21nor_x0 83 82 1551 1552 1566 797 and21nor_x0
xsubckt_2079_or21nand_x0 83 82 1354 1403 1416 1417 or21nand_x0
xsubckt_2106_nand3_x0 83 82 1328 646 854 249 nand3_x0
xsubckt_2221_and4_x1 83 82 1215 93 842 867 91 and4_x1
xfeed_1201 83 82 tie
xsubckt_1151_nand3_x0 83 82 2262 2263 2267 647 nand3_x0
xsubckt_1409_nexor2_x0 83 82 2015 68 2009 nexor2_x0
xsubckt_1644_nand2_x0 83 82 1779 1781 624 nand2_x0
xsubckt_1705_and21nor_x0 83 82 1719 1727 1722 1720 and21nor_x0
xsubckt_2534_and2_x1 83 82 230 928 2719 and2_x1
xfeed_1200 83 82 tie
xsubckt_1157_nand2_x0 83 82 2256 2259 683 nand2_x0
xsubckt_804_and3_x1 83 82 2591 2592 2599 2609 and3_x1
xsubckt_216_nand3_x0 83 82 726 98 86 85 nand3_x0
xsubckt_1388_nand4_x0 83 82 2030 35 250 249 248 nand4_x0
xsubckt_2378_and21nor_x0 83 82 1062 1085 1099 1102 and21nor_x0
xfeed_1203 83 82 decap_w0
xfeed_639 83 82 decap_w0
xsubckt_821_nand2_x0 83 82 2575 2576 2579 nand2_x0
xsubckt_2366_mux2_x1 83 82 75 1076 671 1074 mux2_x1
xfeed_1202 83 82 decap_w0
xfeed_638 83 82 decap_w0
xsubckt_2563_dff_x1 83 82 245 2753 2691 dff_x1
xsubckt_1243_and3_x1 83 82 2172 2177 2191 71 and3_x1
xsubckt_805_nand3_x0 83 82 2590 2592 2599 2609 nand3_x0
xsubckt_763_or21nand_x0 83 82 2630 2647 2645 2646 or21nand_x0
xsubckt_124_and4_x1 83 82 791 80 912 2725 81 and4_x1
xsubckt_529_nand4_x0 83 82 439 673 69 247 250 nand4_x0
xsubckt_1403_mux2_x1 83 82 27 2018 671 2015 mux2_x1
xsubckt_1965_and2_x1 83 82 1466 1467 1488 and2_x1
xsubckt_1975_and21nor_x0 83 82 1456 1549 1511 1514 and21nor_x0
xsubckt_2061_nand3_x0 83 82 1372 646 67 249 nand3_x0
xsubckt_2432_nand3_x0 83 82 1010 673 73 250 nand3_x0
xfeed_848 83 82 decap_w0
xspare_buffer_19 83 82 2729 2713 buf_x4
xsubckt_1060_nor2_x0 83 82 2349 11 34 nor2_x0
xsubckt_730_nexor2_x0 83 82 53 76 2661 nexor2_x0
xsubckt_38_inv_x0 83 82 2696 877 inv_x0
xsubckt_140_and3_x1 83 82 242 780 781 792 and3_x1
xsubckt_1354_mux2_x1 83 82 28 2068 671 2063 mux2_x1
xsubckt_1618_nexor2_x0 83 82 1855 40 1804 nexor2_x0
xsubckt_1891_nand2_x0 83 82 1539 2266 851 nand2_x0
xsubckt_2296_nand2_x0 83 82 1142 1150 818 nand2_x0
xfeed_849 83 82 decap_w0
xsubckt_2679_dff_x1 83 82 126 2735 15 dff_x1
xsubckt_2561_dff_x1 83 82 236 2772 268 dff_x1
xsubckt_1164_and21nor_x0 83 82 2249 2252 2270 79 and21nor_x0
xsubckt_928_nexor2_x0 83 82 4 24 2474 nexor2_x0
xsubckt_533_nand3_x0 83 82 435 646 247 249 nand3_x0
xsubckt_1444_nand3_x0 83 82 1975 686 818 865 nand3_x0
xsubckt_2091_or21nand_x0 83 82 1342 866 1352 1343 or21nand_x0
xfeed_338 83 82 tie
xfeed_213 83 82 decap_w0
xsubckt_890_or21nand_x0 83 82 117 2520 2511 2512 or21nand_x0
xsubckt_775_nand2_x0 83 82 2618 2619 2622 nand2_x0
xsubckt_466_and2_x1 83 82 193 494 495 and2_x1
xfeed_339 83 82 tie
xfeed_212 83 82 tie
xsubckt_2624_dff_x1 83 82 180 2748 2693 dff_x1
xsubckt_1244_nand3_x0 83 82 2171 2177 2191 71 nand3_x0
xsubckt_935_or2_x1 83 82 2468 2486 2505 or2_x1
xfeed_215 83 82 tie
xsubckt_2607_dff_x1 83 82 234 2743 247 dff_x1
xsubckt_221_nand2_x0 83 82 255 723 724 nand2_x0
xsubckt_1494_nand3_x0 83 82 1926 686 816 865 nand3_x0
xsubckt_1529_or21nand_x0 83 82 1891 2288 1894 1892 or21nand_x0
xsubckt_2304_or21nand_x0 83 82 1134 1184 1186 1190 or21nand_x0
xsubckt_2376_nexor2_x0 83 82 1074 814 1064 nexor2_x0
xfeed_214 83 82 tie
xsubckt_2662_dff_x1 83 82 135 2779 32 dff_x1
xsubckt_2590_dff_x1 83 82 230 2757 107 dff_x1
xsubckt_945_and21nor_x0 83 82 2458 2459 2461 446 and21nor_x0
xsubckt_847_and2_x1 83 82 2551 2552 442 and2_x1
xsubckt_656_and2_x1 83 82 318 43 77 and2_x1
xsubckt_1700_or21nand_x0 83 82 1724 13 1797 12 or21nand_x0
xsubckt_1945_nand3_x0 83 82 1486 2269 65 863 nand3_x0
xsubckt_2099_nand4_x0 83 82 1335 1336 1337 1338 647 nand4_x0
xsubckt_2154_and3_x1 83 82 1281 1284 1299 27 and3_x1
xsubckt_2254_nexor2_x0 83 82 1185 1187 1183 nexor2_x0
xsubckt_2404_nand2_x0 83 82 1037 1041 35 nand2_x0
xfeed_518 83 82 tie
xfeed_217 83 82 tie
xsubckt_643_xor2_x0 83 82 75 76 331 xor2_x0
xsubckt_585_nexor2_x0 83 82 46 69 386 nexor2_x0
xsubckt_2401_nor2_x0 83 82 1040 1041 812 nor2_x0
xsubckt_2460_nexor2_x0 83 82 987 808 983 nexor2_x0
xfeed_519 83 82 decap_w0
xfeed_216 83 82 tie
xsubckt_8_inv_x0 83 82 2691 907 inv_x0
xsubckt_341_and21nor_x0 83 82 611 634 639 642 and21nor_x0
xsubckt_1306_and21nor_x0 83 82 2110 2145 2169 2172 and21nor_x0
xsubckt_2347_nand4_x0 83 82 1092 93 805 867 868 nand4_x0
xfeed_840 83 82 decap_w0
xfeed_516 83 82 tie
xfeed_332 83 82 decap_w0
xfeed_219 83 82 tie
xspare_buffer_11 83 82 2729 2723 buf_x4
xsubckt_2647_dff_x1 83 82 142 2745 39 dff_x1
xsubckt_203_nand2_x0 83 82 735 753 16 nand2_x0
xsubckt_470_nand2_x0 83 82 490 491 2705 nand2_x0
xsubckt_564_xor2_x0 83 82 70 47 406 xor2_x0
xsubckt_1783_nand4_x0 83 82 1643 1649 1650 1651 74 nand4_x0
xsubckt_2164_and21nor_x0 83 82 1271 1312 1318 1321 and21nor_x0
xsubckt_2439_and2_x1 83 82 1003 1006 34 and2_x1
xfeed_841 83 82 decap_w0
xfeed_517 83 82 tie
xfeed_333 83 82 decap_w0
xfeed_218 83 82 tie
xsubckt_2617_dff_x1 83 82 187 2752 2700 dff_x1
xsubckt_1195_or21nand_x0 83 82 2219 2226 2247 78 or21nand_x0
xsubckt_512_or21nand_x0 83 82 453 271 247 250 or21nand_x0
xfeed_842 83 82 decap_w0
xfeed_514 83 82 tie
xfeed_330 83 82 tie
xsubckt_2564_dff_x1 83 82 244 2753 2690 dff_x1
xsubckt_1053_nor2_x0 83 82 2355 12 32 nor2_x0
xsubckt_195_and21nor_x0 83 82 199 741 742 914 and21nor_x0
xsubckt_123_and2_x1 83 82 792 793 2717 and2_x1
xsubckt_1379_nexor2_x0 83 82 2097 817 2038 nexor2_x0
xsubckt_1721_nand2_x0 83 82 1703 1708 76 nand2_x0
xfeed_843 83 82 decap_w0
xfeed_515 83 82 tie
xfeed_331 83 82 decap_w0
xspare_buffer_12 83 82 2782 2755 buf_x4
xsubckt_2552_or21nand_x0 83 82 917 84 909 773 or21nand_x0
xfeed_844 83 82 tie
xfeed_512 83 82 tie
xfeed_336 83 82 decap_w0
xspare_buffer_15 83 82 2729 2718 buf_x4
xsubckt_762_xor2_x0 83 82 51 74 2631 xor2_x0
xsubckt_2133_or21nand_x0 83 82 1301 1302 1304 884 or21nand_x0
xsubckt_2539_mux2_x1 83 82 104 75 943 925 mux2_x1
xfeed_845 83 82 decap_w0
xfeed_513 83 82 decap_w0
xfeed_337 83 82 decap_w0
xsubckt_798_or21nand_x0 83 82 2597 2616 2614 2615 or21nand_x0
xsubckt_1318_and2_x1 83 82 2098 2099 866 and2_x1
xsubckt_1609_nor2_x0 83 82 1813 1820 64 nor2_x0
xfeed_846 83 82 decap_w0
xfeed_510 83 82 tie
xfeed_334 83 82 decap_w0
xsubckt_766_or21nand_x0 83 82 2627 435 2629 2628 or21nand_x0
xfeed_847 83 82 decap_w0
xfeed_511 83 82 decap_w0
xfeed_335 83 82 decap_w0
xspare_buffer_16 83 82 2782 2742 buf_x4
xsubckt_925_and21nor_x0 83 82 2477 2496 2493 2495 and21nor_x0
xsubckt_736_xor2_x0 83 82 53 73 2655 xor2_x0
xsubckt_116_inv_x0 83 82 79 799 inv_x0
xsubckt_445_nand3_x0 83 82 513 514 694 110 nand3_x0
xsubckt_2457_nor2_x0 83 82 986 987 808 nor2_x0
xfeed_1191 83 82 decap_w0
xfeed_729 83 82 decap_w0
xsubckt_555_mux2_x1 83 82 415 429 447 157 mux2_x1
xsubckt_1682_nand4_x0 83 82 1741 93 836 867 868 nand4_x0
xsubckt_1724_and2_x1 83 82 1700 1708 845 and2_x1
xfeed_1190 83 82 decap_w0
xfeed_728 83 82 decap_w0
xfeed_70 83 82 tie
xsubckt_2684_dff_x1 83 82 115 2732 4 dff_x1
xsubckt_1026_nand3_x0 83 82 2381 2382 558 247 nand3_x0
xsubckt_160_and2_x1 83 82 765 61 2725 and2_x1
xsubckt_1568_and21nor_x0 83 82 1853 90 93 65 and21nor_x0
xsubckt_1591_and3_x1 83 82 1831 1832 1833 647 and3_x1
xsubckt_1593_nand2_x0 83 82 1829 1830 624 nand2_x0
xsubckt_1968_and3_x1 83 82 1463 1467 1488 31 and3_x1
xfeed_1193 83 82 decap_w0
xfeed_73 83 82 tie
xsubckt_1101_or21nand_x0 83 82 2310 435 2312 2311 or21nand_x0
xsubckt_923_and2_x1 83 82 2479 2480 436 and2_x1
xsubckt_724_mux2_x1 83 82 2667 2681 447 143 mux2_x1
xsubckt_1586_and2_x1 83 82 1835 1836 1840 and2_x1
xsubckt_1637_and21nor_x0 83 82 159 1786 1788 1834 and21nor_x0
xfeed_1192 83 82 decap_w0
xfeed_72 83 82 tie
xsubckt_752_and21nor_x0 83 82 2640 2654 2655 2656 and21nor_x0
xsubckt_741_nor2_x0 83 82 2650 2651 2657 nor2_x0
xsubckt_122_nand3_x0 83 82 793 794 80 81 nand3_x0
xsubckt_1283_and21nor_x0 83 82 2133 2134 2137 648 and21nor_x0
xsubckt_1698_and3_x1 83 82 1726 1798 804 805 and3_x1
xsubckt_2142_and2_x1 83 82 1293 1294 1298 and2_x1
xfeed_1195 83 82 decap_w0
xfeed_75 83 82 decap_w0
xspare_feed_48 83 82 tie
xsubckt_1165_or3_x1 83 82 2248 2249 2251 866 or3_x1
xsubckt_1136_and21nor_x0 83 82 2277 868 867 798 and21nor_x0
xsubckt_801_or21nand_x0 83 82 2594 435 2596 2595 or21nand_x0
xsubckt_104_inv_x0 83 82 2 811 inv_x0
xsubckt_1334_nand2_x0 83 82 2083 2268 29 nand2_x0
xsubckt_1558_nand2_x0 83 82 1863 1865 65 nand2_x0
xsubckt_1886_nand2_x0 83 82 1543 1544 1547 nand2_x0
xsubckt_1908_and2_x1 83 82 1522 1523 671 and2_x1
xsubckt_2196_and2_x1 83 82 1240 1241 671 and2_x1
xsubckt_2375_nand2_x0 83 82 1065 1074 814 nand2_x0
xfeed_1194 83 82 decap_w0
xfeed_74 83 82 tie
xspare_feed_49 83 82 tie
xsubckt_1043_and3_x1 83 82 2365 558 32 247 and3_x1
xsubckt_854_and2_x1 83 82 2545 2546 447 and2_x1
xsubckt_285_nexor2_x0 83 82 670 2707 665 nexor2_x0
xsubckt_2166_nexor2_x0 83 82 1271 1276 1269 nexor2_x0
xfeed_1197 83 82 decap_w0
xfeed_77 83 82 decap_w0
xsubckt_827_nand4_x0 83 82 2570 673 29 247 250 nand4_x0
xsubckt_120_inv_x0 83 82 89 795 inv_x0
xsubckt_520_and21nor_x0 83 82 177 682 454 448 and21nor_x0
xsubckt_1655_and3_x1 83 82 1768 673 814 250 and3_x1
xfeed_1196 83 82 decap_w0
xfeed_76 83 82 decap_w0
xsubckt_2673_dff_x1 83 82 156 2757 53 dff_x1
xsubckt_2585_dff_x1 83 82 196 2778 16 dff_x1
xsubckt_830_nexor2_x0 83 82 2568 15 2567 nexor2_x0
xsubckt_688_nor2_x0 83 82 288 289 293 nor2_x0
xsubckt_587_or21nand_x0 83 82 384 850 436 441 or21nand_x0
xsubckt_2488_or21nand_x0 83 82 956 962 960 957 or21nand_x0
xfeed_1199 83 82 tie
xfeed_721 83 82 decap_w0
xfeed_79 83 82 decap_w0
xspare_feed_44 83 82 tie
xsubckt_713_xor2_x0 83 82 40 77 2677 xor2_x0
xsubckt_575_or21nand_x0 83 82 396 412 413 414 or21nand_x0
xsubckt_1851_and21nor_x0 83 82 1577 2275 1582 1578 and21nor_x0
xfeed_1198 83 82 decap_w0
xfeed_720 83 82 tie
xfeed_78 83 82 decap_w0
xspare_feed_45 83 82 tie
xsubckt_899_nand2_x0 83 82 2502 5 28 nand2_x0
xsubckt_893_nor2_x0 83 82 2508 2509 2510 nor2_x0
xsubckt_877_nand2_x0 83 82 2523 6 26 nand2_x0
xsubckt_1365_and2_x1 83 82 2052 2117 70 and2_x1
xfeed_723 83 82 decap_w0
xspare_feed_46 83 82 tie
xsubckt_209_nand2_x0 83 82 259 731 733 nand2_x0
xsubckt_43_inv_x0 83 82 2700 872 inv_x0
xsubckt_499_nand3_x0 83 82 464 466 470 870 nand3_x0
xsubckt_2287_or21nand_x0 83 82 1151 1158 1152 1154 or21nand_x0
xsubckt_2306_nand2_x0 83 82 1132 1796 2275 nand2_x0
xsubckt_2518_and2_x1 83 82 222 936 2721 and2_x1
xfeed_722 83 82 decap_w0
xspare_feed_47 83 82 tie
xsubckt_871_nand2_x0 83 82 2529 24 25 nand2_x0
xsubckt_799_nexor2_x0 83 82 2597 2599 2596 nexor2_x0
xsubckt_715_and2_x1 83 82 2675 2676 436 and2_x1
xsubckt_682_nand2_x0 83 82 294 311 332 nand2_x0
xsubckt_48_inv_x0 83 82 90 867 inv_x0
xsubckt_1988_and21nor_x0 83 82 134 1444 1457 251 and21nor_x0
xfeed_725 83 82 decap_w0
xspare_feed_40 83 82 tie
xsubckt_1257_nand2_x0 83 82 2158 2283 71 nand2_x0
xsubckt_23_inv_x0 83 82 60 892 inv_x0
xsubckt_1433_and3_x1 83 82 163 1986 1990 884 and3_x1
xsubckt_2447_or21nand_x0 83 82 995 1034 1036 1037 or21nand_x0
xfeed_724 83 82 decap_w0
xspare_feed_41 83 82 tie
xsubckt_708_nexor2_x0 83 82 72 73 2682 nexor2_x0
xsubckt_46_inv_x0 83 82 110 869 inv_x0
xsubckt_567_or21nand_x0 83 82 403 421 420 419 or21nand_x0
xsubckt_1353_or21nand_x0 83 82 2064 2074 2070 2067 or21nand_x0
xsubckt_2352_or21nand_x0 83 82 1087 658 1096 1088 or21nand_x0
xfeed_727 83 82 decap_w0
xspare_feed_42 83 82 tie
xsubckt_1094_and2_x1 83 82 2317 9 32 and2_x1
xsubckt_839_nexor2_x0 83 82 2561 2564 2559 nexor2_x0
xsubckt_807_nand2_x0 83 82 2588 2589 442 nand2_x0
xsubckt_54_inv_x0 83 82 55 861 inv_x0
xsubckt_336_nexor2_x0 83 82 621 2699 616 nexor2_x0
xsubckt_472_and3_x1 83 82 192 489 490 884 and3_x1
xsubckt_1483_and2_x1 83 82 1937 251 894 and2_x1
xsubckt_1826_and21nor_x0 83 82 1601 801 2282 1602 and21nor_x0
xfeed_726 83 82 decap_w0
xspare_feed_43 83 82 tie
xsubckt_922_nexor2_x0 83 82 2481 2484 2480 nexor2_x0
xsubckt_776_nand2_x0 83 82 2617 2618 2627 nand2_x0
xsubckt_701_and21nor_x0 83 82 275 301 299 300 and21nor_x0
xsubckt_250_or2_x1 83 82 697 699 705 or2_x1
xsubckt_170_mux2_x1 83 82 759 760 772 206 mux2_x1
xsubckt_557_nexor2_x0 83 82 65 66 413 nexor2_x0
xsubckt_1951_nand2_x0 83 82 1480 1482 624 nand2_x0
xsubckt_2217_nand2_x0 83 82 1219 1902 2282 nand2_x0
xsubckt_2549_and21nor_x0 83 82 214 919 921 914 and21nor_x0
xfeed_1087 83 82 tie
xfeed_817 83 82 tie
xfeed_170 83 82 tie
xsubckt_1024_and21nor_x0 83 82 111 2383 2389 2396 and21nor_x0
xsubckt_815_and2_x1 83 82 2581 2582 436 and2_x1
xsubckt_89_inv_x0 83 82 28 826 inv_x0
xsubckt_356_nexor2_x0 83 82 623 875 597 nexor2_x0
xsubckt_460_and2_x1 83 82 499 500 691 and2_x1
xsubckt_1340_nand3_x0 83 82 2077 626 25 248 nand3_x0
xfeed_1086 83 82 decap_w0
xfeed_816 83 82 tie
xfeed_171 83 82 tie
xsubckt_295_nor2_x0 83 82 655 271 2707 nor2_x0
xsubckt_289_nexor2_x0 83 82 663 665 661 nexor2_x0
xsubckt_110_inv_x0 83 82 13 805 inv_x0
xsubckt_142_nand3_x0 83 82 778 791 900 913 nand3_x0
xsubckt_1350_and2_x1 83 82 2067 2069 671 and2_x1
xsubckt_2023_nexor2_x0 83 82 1419 821 1409 nexor2_x0
xsubckt_2351_and2_x1 83 82 1088 1089 674 and2_x1
xsubckt_2486_nand4_x0 83 82 958 93 831 867 91 nand4_x0
xfeed_1085 83 82 decap_w0
xfeed_815 83 82 decap_w0
xfeed_198 83 82 tie
xsubckt_248_or2_x1 83 82 699 2704 2703 or2_x1
xsubckt_58_inv_x0 83 82 68 857 inv_x0
xsubckt_435_and2_x1 83 82 522 527 2695 and2_x1
xsubckt_491_nand3_x0 83 82 472 474 487 2706 nand3_x0
xsubckt_2086_and2_x1 83 82 1347 1348 2287 and2_x1
xfeed_1084 83 82 decap_w0
xfeed_814 83 82 decap_w0
xfeed_447 83 82 tie
xfeed_199 83 82 tie
xfeed_173 83 82 tie
xsubckt_2602_dff_x1 83 82 218 2780 95 dff_x1
xsubckt_1193_or21nand_x0 83 82 2221 2226 2247 860 or21nand_x0
xsubckt_1171_and21nor_x0 83 82 2243 38 2268 2244 and21nor_x0
xsubckt_1021_xor2_x0 83 82 0 34 2385 xor2_x0
xsubckt_306_or2_x1 83 82 645 250 248 or2_x1
xsubckt_1834_and21nor_x0 83 82 1593 1599 1596 1594 and21nor_x0
xfeed_1083 83 82 decap_w0
xfeed_813 83 82 decap_w0
xfeed_549 83 82 tie
xfeed_174 83 82 tie
xsubckt_1146_nand3_x0 83 82 2267 2269 27 863 nand3_x0
xsubckt_1121_nand2_x0 83 82 2291 2292 2295 nand2_x0
xsubckt_1894_and4_x1 83 82 1536 1537 1538 1539 647 and4_x1
xsubckt_2389_and4_x1 83 82 1051 93 835 867 91 and4_x1
xsubckt_2511_or21nand_x0 83 82 939 869 693 940 or21nand_x0
xfeed_1082 83 82 decap_w0
xfeed_812 83 82 decap_w0
xfeed_548 83 82 decap_w0
xfeed_175 83 82 tie
xsubckt_895_xor2_x0 83 82 37 24 2506 xor2_x0
xsubckt_161_mux2_x1 83 82 765 766 772 209 mux2_x1
xsubckt_1295_nand3_x0 83 82 2121 646 826 249 nand3_x0
xfeed_1081 83 82 tie
xfeed_811 83 82 decap_w0
xfeed_442 83 82 tie
xfeed_176 83 82 tie
xsubckt_975_xor2_x0 83 82 2 36 2429 xor2_x0
xsubckt_785_or2_x1 83 82 2609 50 72 or2_x1
xsubckt_25_inv_x0 83 82 23 890 inv_x0
xsubckt_324_mux2_x1 83 82 628 629 691 627 mux2_x1
xsubckt_582_or21nand_x0 83 82 389 409 408 407 or21nand_x0
xsubckt_1685_nexor2_x0 83 82 1798 13 1738 nexor2_x0
xsubckt_1689_and2_x1 83 82 1734 1735 884 and2_x1
xsubckt_2157_nand2_x0 83 82 1278 1282 27 nand2_x0
xsubckt_2171_or21nand_x0 83 82 1264 868 844 2290 or21nand_x0
xsubckt_2395_nand2_x0 83 82 1046 251 18 nand2_x0
xfeed_1080 83 82 tie
xfeed_177 83 82 tie
xsubckt_101_inv_x0 83 82 36 814 inv_x0
xfeed_192 83 82 tie
xfeed_178 83 82 tie
xsubckt_2690_dff_x1 83 82 123 2758 12 dff_x1
xsubckt_968_xor2_x0 83 82 2 25 2436 xor2_x0
xsubckt_835_or2_x1 83 82 2563 31 14 or2_x1
xsubckt_786_nand2_x0 83 82 2608 50 72 nand2_x0
xsubckt_1396_and21nor_x0 83 82 2022 2027 2025 2023 and21nor_x0
xsubckt_1402_or21nand_x0 83 82 2016 2022 2020 2017 or21nand_x0
xfeed_544 83 82 tie
xfeed_179 83 82 tie
xsubckt_1179_nand2_x0 83 82 2235 2237 683 nand2_x0
xsubckt_1285_nand4_x0 83 82 2131 25 250 864 248 nand4_x0
xsubckt_1357_and3_x1 83 82 2060 2064 2086 69 and3_x1
xsubckt_1387_nand3_x0 83 82 2031 673 827 250 nand3_x0
xsubckt_1652_and21nor_x0 83 82 1771 683 1776 1772 and21nor_x0
xsubckt_1974_nand3_x0 83 82 1457 1458 1459 675 nand3_x0
xfeed_547 83 82 tie
xfeed_190 83 82 tie
xsubckt_552_nexor2_x0 83 82 418 422 417 nexor2_x0
xsubckt_599_nand2_x0 83 82 373 77 64 nand2_x0
xsubckt_1473_nand4_x0 83 82 1946 2097 813 815 817 nand4_x0
xsubckt_1893_nand2_x0 83 82 1537 2268 860 nand2_x0
xsubckt_2243_or21nand_x0 83 82 1194 1201 1199 1196 or21nand_x0
xsubckt_2294_nand2_x0 83 82 1144 1151 24 nand2_x0
xsubckt_2362_mux2_x1 83 82 73 1079 683 1078 mux2_x1
xfeed_546 83 82 decap_w0
xsubckt_1070_and21nor_x0 83 82 2339 2356 2354 2355 and21nor_x0
xsubckt_863_and2_x1 83 82 2536 7 27 and2_x1
xsubckt_2072_nexor2_x0 83 82 1366 828 1361 nexor2_x0
xsubckt_2211_or21nand_x0 83 82 1225 1275 1277 1278 or21nand_x0
xfeed_541 83 82 decap_w0
xfeed_448 83 82 tie
xsubckt_179_nand2_x0 83 82 752 753 23 nand2_x0
xsubckt_1314_mux2_x1 83 82 70 90 93 2102 mux2_x1
xsubckt_1439_nand4_x0 83 82 1980 814 250 864 248 nand4_x0
xsubckt_1811_and21nor_x0 83 82 1615 659 1630 1616 and21nor_x0
xfeed_540 83 82 decap_w0
xfeed_449 83 82 tie
xfeed_197 83 82 tie
xsubckt_1008_nand3_x0 83 82 2398 2400 2402 2407 nand3_x0
xsubckt_645_nexor2_x0 83 82 331 335 329 nexor2_x0
xsubckt_403_nexor2_x0 83 82 558 877 552 nexor2_x0
xsubckt_1498_or21nand_x0 83 82 1922 1927 1925 1923 or21nand_x0
xfeed_1089 83 82 tie
xfeed_819 83 82 tie
xfeed_543 83 82 tie
xfeed_194 83 82 tie
xsubckt_1012_or2_x1 83 82 2394 0 37 or2_x1
xsubckt_418_and21nor_x0 83 82 537 549 546 538 and21nor_x0
xsubckt_1595_and2_x1 83 82 1827 1828 683 and2_x1
xsubckt_1664_nand2_x0 83 82 1759 1764 77 nand2_x0
xsubckt_1853_and21nor_x0 83 82 1575 91 1576 2289 and21nor_x0
xsubckt_2158_nexor2_x0 83 82 1283 827 1277 nexor2_x0
xsubckt_2330_and2_x1 83 82 1109 1112 671 and2_x1
xsubckt_2533_mux2_x1 83 82 107 64 943 928 mux2_x1
xfeed_1088 83 82 tie
xfeed_818 83 82 tie
xfeed_542 83 82 tie
xsubckt_1154_nand3_x0 83 82 2259 626 29 248 nand3_x0
xsubckt_1460_nexor2_x0 83 82 1961 1963 1959 nexor2_x0
xfeed_1094 83 82 tie
xfeed_804 83 82 tie
xfeed_431 83 82 tie
xspare_buffer_55 83 82 2718 2717 buf_x4
xsubckt_1191_nand3_x0 83 82 2223 2225 2246 78 nand3_x0
xsubckt_971_or21nand_x0 83 82 2433 2 436 441 or21nand_x0
xsubckt_281_mux2_x1 83 82 249 673 250 669 mux2_x1
xsubckt_412_and21nor_x0 83 82 543 575 569 545 and21nor_x0
xsubckt_1603_and2_x1 83 82 1819 1820 849 and2_x1
xsubckt_1806_or21nand_x0 83 82 1620 868 1622 2290 or21nand_x0
xsubckt_1859_and21nor_x0 83 82 1569 1589 1610 1612 and21nor_x0
xsubckt_2360_mux2_x1 83 82 837 845 865 1080 mux2_x1
xsubckt_2407_or21nand_x0 83 82 1034 1068 1057 1065 or21nand_x0
xsubckt_2496_mux2_x1 83 82 16 949 884 135 mux2_x1
xfeed_1095 83 82 decap_w0
xfeed_805 83 82 decap_w0
xfeed_430 83 82 tie
xspare_buffer_54 83 82 2755 2752 buf_x4
xsubckt_902_nexor2_x0 83 82 2500 2501 2499 nexor2_x0
xsubckt_840_and21nor_x0 83 82 2558 2559 436 442 and21nor_x0
xsubckt_64_inv_x0 83 82 65 851 inv_x0
xsubckt_1502_and21nor_x0 83 82 1918 1922 1936 854 and21nor_x0
xsubckt_1858_and21nor_x0 83 82 1570 659 1583 1571 and21nor_x0
xsubckt_1935_nand2_x0 83 82 1495 1496 1497 nand2_x0
xsubckt_2248_and3_x1 83 82 1189 1194 1210 25 and3_x1
xfeed_1096 83 82 decap_w0
xfeed_806 83 82 tie
xfeed_558 83 82 decap_w0
xfeed_433 83 82 decap_w0
xspare_buffer_57 83 82 2755 2750 buf_x4
xsubckt_2689_dff_x1 83 82 124 2761 13 dff_x1
xsubckt_282_and2_x1 83 82 668 669 2707 and2_x1
xsubckt_268_and2_x1 83 82 681 682 271 and2_x1
xsubckt_2030_nand2_x0 83 82 1402 1404 1410 nand2_x0
xfeed_1097 83 82 decap_w0
xfeed_807 83 82 tie
xfeed_559 83 82 tie
xfeed_432 83 82 decap_w0
xspare_buffer_56 83 82 2755 2751 buf_x4
xsubckt_1063_or21nand_x0 83 82 2346 2363 2361 2362 or21nand_x0
xsubckt_2130_and21nor_x0 83 82 1304 1305 1308 1309 and21nor_x0
xfeed_1090 83 82 decap_w0
xfeed_909 83 82 tie
xfeed_800 83 82 tie
xfeed_435 83 82 decap_w0
xspare_buffer_51 83 82 2723 2719 buf_x4
xsubckt_1239_and21nor_x0 83 82 2176 2177 2191 855 and21nor_x0
xsubckt_1049_nexor2_x0 83 82 2360 2363 2359 nexor2_x0
xsubckt_742_nor2_x0 83 82 156 2650 2664 nor2_x0
xsubckt_354_nand3_x0 83 82 599 625 865 2698 nand3_x0
xsubckt_569_and2_x1 83 82 401 47 67 and2_x1
xsubckt_2223_and21nor_x0 83 82 1213 1219 1217 1214 and21nor_x0
xfeed_1091 83 82 decap_w0
xfeed_908 83 82 decap_w0
xfeed_434 83 82 decap_w0
xspare_buffer_50 83 82 2768 2756 buf_x4
xsubckt_800_and21nor_x0 83 82 2595 832 435 442 and21nor_x0
xsubckt_263_and2_x1 83 82 686 250 249 and2_x1
xsubckt_1526_nand2_x0 83 82 1894 1895 1898 nand2_x0
xsubckt_2118_or21nand_x0 83 82 1316 1359 1360 1364 or21nand_x0
xsubckt_2368_and2_x1 83 82 1072 1073 814 and2_x1
xfeed_1188 83 82 decap_w0
xfeed_1092 83 82 decap_w0
xfeed_802 83 82 decap_w0
xfeed_437 83 82 tie
xspare_buffer_53 83 82 2755 2753 buf_x4
xsubckt_1084_or21nand_x0 83 82 2326 435 2328 2327 or21nand_x0
xsubckt_1299_or21nand_x0 83 82 2117 2119 2123 2571 or21nand_x0
xsubckt_1596_or21nand_x0 83 82 1826 1831 1829 1827 or21nand_x0
xsubckt_1870_nand3_x0 83 82 1559 626 69 248 nand3_x0
xsubckt_2333_or21nand_x0 83 82 1106 1115 1113 1109 or21nand_x0
xfeed_1189 83 82 decap_w0
xfeed_1093 83 82 tie
xfeed_803 83 82 decap_w0
xfeed_436 83 82 decap_w0
xfeed_69 83 82 tie
xspare_buffer_52 83 82 2755 2754 buf_x4
xsubckt_1143_nand3_x0 83 82 2270 673 829 250 nand3_x0
xsubckt_240_nor2_x0 83 82 707 2694 2693 nor2_x0
xsubckt_210_nand3_x0 83 82 730 100 86 85 nand3_x0
xsubckt_536_or21nand_x0 83 82 432 434 440 861 or21nand_x0
xsubckt_1370_and2_x1 83 82 2047 2106 848 and2_x1
xsubckt_1461_nand2_x0 83 82 1958 1959 675 nand2_x0
xfeed_1186 83 82 tie
xfeed_905 83 82 tie
xfeed_552 83 82 tie
xfeed_66 83 82 tie
xsubckt_1175_and2_x1 83 82 2239 2240 624 and2_x1
xsubckt_961_and2_x1 83 82 2443 2459 2464 and2_x1
xsubckt_1301_nand2_x0 83 82 2115 2117 852 nand2_x0
xsubckt_2538_and2_x1 83 82 228 926 2721 and2_x1
xfeed_1187 83 82 decap_w0
xfeed_904 83 82 tie
xfeed_553 83 82 tie
xfeed_438 83 82 tie
xfeed_67 83 82 tie
xsubckt_1071_or2_x1 83 82 2338 2339 2340 or2_x1
xsubckt_2188_nand3_x0 83 82 1248 626 76 248 nand3_x0
xsubckt_2280_and21nor_x0 83 82 1158 683 1163 1159 and21nor_x0
xfeed_1184 83 82 tie
xfeed_907 83 82 decap_w0
xfeed_550 83 82 tie
xfeed_64 83 82 tie
xsubckt_946_and21nor_x0 83 82 2457 2484 2483 2482 and21nor_x0
xsubckt_704_or21nand_x0 83 82 272 280 279 273 or21nand_x0
xsubckt_29_inv_x0 83 82 85 886 inv_x0
xsubckt_1383_nand2_x0 83 82 2034 2035 2037 nand2_x0
xsubckt_1863_nand3_x0 83 82 1566 673 860 250 nand3_x0
xfeed_1185 83 82 tie
xfeed_906 83 82 decap_w0
xfeed_551 83 82 tie
xsubckt_927_nand2_x0 83 82 2475 4 24 nand2_x0
xsubckt_648_nor2_x0 83 82 326 43 66 nor2_x0
xsubckt_309_and3_x1 83 82 642 645 647 2700 and3_x1
xsubckt_485_nand3_x0 83 82 477 694 700 110 nand3_x0
xsubckt_1657_and2_x1 83 82 1766 1769 671 and2_x1
xsubckt_1756_nexor2_x0 83 82 1732 51 1669 nexor2_x0
xsubckt_1958_and2_x1 83 82 1473 1474 437 and2_x1
xsubckt_2035_or21nand_x0 83 82 1397 2281 2105 1398 or21nand_x0
xfeed_1182 83 82 tie
xfeed_1098 83 82 decap_w0
xfeed_901 83 82 decap_w0
xfeed_808 83 82 tie
xfeed_556 83 82 tie
xfeed_62 83 82 tie
xspare_buffer_59 83 82 2718 2716 buf_x4
xsubckt_247_and21nor_x0 83 82 700 2695 710 703 and21nor_x0
xsubckt_155_mux2_x1 83 82 769 770 772 211 mux2_x1
xsubckt_612_xor2_x0 83 82 45 65 360 xor2_x0
xsubckt_1598_nor2_x0 83 82 1824 36 248 nor2_x0
xsubckt_1608_nand2_x0 83 82 1814 1820 64 nand2_x0
xsubckt_1779_nand3_x0 83 82 1647 1649 1650 1651 nand3_x0
xfeed_1183 83 82 tie
xfeed_1099 83 82 decap_w0
xfeed_900 83 82 decap_w0
xfeed_809 83 82 tie
xfeed_557 83 82 decap_w0
xspare_buffer_58 83 82 2755 2749 buf_x4
xsubckt_1013_and2_x1 83 82 2393 0 37 and2_x1
xsubckt_1362_and21nor_x0 83 82 2055 2110 2113 2116 and21nor_x0
xsubckt_1747_or2_x1 83 82 1678 1682 843 or2_x1
xfeed_1180 83 82 tie
xfeed_903 83 82 tie
xfeed_554 83 82 tie
xfeed_60 83 82 tie
xsubckt_2652_dff_x1 83 82 131 2761 28 dff_x1
xsubckt_1265_and4_x1 83 82 2150 93 47 867 868 and4_x1
xsubckt_1108_or2_x1 83 82 2303 2304 2307 or2_x1
xsubckt_1017_or21nand_x0 83 82 2389 435 2391 2390 or21nand_x0
xsubckt_535_nand4_x0 83 82 433 646 78 247 249 nand4_x0
xsubckt_624_and2_x1 83 82 349 44 67 and2_x1
xsubckt_1654_nand3_x0 83 82 1769 646 35 249 nand3_x0
xsubckt_2247_nand2_x0 83 82 1190 1192 25 nand2_x0
xsubckt_2297_nexor2_x0 83 82 1151 24 1141 nexor2_x0
xfeed_1181 83 82 tie
xfeed_902 83 82 tie
xfeed_555 83 82 tie
xfeed_61 83 82 tie
xsubckt_409_and2_x1 83 82 546 547 659 and2_x1
xsubckt_532_and3_x1 83 82 436 646 247 249 and3_x1
xsubckt_1898_nand2_x0 83 82 1532 1534 624 nand2_x0
xdiode_120 83 82 247 diode_w1
xfeed_765 83 82 decap_w0
xspare_feed_88 83 82 tie
xsubckt_2625_dff_x1 83 82 193 2746 2706 dff_x1
xsubckt_1056_nexor2_x0 83 82 2353 2356 2352 nexor2_x0
xsubckt_1397_nand3_x0 83 82 2021 686 820 865 nand3_x0
xsubckt_1703_nand4_x0 83 82 1721 93 835 867 868 nand4_x0
xsubckt_1712_and3_x1 83 82 1712 673 812 250 and3_x1
xsubckt_2450_nand2_x0 83 82 992 993 674 nand2_x0
xsubckt_2507_nand3_x0 83 82 942 92 86 886 nand3_x0
xdiode_121 83 82 34 diode_w1
xfeed_764 83 82 decap_w0
xspare_feed_89 83 82 tie
xsubckt_1408_nand3_x0 83 82 2010 2016 2031 68 nand3_x0
xsubckt_1501_nand3_x0 83 82 1919 1922 1936 854 nand3_x0
xsubckt_2179_and2_x1 83 82 1257 251 890 and2_x1
xdiode_122 83 82 34 diode_w1
xfeed_767 83 82 decap_w0
xsubckt_2627_dff_x1 83 82 191 2746 2704 dff_x1
xsubckt_1272_nand3_x0 83 82 2143 2145 2169 2171 nand3_x0
xsubckt_959_or21nand_x0 83 82 2444 2452 2451 2445 or21nand_x0
xsubckt_7_inv_x0 83 82 266 908 inv_x0
xsubckt_1282_and21nor_x0 83 82 2134 816 2266 2136 and21nor_x0
xsubckt_2282_nand3_x0 83 82 1156 646 76 249 nand3_x0
xdiode_123 83 82 34 diode_w1
xfeed_766 83 82 decap_w0
xsubckt_79_inv_x0 83 82 53 836 inv_x0
xsubckt_1366_nand2_x0 83 82 2051 2117 70 nand2_x0
xsubckt_1389_nand3_x0 83 82 2029 2269 36 863 nand3_x0
xsubckt_1614_or21nand_x0 83 82 1808 1857 1859 1863 or21nand_x0
xsubckt_2071_or21nand_x0 83 82 1362 1368 1390 29 or21nand_x0
xdiode_124 83 82 34 diode_w1
xfeed_761 83 82 decap_w0
xfeed_259 83 82 tie
xsubckt_706_or21nand_x0 83 82 2684 293 292 291 or21nand_x0
xsubckt_527_nand3_x0 83 82 441 673 247 250 nand3_x0
xsubckt_1540_and2_x1 83 82 1881 1882 649 and2_x1
xsubckt_1810_or2_x1 83 82 1616 1617 251 or2_x1
xsubckt_1903_or21nand_x0 83 82 1527 1536 1532 1530 or21nand_x0
xdiode_125 83 82 34 diode_w1
xfeed_760 83 82 decap_w0
xfeed_399 83 82 tie
xsubckt_851_nand2_x0 83 82 2548 25 26 nand2_x0
xsubckt_180_and4_x1 83 82 751 754 80 913 81 and4_x1
xsubckt_11_inv_x0 83 82 264 904 inv_x0
xsubckt_421_nand3_x0 83 82 534 694 709 110 nand3_x0
xsubckt_1854_nand4_x0 83 82 1574 93 831 867 868 nand4_x0
xsubckt_2377_nexor2_x0 83 82 1074 36 1063 nexor2_x0
xdiode_126 83 82 442 diode_w1
xfeed_763 83 82 tie
xsubckt_2649_dff_x1 83 82 134 2735 31 dff_x1
xsubckt_1196_and3_x1 83 82 2218 2225 2246 860 and3_x1
xsubckt_882_or2_x1 83 82 2518 6 29 or2_x1
xsubckt_473_nand3_x0 83 82 488 520 675 706 nand3_x0
xsubckt_630_nor2_x0 83 82 343 44 64 nor2_x0
xdiode_127 83 82 442 diode_w1
xfeed_762 83 82 decap_w0
xsubckt_1235_and2_x1 83 82 2180 2190 437 and2_x1
xsubckt_1027_and21nor_x0 83 82 2380 2403 2400 2381 and21nor_x0
xsubckt_135_nand3_x0 83 82 783 791 904 913 nand3_x0
xsubckt_355_nexor2_x0 83 82 623 2698 598 nexor2_x0
xsubckt_1946_nand2_x0 83 82 1485 2268 71 nand2_x0
xsubckt_2413_nand4_x0 83 82 1028 93 834 867 91 nand4_x0
xsubckt_2503_nand2_x0 83 82 945 2265 271 nand2_x0
xsubckt_2524_and2_x1 83 82 219 933 2721 and2_x1
xdiode_128 83 82 64 diode_w1
xfeed_394 83 82 tie
xspare_feed_80 83 82 tie
xsubckt_2588_dff_x1 83 82 232 2757 109 dff_x1
xsubckt_2566_dff_x1 83 82 242 2753 2688 dff_x1
xsubckt_1234_nand3_x0 83 82 2181 646 828 249 nand3_x0
xsubckt_1910_and21nor_x0 83 82 1520 1527 1525 1521 and21nor_x0
xdiode_129 83 82 64 diode_w1
xfeed_395 83 82 tie
xfeed_254 83 82 tie
xspare_feed_81 83 82 tie
xsubckt_1263_and21nor_x0 83 82 2152 2153 2286 2288 and21nor_x0
xsubckt_829_and2_x1 83 82 2568 2569 2570 and2_x1
xsubckt_361_and21nor_x0 83 82 592 610 617 620 and21nor_x0
xsubckt_1766_or21nand_x0 83 82 1659 2288 1662 1660 or21nand_x0
xfeed_396 83 82 tie
xspare_feed_82 83 82 tie
xsubckt_1259_or21nand_x0 83 82 2156 15 14 7 or21nand_x0
xsubckt_286_nexor2_x0 83 82 670 874 664 nexor2_x0
xsubckt_2182_nand4_x0 83 82 1254 73 250 249 248 nand4_x0
xfeed_256 83 82 tie
xspare_feed_83 83 82 tie
xsubckt_2589_dff_x1 83 82 231 2757 108 dff_x1
xsubckt_2567_dff_x1 83 82 241 2754 2687 dff_x1
xsubckt_984_nexor2_x0 83 82 2422 2423 2421 nexor2_x0
xsubckt_1287_or21nand_x0 83 82 2129 2133 2139 624 or21nand_x0
xsubckt_1405_and21nor_x0 83 82 2013 2016 2031 857 and21nor_x0
xsubckt_1561_nexor2_x0 83 82 1866 65 1860 nexor2_x0
xfeed_769 83 82 decap_w0
xfeed_390 83 82 tie
xfeed_251 83 82 tie
xspare_feed_84 83 82 decap_w0
xsubckt_2694_dff_x1 83 82 119 2757 8 dff_x1
xsubckt_1152_nand4_x0 83 82 2261 826 250 864 248 nand4_x0
xsubckt_5_inv_x0 83 82 2692 910 inv_x0
xsubckt_531_nand2_x0 83 82 437 646 249 nand2_x0
xsubckt_1656_nand3_x0 83 82 1767 673 814 250 nand3_x0
xsubckt_2018_and21nor_x0 83 82 1414 1420 1442 30 and21nor_x0
xsubckt_2120_nand2_x0 83 82 1314 1315 675 nand2_x0
xsubckt_2309_and4_x1 83 82 1129 93 807 867 868 and4_x1
xfeed_768 83 82 decap_w0
xfeed_391 83 82 tie
xfeed_250 83 82 decap_w0
xspare_feed_85 83 82 tie
xsubckt_1018_and21nor_x0 83 82 2388 2418 2415 2417 and21nor_x0
xsubckt_19_inv_x0 83 82 260 896 inv_x0
xsubckt_503_nand2_x0 83 82 460 461 584 nand2_x0
xsubckt_560_and2_x1 83 82 410 411 447 and2_x1
xsubckt_1321_nexor2_x0 83 82 2155 819 2095 nexor2_x0
xsubckt_1484_nand3_x0 83 82 1936 673 820 250 nand3_x0
xsubckt_1872_and21nor_x0 83 82 1557 1562 1560 1558 and21nor_x0
xsubckt_2298_nexor2_x0 83 82 1151 818 1140 nexor2_x0
xsubckt_2430_nor3_x0 83 82 1012 1013 1014 659 nor3_x0
xfeed_392 83 82 tie
xfeed_253 83 82 tie
xspare_feed_86 83 82 tie
xsubckt_812_xor2_x0 83 82 48 72 2584 xor2_x0
xsubckt_665_xor2_x0 83 82 74 75 310 xor2_x0
xsubckt_156_and2_x1 83 82 768 266 912 and2_x1
xsubckt_1333_nand3_x0 83 82 2084 2269 37 863 nand3_x0
xsubckt_1424_nand4_x0 83 82 1994 93 846 867 868 nand4_x0
xsubckt_2048_and4_x1 83 82 1385 1386 1387 1388 647 and4_x1
xsubckt_2186_nand4_x0 83 82 1250 843 250 864 248 nand4_x0
xfeed_393 83 82 tie
xfeed_252 83 82 tie
xspare_feed_87 83 82 decap_w0
xsubckt_1328_and21nor_x0 83 82 2088 659 2089 2092 and21nor_x0
xdiode_49 83 82 646 diode_w1
xfeed_1133 83 82 tie
xfeed_992 83 82 tie
xfeed_668 83 82 decap_w0
xsubckt_2661_dff_x1 83 82 136 2779 33 dff_x1
xsubckt_2593_dff_x1 83 82 227 2763 104 dff_x1
xsubckt_2579_dff_x1 83 82 202 2773 22 dff_x1
xsubckt_126_or21nand_x0 83 82 789 269 790 910 or21nand_x0
xsubckt_2076_nand2_x0 83 82 1357 1358 1361 nand2_x0
xsubckt_2189_and2_x1 83 82 1247 1248 683 and2_x1
xdiode_48 83 82 646 diode_w1
xfeed_1132 83 82 decap_w0
xfeed_993 83 82 decap_w0
xfeed_669 83 82 decap_w0
xsubckt_288_nand2_x0 83 82 662 682 873 nand2_x0
xsubckt_260_and3_x1 83 82 176 688 689 884 and3_x1
xsubckt_340_nand3_x0 83 82 612 613 614 659 nand3_x0
xsubckt_1291_and2_x1 83 82 2125 2126 437 and2_x1
xsubckt_1326_or21nand_x0 83 82 2090 2168 2174 2175 or21nand_x0
xsubckt_1875_nand3_x0 83 82 1554 646 71 249 nand3_x0
xsubckt_2020_and3_x1 83 82 1412 1420 1442 30 and3_x1
xsubckt_2369_nand2_x0 83 82 1071 1073 814 nand2_x0
xsubckt_2464_and21nor_x0 83 82 979 981 984 674 and21nor_x0
xfeed_1131 83 82 decap_w0
xfeed_990 83 82 decap_w0
xsubckt_1246_or21nand_x0 83 82 2169 2178 2192 855 or21nand_x0
xsubckt_201_and21nor_x0 83 82 197 737 738 914 and21nor_x0
xsubckt_21_inv_x0 83 82 63 894 inv_x0
xsubckt_1290_nand3_x0 83 82 2126 686 27 865 nand3_x0
xsubckt_2041_and21nor_x0 83 82 1391 1406 1405 1392 and21nor_x0
xsubckt_2207_nand2_x0 83 82 1229 1238 823 nand2_x0
xfeed_1130 83 82 decap_w0
xfeed_991 83 82 tie
xsubckt_1170_and4_x1 83 82 2244 25 250 249 248 and4_x1
xsubckt_997_and2_x1 83 82 2408 33 34 and2_x1
xsubckt_989_xor2_x0 83 82 1 35 2416 xor2_x0
xsubckt_153_and2_x1 83 82 770 267 912 and2_x1
xsubckt_1438_nand4_x0 83 82 1981 1982 1983 1984 647 nand4_x0
xsubckt_1701_nexor2_x0 83 82 1739 12 1723 nexor2_x0
xsubckt_1764_nand4_x0 83 82 1661 93 834 867 868 nand4_x0
xsubckt_2008_or21nand_x0 83 82 1424 1430 1426 1425 or21nand_x0
xfeed_1137 83 82 decap_w0
xfeed_996 83 82 decap_w0
xfeed_39 83 82 tie
xsubckt_913_nand2_x0 83 82 2489 2505 2507 nand2_x0
xsubckt_1592_nand4_x0 83 82 1830 33 250 864 248 nand4_x0
xsubckt_1639_nand2_x0 83 82 1784 2268 816 nand2_x0
xsubckt_2029_or21nand_x0 83 82 1403 1456 1460 1464 or21nand_x0
xsubckt_2131_nand4_x0 83 82 1303 93 4 867 868 nand4_x0
xfeed_1136 83 82 decap_w0
xfeed_997 83 82 decap_w0
xfeed_38 83 82 tie
xsubckt_396_nand2_x0 83 82 559 251 901 nand2_x0
xsubckt_2097_nand2_x0 83 82 1337 2266 843 nand2_x0
xfeed_1258 83 82 tie
xfeed_1135 83 82 decap_w0
xfeed_994 83 82 tie
xsubckt_1268_nand2_x0 83 82 2147 2148 2164 nand2_x0
xsubckt_1040_or21nand_x0 83 82 2367 2368 2369 446 or21nand_x0
xsubckt_3_inv_x0 83 82 268 912 inv_x0
xsubckt_1496_nand3_x0 83 82 1924 646 24 249 nand3_x0
xsubckt_1879_and3_x1 83 82 1550 1552 1566 797 and3_x1
xsubckt_1916_and3_x1 83 82 1514 1519 1540 38 and3_x1
xsubckt_2144_nand2_x0 83 82 1291 1292 683 nand2_x0
xfeed_1259 83 82 tie
xfeed_1134 83 82 decap_w0
xfeed_995 83 82 tie
xsubckt_1078_or21nand_x0 83 82 2332 2349 2346 2348 or21nand_x0
xsubckt_734_and21nor_x0 83 82 2657 436 2659 2658 and21nor_x0
xsubckt_664_nand2_x0 83 82 311 74 75 nand2_x0
xsubckt_482_and3_x1 83 82 480 520 675 704 and3_x1
xsubckt_1693_nexor2_x0 83 82 1747 52 1731 nexor2_x0
xsubckt_1932_and2_x1 83 82 1498 1499 2287 and2_x1
xsubckt_2077_nand2_x0 83 82 1356 1359 1360 nand2_x0
xsubckt_2551_and2_x1 83 82 213 918 2727 and2_x1
xdiode_41 83 82 558 diode_w1
xfeed_660 83 82 tie
xfeed_35 83 82 tie
xsubckt_2654_dff_x1 83 82 129 2761 26 dff_x1
xsubckt_1428_or21nand_x0 83 82 1990 658 2005 1991 or21nand_x0
xsubckt_1845_nexor2_x0 83 82 1585 1586 1583 nexor2_x0
xsubckt_2136_nand3_x0 83 82 1299 673 66 250 nand3_x0
xfeed_1257 83 82 tie
xdiode_40 83 82 74 diode_w1
xfeed_661 83 82 tie
xsubckt_278_or2_x1 83 82 672 249 248 or2_x1
xsubckt_86_inv_x0 83 82 38 829 inv_x0
xsubckt_1369_nexor2_x0 83 82 2050 2058 2048 nexor2_x0
xsubckt_1991_nand4_x0 83 82 1441 77 250 249 248 nand4_x0
xsubckt_2250_nexor2_x0 83 82 1193 25 1187 nexor2_x0
xdiode_43 83 82 558 diode_w1
xfeed_1139 83 82 tie
xfeed_998 83 82 decap_w0
xfeed_662 83 82 tie
xsubckt_938_and2_x1 83 82 2465 35 36 and2_x1
xsubckt_1434_nand3_x0 83 82 1985 673 823 250 nand3_x0
xdiode_42 83 82 558 diode_w1
xfeed_1138 83 82 tie
xfeed_999 83 82 decap_w0
xfeed_663 83 82 tie
xsubckt_1200_nand3_x0 83 82 2214 2215 2216 659 nand3_x0
xsubckt_71_inv_x0 83 82 43 844 inv_x0
xsubckt_364_and2_x1 83 82 589 590 675 and2_x1
xsubckt_486_and21nor_x0 83 82 476 477 478 882 and21nor_x0
xsubckt_1553_or21nand_x0 83 82 1868 1872 1888 671 or21nand_x0
xsubckt_1672_and21nor_x0 83 82 1751 1807 1816 1819 and21nor_x0
xsubckt_1727_nexor2_x0 83 82 1708 76 1697 nexor2_x0
xsubckt_2170_or21nand_x0 83 82 1265 2274 1944 1266 or21nand_x0
xdiode_45 83 82 36 diode_w1
xfeed_1252 83 82 tie
xfeed_664 83 82 decap_w0
xsubckt_932_and2_x1 83 82 2470 2485 447 and2_x1
xsubckt_709_nexor2_x0 83 82 2682 2684 2681 nexor2_x0
xsubckt_297_and2_x1 83 82 653 654 660 and2_x1
xsubckt_1532_and21nor_x0 83 82 161 1889 1907 1937 and21nor_x0
xsubckt_2151_or21nand_x0 83 82 1284 1290 1288 1285 or21nand_x0
xdiode_44 83 82 36 diode_w1
xfeed_1253 83 82 tie
xfeed_665 83 82 decap_w0
xsubckt_1044_nand3_x0 83 82 2364 558 32 247 nand3_x0
xsubckt_1384_or21nand_x0 83 82 2033 2034 2041 884 or21nand_x0
xsubckt_1506_and21nor_x0 83 82 1914 1922 1936 66 and21nor_x0
xsubckt_1942_and3_x1 83 82 1489 673 852 250 and3_x1
xsubckt_2316_and3_x1 83 82 1123 626 73 248 and3_x1
xdiode_47 83 82 646 diode_w1
xfeed_1250 83 82 tie
xfeed_666 83 82 decap_w0
xfeed_33 83 82 tie
xsubckt_18_inv_x0 83 82 2686 897 inv_x0
xsubckt_146_and3_x1 83 82 240 776 777 792 and3_x1
xsubckt_1551_and2_x1 83 82 1870 1871 1887 and2_x1
xsubckt_1725_nand2_x0 83 82 1699 1708 845 nand2_x0
xsubckt_1786_and4_x1 83 82 1640 1649 1650 1651 841 and4_x1
xsubckt_1840_or21nand_x0 83 82 1587 1588 674 884 or21nand_x0
xsubckt_1892_nand3_x0 83 82 1538 2269 854 863 nand3_x0
xdiode_46 83 82 36 diode_w1
xfeed_1251 83 82 tie
xfeed_667 83 82 decap_w0
xsubckt_2628_dff_x1 83 82 190 2746 2703 dff_x1
xsubckt_231_nor2_x0 83 82 716 2708 2707 nor2_x0
xsubckt_347_nand2_x0 83 82 605 606 612 nand2_x0
xsubckt_1425_nand2_x0 83 82 1993 1994 866 nand2_x0
xsubckt_1943_nand3_x0 83 82 1488 673 852 250 nand3_x0
xsubckt_2187_nand2_x0 83 82 1249 1250 624 nand2_x0
xsubckt_2317_nand3_x0 83 82 1122 626 73 248 nand3_x0
xfeed_1069 83 82 tie
xsubckt_767_and2_x1 83 82 2626 51 72 and2_x1
xsubckt_1573_nand3_x0 83 82 1848 1947 809 811 nand3_x0
xsubckt_1723_nand2_x0 83 82 1701 1707 76 nand2_x0
xsubckt_2438_nand4_x0 83 82 1004 1008 1009 1010 810 nand4_x0
xsubckt_744_nand3_x0 83 82 2648 558 72 247 nand3_x0
xsubckt_1955_and21nor_x0 83 82 1476 1483 1481 1477 and21nor_x0
xsubckt_2125_and3_x1 83 82 1309 1310 93 867 and3_x1
xfeed_349 83 82 tie
xsubckt_1116_or21nand_x0 83 82 2296 8 436 441 or21nand_x0
xsubckt_721_nexor2_x0 83 82 2670 2673 2669 nexor2_x0
xsubckt_174_and2_x1 83 82 756 260 912 and2_x1
xsubckt_344_and21nor_x0 83 82 608 611 616 674 and21nor_x0
xsubckt_380_or21nand_x0 83 82 574 596 598 599 or21nand_x0
xsubckt_544_xor2_x0 83 82 71 54 425 xor2_x0
xsubckt_1286_and3_x1 83 82 2130 2131 2132 624 and3_x1
xsubckt_1426_and21nor_x0 83 82 1992 2286 1995 1993 and21nor_x0
xfeed_348 83 82 tie
xsubckt_1221_nor2_x0 83 82 2193 2194 251 nor2_x0
xsubckt_1214_and21nor_x0 83 82 2200 2201 2208 675 and21nor_x0
xsubckt_831_mux2_x1 83 82 2567 2573 447 126 mux2_x1
xsubckt_584_and2_x1 83 82 387 46 69 and2_x1
xsubckt_1338_and2_x1 83 82 2079 2080 624 and2_x1
xfeed_138 83 82 tie
xsubckt_2621_dff_x1 83 82 183 2752 2696 dff_x1
xsubckt_193_nand2_x0 83 82 742 751 263 nand2_x0
xsubckt_345_and2_x1 83 82 607 866 2699 and2_x1
xsubckt_1302_and2_x1 83 82 2114 2118 70 and2_x1
xfeed_139 83 82 tie
xsubckt_2613_dff_x1 83 82 176 2743 91 dff_x1
xsubckt_814_nexor2_x0 83 82 2584 2585 2582 nexor2_x0
xsubckt_1658_nand2_x0 83 82 1765 1769 671 nand2_x0
xsubckt_2253_and21nor_x0 83 82 1184 1221 1229 1232 and21nor_x0
xsubckt_353_or21nand_x0 83 82 600 626 248 2698 or21nand_x0
xsubckt_1769_or21nand_x0 83 82 1656 1691 1704 1705 or21nand_x0
xsubckt_224_nand2_x0 83 82 254 721 722 nand2_x0
xsubckt_57_inv_x0 83 82 67 858 inv_x0
xsubckt_1749_nexor2_x0 83 82 1682 75 1676 nexor2_x0
xsubckt_2064_nand2_x0 83 82 1369 1372 671 nand2_x0
xsubckt_2255_and3_x1 83 82 1182 1847 1848 2275 and3_x1
xfeed_1061 83 82 decap_w0
xfeed_343 83 82 tie
xsubckt_1038_and2_x1 83 82 2369 2370 2371 and2_x1
xsubckt_178_nand3_x0 83 82 753 754 80 81 nand3_x0
xsubckt_9_inv_x0 83 82 265 906 inv_x0
xsubckt_1713_nand3_x0 83 82 1711 673 812 250 nand3_x0
xsubckt_1976_or21nand_x0 83 82 1455 1550 1512 1513 or21nand_x0
xfeed_1060 83 82 decap_w0
xfeed_342 83 82 tie
xsubckt_914_nand2_x0 83 82 2488 36 37 nand2_x0
xsubckt_335_nexor2_x0 83 82 621 871 617 nexor2_x0
xsubckt_628_or21nand_x0 83 82 345 846 436 441 or21nand_x0
xsubckt_2400_mux2_x1 83 82 841 1042 671 1041 mux2_x1
xfeed_1063 83 82 decap_w0
xfeed_341 83 82 tie
xfeed_136 83 82 tie
xsubckt_2478_and21nor_x0 83 82 965 980 979 966 and21nor_x0
xfeed_1062 83 82 tie
xfeed_340 83 82 tie
xsubckt_1076_nand2_x0 83 82 2333 2334 2343 nand2_x0
xsubckt_232_nor3_x0 83 82 715 2700 2708 2707 nor3_x0
xsubckt_1730_nexor2_x0 83 82 1696 1697 1694 nexor2_x0
xfeed_1065 83 82 tie
xfeed_347 83 82 tie
xsubckt_1095_nand2_x0 83 82 2316 9 32 nand2_x0
xsubckt_915_xor2_x0 83 82 36 37 2487 xor2_x0
xsubckt_2049_nand4_x0 83 82 1384 1386 1387 1388 647 nand4_x0
xsubckt_2335_and3_x1 83 82 1104 1106 1110 37 and3_x1
xfeed_1064 83 82 tie
xfeed_346 83 82 tie
xfeed_131 83 82 tie
xsubckt_1184_nand2_x0 83 82 2230 2232 437 nand2_x0
xsubckt_996_and21nor_x0 83 82 2409 2441 2460 2465 and21nor_x0
xsubckt_177_and2_x1 83 82 754 268 2725 and2_x1
xsubckt_480_or21nand_x0 83 82 481 483 2704 884 or21nand_x0
xsubckt_1395_nand2_x0 83 82 2023 2024 683 nand2_x0
xsubckt_1674_or21nand_x0 83 82 1749 1751 1757 675 or21nand_x0
xfeed_345 83 82 tie
xfeed_132 83 82 decap_w0
xsubckt_1273_and21nor_x0 83 82 2142 2143 2144 674 and21nor_x0
xsubckt_1004_and21nor_x0 83 82 2401 2402 2404 446 and21nor_x0
xsubckt_986_or21nand_x0 83 82 2419 809 436 441 or21nand_x0
xsubckt_646_and2_x1 83 82 328 329 447 and2_x1
xsubckt_400_and2_x1 83 82 555 558 2696 and2_x1
xsubckt_1563_or21nand_x0 83 82 1858 1906 1914 1915 or21nand_x0
xsubckt_1761_nand2_x0 83 82 1664 1665 2286 nand2_x0
xsubckt_2051_and2_x1 83 82 1382 1383 624 and2_x1
xfeed_1066 83 82 tie
xfeed_344 83 82 tie
xfeed_133 83 82 tie
xsubckt_2637_dff_x1 83 82 162 2761 67 dff_x1
xsubckt_917_nexor2_x0 83 82 2487 2489 2485 nexor2_x0
xsubckt_1432_nand2_x0 83 82 1986 1987 675 nand2_x0
xsubckt_2194_nand2_x0 83 82 1242 1244 1246 nand2_x0
xsubckt_2547_nand2_x0 83 82 920 89 885 nand2_x0
xfeed_1076 83 82 decap_w0
xfeed_358 83 82 decap_w0
xfeed_149 83 82 tie
xsubckt_1073_nand2_x0 83 82 2336 2339 2340 nand2_x0
xsubckt_74_inv_x0 83 82 74 841 inv_x0
xsubckt_431_nand3_x0 83 82 525 526 530 691 nand3_x0
xsubckt_1560_nand3_x0 83 82 1861 1867 1868 65 nand3_x0
xsubckt_1710_nand4_x0 83 82 1714 1716 1717 1883 437 nand4_x0
xfeed_1077 83 82 decap_w0
xfeed_492 83 82 decap_w0
xsubckt_381_nand2_x0 83 82 573 574 576 nand2_x0
xsubckt_549_nor2_x0 83 82 420 54 68 nor2_x0
xsubckt_2288_and21nor_x0 83 82 1150 1157 1153 1155 and21nor_x0
xfeed_1074 83 82 tie
xfeed_491 83 82 tie
xsubckt_777_mux2_x1 83 82 72 2617 446 154 mux2_x1
xsubckt_740_or21nand_x0 83 82 2651 2652 2653 446 or21nand_x0
xsubckt_111_inv_x0 83 82 12 804 inv_x0
xfeed_1075 83 82 decap_w0
xfeed_490 83 82 tie
xsubckt_1023_and21nor_x0 83 82 2383 2384 442 447 and21nor_x0
xsubckt_778_or21nand_x0 83 82 2616 2633 2630 2632 or21nand_x0
xsubckt_769_xor2_x0 83 82 51 72 2624 xor2_x0
xsubckt_53_inv_x0 83 82 247 862 inv_x0
xsubckt_1728_and21nor_x0 83 82 1696 1755 1758 1762 and21nor_x0
xsubckt_1899_nand3_x0 83 82 1531 626 857 248 nand3_x0
xsubckt_2054_and2_x1 83 82 1379 1380 683 and2_x1
xsubckt_2213_nand2_x0 83 82 1223 1224 675 nand2_x0
xfeed_497 83 82 decap_w0
xfeed_479 83 82 tie
xsubckt_2665_dff_x1 83 82 150 2732 47 dff_x1
xsubckt_2597_dff_x1 83 82 223 2758 100 dff_x1
xsubckt_1173_nand3_x0 83 82 2241 2243 2245 647 nand3_x0
xsubckt_1030_nexor2_x0 83 82 13 36 2377 nexor2_x0
xsubckt_363_nexor2_x0 83 82 592 598 590 nexor2_x0
xsubckt_1335_and4_x1 83 82 2082 2083 2084 2085 647 and4_x1
xsubckt_1602_mux2_x1 83 82 37 1821 671 1820 mux2_x1
xsubckt_1642_nand4_x0 83 82 1781 32 250 864 248 nand4_x0
xsubckt_1671_or21nand_x0 83 82 1752 1806 1817 1818 or21nand_x0
xsubckt_1745_nand2_x0 83 82 1680 1682 75 nand2_x0
xsubckt_1929_nand2_x0 83 82 1501 2283 38 nand2_x0
xfeed_496 83 82 decap_w0
xfeed_478 83 82 tie
xsubckt_2626_dff_x1 83 82 192 2746 2705 dff_x1
xsubckt_189_and21nor_x0 83 82 201 745 746 914 and21nor_x0
xsubckt_99_inv_x0 83 82 37 816 inv_x0
xsubckt_1632_nand2_x0 83 82 1790 1791 884 nand2_x0
xsubckt_1861_or21nand_x0 83 82 1567 1568 674 884 or21nand_x0
xsubckt_2028_and21nor_x0 83 82 1404 1455 1461 1465 and21nor_x0
xsubckt_2068_and3_x1 83 82 1365 1367 1389 29 and3_x1
xfeed_1070 83 82 decap_w0
xfeed_495 83 82 decap_w0
xsubckt_2210_and21nor_x0 83 82 1226 1274 1276 1279 and21nor_x0
xsubckt_2471_nand3_x0 83 82 972 1604 1605 2282 nand3_x0
xfeed_1071 83 82 decap_w0
xfeed_494 83 82 decap_w0
xsubckt_1046_or2_x1 83 82 2362 12 35 or2_x1
xsubckt_956_xor2_x0 83 82 3 37 2447 xor2_x0
xsubckt_791_nand3_x0 83 82 2603 2604 2605 442 nand3_x0
xsubckt_265_and2_x1 83 82 684 686 865 and2_x1
xfeed_475 83 82 tie
xfeed_350 83 82 tie
xfeed_141 83 82 tie
xsubckt_1227_nand3_x0 83 82 2188 2269 820 863 nand3_x0
xsubckt_872_xor2_x0 83 82 24 25 2528 xor2_x0
xsubckt_513_or3_x1 83 82 452 247 250 271 or3_x1
xsubckt_603_nor2_x0 83 82 369 45 68 nor2_x0
xsubckt_2550_nand3_x0 83 82 918 921 942 732 nand3_x0
xfeed_474 83 82 tie
xfeed_351 83 82 decap_w0
xfeed_140 83 82 tie
xsubckt_765_and21nor_x0 83 82 2628 834 435 442 and21nor_x0
xsubckt_511_or2_x1 83 82 454 247 271 or2_x1
xsubckt_2226_and21nor_x0 83 82 129 1211 1223 1257 and21nor_x0
xfeed_499 83 82 decap_w0
xfeed_477 83 82 decap_w0
xfeed_352 83 82 decap_w0
xfeed_143 83 82 tie
xsubckt_326_nor2_x0 83 82 626 250 249 nor2_x0
xsubckt_1404_nand2_x0 83 82 2014 2016 2031 nand2_x0
xsubckt_1794_and21nor_x0 83 82 1632 1674 1676 1679 and21nor_x0
xsubckt_1857_nand2_x0 83 82 1571 1572 674 nand2_x0
xfeed_498 83 82 tie
xfeed_476 83 82 tie
xfeed_353 83 82 decap_w0
xsubckt_2668_dff_x1 83 82 147 2732 44 dff_x1
xsubckt_2570_dff_x1 83 82 211 2772 63 dff_x1
xsubckt_729_nand2_x0 83 82 2662 53 76 nand2_x0
xsubckt_684_nor2_x0 83 82 292 73 74 nor2_x0
xsubckt_613_and21nor_x0 83 82 359 382 380 381 and21nor_x0
xsubckt_2234_nand3_x0 83 82 1203 626 843 248 nand3_x0
xfeed_471 83 82 tie
xfeed_354 83 82 decap_w0
xsubckt_2687_dff_x1 83 82 112 2738 1 dff_x1
xsubckt_719_nand2_x0 83 82 2671 40 74 nand2_x0
xsubckt_49_inv_x0 83 82 271 866 inv_x0
xsubckt_449_or21nand_x0 83 82 509 522 512 510 or21nand_x0
xsubckt_1661_and2_x1 83 82 1762 1763 77 and2_x1
xsubckt_2238_nand2_x0 83 82 1199 1200 437 nand2_x0
xsubckt_2276_mux2_x1 83 82 74 1164 624 1162 mux2_x1
xfeed_470 83 82 tie
xfeed_355 83 82 decap_w0
xfeed_144 83 82 tie
xsubckt_1251_nand3_x0 83 82 2164 2165 2166 659 nand3_x0
xsubckt_1717_and21nor_x0 83 82 1707 1714 1710 1712 and21nor_x0
xsubckt_2257_or21nand_x0 83 82 1180 2281 1854 1181 or21nand_x0
xfeed_1078 83 82 decap_w0
xfeed_473 83 82 tie
xfeed_356 83 82 decap_w0
xfeed_147 83 82 tie
xsubckt_2685_dff_x1 83 82 114 2738 3 dff_x1
xsubckt_1233_and3_x1 83 82 2182 2185 2189 624 and3_x1
xsubckt_1847_nexor2_x0 83 82 1606 48 1581 nexor2_x0
xsubckt_2138_nand3_x0 83 82 1297 2269 843 863 nand3_x0
xsubckt_2290_nand2_x0 83 82 1148 1151 818 nand2_x0
xfeed_1079 83 82 tie
xfeed_472 83 82 tie
xfeed_357 83 82 decap_w0
xsubckt_1064_nexor2_x0 83 82 2346 2347 2345 nexor2_x0
xsubckt_1500_and3_x1 83 82 1920 1922 1936 854 and3_x1
xsubckt_2006_nand2_x0 83 82 1426 1428 437 nand2_x0
xfeed_624 83 82 tie
xspare_feed_109 83 82 tie
xsubckt_870_nor2_x0 83 82 2530 24 25 nor2_x0
xsubckt_759_nand2_x0 83 82 155 2634 2648 nand2_x0
xsubckt_197_nand2_x0 83 82 739 753 18 nand2_x0
xsubckt_2103_nand3_x0 83 82 1331 686 65 865 nand3_x0
xsubckt_2178_and2_x1 83 82 130 1258 1272 and2_x1
xspare_feed_108 83 82 decap_w0
xsubckt_432_and2_x1 83 82 524 525 534 and2_x1
xsubckt_568_or2_x1 83 82 402 47 67 or2_x1
xsubckt_623_or2_x1 83 82 350 44 67 or2_x1
xsubckt_2078_nand3_x0 83 82 1355 1356 1357 675 nand3_x0
xfeed_1218 83 82 tie
xfeed_626 83 82 tie
xsubckt_1145_nand2_x0 83 82 2268 249 248 nand2_x0
xsubckt_65_inv_x0 83 82 46 850 inv_x0
xsubckt_429_and21nor_x0 83 82 527 547 554 658 and21nor_x0
xsubckt_545_nexor2_x0 83 82 425 428 424 nexor2_x0
xsubckt_1371_nexor2_x0 83 82 2106 848 2046 nexor2_x0
xsubckt_1530_nand2_x0 83 82 1890 1891 884 nand2_x0
xsubckt_1788_nexor2_x0 83 82 1648 841 1638 nexor2_x0
xsubckt_1797_and2_x1 83 82 1629 1671 833 and2_x1
xsubckt_2311_or3_x1 83 82 1127 1128 1129 271 or3_x1
xfeed_1219 83 82 tie
xfeed_627 83 82 tie
xsubckt_936_or21nand_x0 83 82 2467 24 36 37 or21nand_x0
xsubckt_2031_and21nor_x0 83 82 1401 1403 1409 658 and21nor_x0
xsubckt_2112_or21nand_x0 83 82 1322 1326 1341 28 or21nand_x0
xsubckt_2350_or21nand_x0 83 82 1089 1095 1093 1090 or21nand_x0
xfeed_620 83 82 tie
xsubckt_1204_nand2_x0 83 82 2210 2283 78 nand2_x0
xsubckt_690_nor2_x0 83 82 286 287 446 nor2_x0
xsubckt_655_or2_x1 83 82 319 43 77 or2_x1
xsubckt_173_mux2_x1 83 82 757 758 772 205 mux2_x1
xsubckt_1641_nand3_x0 83 82 1782 1784 1832 647 nand3_x0
xsubckt_1643_and2_x1 83 82 1780 1781 624 and2_x1
xfeed_621 83 82 tie
xsubckt_1122_mux2_x1 83 82 32 2291 446 119 mux2_x1
xsubckt_865_nexor2_x0 83 82 2535 2538 2534 nexor2_x0
xsubckt_679_nand2_x0 83 82 296 297 442 nand2_x0
xsubckt_2081_nexor2_x0 83 82 1354 1360 1352 nexor2_x0
xsubckt_2522_and2_x1 83 82 220 934 2721 and2_x1
xfeed_622 83 82 tie
xsubckt_2605_dff_x1 83 82 233 2747 110 dff_x1
xsubckt_753_nor2_x0 83 82 2639 52 72 nor2_x0
xsubckt_2348_nand4_x0 83 82 1091 93 836 867 91 nand4_x0
xsubckt_2374_and2_x1 83 82 1066 1074 814 and2_x1
xfeed_623 83 82 tie
xsubckt_2664_dff_x1 83 82 157 2735 54 dff_x1
xsubckt_2596_dff_x1 83 82 224 2758 101 dff_x1
xsubckt_556_nand2_x0 83 82 414 65 66 nand2_x0
xsubckt_1316_and2_x1 83 82 2100 2101 2104 and2_x1
xsubckt_1324_or21nand_x0 83 82 2092 2093 2100 884 or21nand_x0
xsubckt_1621_and21nor_x0 83 82 1801 807 2282 1802 and21nor_x0
xsubckt_1754_and4_x1 83 82 1671 1805 834 835 836 and4_x1
xsubckt_2107_nand2_x0 83 82 1327 1328 671 nand2_x0
xsubckt_2289_and2_x1 83 82 1149 1151 818 and2_x1
xfeed_1212 83 82 decap_w0
xspare_feed_101 83 82 tie
xsubckt_867_or21nand_x0 83 82 2532 442 2539 2533 or21nand_x0
xsubckt_100_inv_x0 83 82 4 815 inv_x0
xsubckt_148_or21nand_x0 83 82 774 269 790 895 or21nand_x0
xsubckt_370_nexor2_x0 83 82 713 2698 583 nexor2_x0
xsubckt_430_or21nand_x0 83 82 526 548 555 659 or21nand_x0
xsubckt_547_and2_x1 83 82 422 69 55 and2_x1
xsubckt_1373_and2_x1 83 82 2044 2282 817 and2_x1
xsubckt_1763_and3_x1 83 82 1662 1663 1664 1672 and3_x1
xsubckt_2083_or21nand_x0 83 82 1350 2274 2038 1351 or21nand_x0
xsubckt_2268_and2_x1 83 82 1169 1170 1174 and2_x1
xfeed_1213 83 82 decap_w0
xspare_feed_100 83 82 tie
xsubckt_304_nand3_x0 83 82 647 250 864 248 nand3_x0
xsubckt_28_inv_x0 83 82 17 887 inv_x0
xfeed_1210 83 82 decap_w0
xspare_feed_103 83 82 tie
xsubckt_843_nor2_x0 83 82 2555 14 28 nor2_x0
xsubckt_50_inv_x0 83 82 248 865 inv_x0
xsubckt_366_and21nor_x0 83 82 587 110 694 588 and21nor_x0
xsubckt_541_and2_x1 83 82 428 78 55 and2_x1
xsubckt_1347_nand2_x0 83 82 2070 2072 437 nand2_x0
xsubckt_1549_and21nor_x0 83 82 1872 1880 1877 1873 and21nor_x0
xsubckt_1587_mux2_x1 83 82 62 1835 884 160 mux2_x1
xsubckt_1957_nand3_x0 83 82 1474 686 857 865 nand3_x0
xfeed_1211 83 82 decap_w0
xspare_feed_102 83 82 decap_w0
xsubckt_1275_and2_x1 83 82 166 2141 2147 and2_x1
xsubckt_510_nor2_x0 83 82 188 455 458 nor2_x0
xsubckt_558_or21nand_x0 83 82 412 66 68 67 or21nand_x0
xsubckt_635_or21nand_x0 83 82 338 346 345 339 or21nand_x0
xsubckt_1647_or21nand_x0 83 82 1776 1783 1779 1777 or21nand_x0
xsubckt_1928_nand2_x0 83 82 1502 2212 2282 nand2_x0
xsubckt_2285_and2_x1 83 82 1153 1156 671 and2_x1
xfeed_1216 83 82 decap_w0
xfeed_628 83 82 tie
xspare_feed_105 83 82 decap_w0
xsubckt_948_nand2_x0 83 82 2455 3 26 nand2_x0
xsubckt_1346_and2_x1 83 82 2071 2072 437 and2_x1
xsubckt_1503_nand2_x0 83 82 1917 1921 66 nand2_x0
xsubckt_1960_nand3_x0 83 82 1471 646 69 249 nand3_x0
xfeed_1217 83 82 decap_w0
xfeed_629 83 82 decap_w0
xspare_feed_104 83 82 tie
xsubckt_234_and2_x1 83 82 713 714 2699 and2_x1
xsubckt_559_nexor2_x0 83 82 412 413 411 nexor2_x0
xsubckt_1911_or21nand_x0 83 82 1519 1528 1524 1522 or21nand_x0
xfeed_1214 83 82 decap_w0
xspare_feed_107 83 82 tie
xsubckt_1156_nand2_x0 83 82 2257 2258 437 nand2_x0
xsubckt_2305_nexor2_x0 83 82 1135 1140 1133 nexor2_x0
xsubckt_2449_or21nand_x0 83 82 993 658 994 1011 or21nand_x0
xfeed_1215 83 82 decap_w0
xspare_feed_106 83 82 tie
xsubckt_844_nand2_x0 83 82 2554 14 28 nand2_x0
xsubckt_698_or2_x1 83 82 278 41 75 or2_x1
xsubckt_75_inv_x0 83 82 41 840 inv_x0
xsubckt_1470_and3_x1 83 82 1949 1950 1951 2285 and3_x1
xsubckt_1907_nand3_x0 83 82 1523 646 852 249 nand3_x0
xsubckt_2246_and21nor_x0 83 82 1191 1194 1210 820 and21nor_x0
xsubckt_2501_or21nand_x0 83 82 946 862 438 947 or21nand_x0
xfeed_307 83 82 tie
xsubckt_1155_nand3_x0 83 82 2258 686 821 865 nand3_x0
xsubckt_323_nexor2_x0 83 82 716 872 628 nexor2_x0
xsubckt_516_or2_x1 83 82 450 453 249 or2_x1
xsubckt_1741_nand2_x0 83 82 1684 673 35 nand2_x0
xsubckt_1827_and2_x1 83 82 1600 1601 2285 and2_x1
xfeed_1024 83 82 decap_w0
xfeed_306 83 82 tie
xsubckt_964_nexor2_x0 83 82 2441 2443 2440 nexor2_x0
xsubckt_955_and2_x1 83 82 2448 3 37 and2_x1
xsubckt_15_inv_x0 83 82 262 900 inv_x0
xsubckt_331_and2_x1 83 82 621 622 624 and2_x1
xsubckt_1692_and3_x1 83 82 1732 1805 835 836 and3_x1
xsubckt_2013_mux2_x1 83 82 69 1424 671 1419 mux2_x1
xsubckt_2426_mux2_x1 83 82 90 810 798 1016 mux2_x1
xsubckt_2554_or21nand_x0 83 82 916 84 909 754 or21nand_x0
xfeed_1027 83 82 decap_w0
xfeed_529 83 82 tie
xfeed_305 83 82 tie
xsubckt_2638_dff_x1 83 82 161 2761 66 dff_x1
xsubckt_1148_nand3_x0 83 82 2265 250 249 248 nand3_x0
xsubckt_731_or21nand_x0 83 82 2660 2680 2678 2679 or21nand_x0
xsubckt_330_nand3_x0 83 82 622 625 685 865 nand3_x0
xsubckt_1772_or21nand_x0 83 82 1653 1654 674 884 or21nand_x0
xsubckt_1895_nand4_x0 83 82 1535 1537 1538 1539 647 nand4_x0
xsubckt_2342_and21nor_x0 83 82 1097 1144 1135 1143 and21nor_x0
xfeed_528 83 82 tie
xfeed_304 83 82 tie
xsubckt_2660_dff_x1 83 82 137 2777 34 dff_x1
xsubckt_2592_dff_x1 83 82 228 2757 105 dff_x1
xsubckt_2578_dff_x1 83 82 203 2772 23 dff_x1
xsubckt_1873_nand3_x0 83 82 1556 686 852 865 nand3_x0
xsubckt_2387_and21nor_x0 83 82 1053 2282 1731 1054 and21nor_x0
xfeed_1021 83 82 decap_w0
xfeed_303 83 82 tie
xsubckt_85_inv_x0 83 82 15 830 inv_x0
xsubckt_1459_or21nand_x0 83 82 1960 1989 2008 2012 or21nand_x0
xsubckt_1914_and3_x1 83 82 1516 1519 1540 829 and3_x1
xsubckt_2327_nand3_x0 83 82 1112 646 843 249 nand3_x0
xfeed_1020 83 82 decap_w0
xfeed_302 83 82 tie
xsubckt_2675_dff_x1 83 82 154 2762 51 dff_x1
xsubckt_2583_dff_x1 83 82 198 2778 18 dff_x1
xsubckt_114_inv_x0 83 82 9 801 inv_x0
xsubckt_141_or21nand_x0 83 82 779 269 790 899 or21nand_x0
xsubckt_322_and2_x1 83 82 629 630 636 and2_x1
xsubckt_439_or21nand_x0 83 82 518 519 522 691 or21nand_x0
xsubckt_1758_and2_x1 83 82 1667 2282 803 and2_x1
xsubckt_2440_nand2_x0 83 82 1002 1006 34 nand2_x0
xfeed_1179 83 82 tie
xfeed_1023 83 82 decap_w0
xfeed_958 83 82 decap_w0
xfeed_301 83 82 tie
xfeed_99 83 82 tie
xsubckt_1209_nexor2_x0 83 82 14 15 2205 nexor2_x0
xsubckt_61_inv_x0 83 82 66 854 inv_x0
xsubckt_1780_and2_x1 83 82 1646 1647 841 and2_x1
xsubckt_2262_and2_x1 83 82 1175 1176 674 and2_x1
xfeed_1178 83 82 decap_w0
xfeed_1022 83 82 decap_w0
xfeed_959 83 82 decap_w0
xfeed_300 83 82 tie
xfeed_98 83 82 tie
xsubckt_93_inv_x0 83 82 7 822 inv_x0
xsubckt_1735_nand2_x0 83 82 1689 1690 675 nand2_x0
xsubckt_1984_nand4_x0 83 82 1447 93 7 867 868 nand4_x0
xsubckt_2216_nexor2_x0 83 82 1222 1227 1220 nexor2_x0
xfeed_1177 83 82 decap_w0
xfeed_956 83 82 decap_w0
xfeed_523 83 82 decap_w0
xfeed_97 83 82 tie
xsubckt_2683_dff_x1 83 82 116 2732 5 dff_x1
xsubckt_211_nand3_x0 83 82 729 108 885 85 nand3_x0
xsubckt_551_xor2_x0 83 82 54 68 418 xor2_x0
xsubckt_1572_and3_x1 83 82 1849 1947 809 811 and3_x1
xfeed_1176 83 82 decap_w0
xfeed_957 83 82 decap_w0
xfeed_522 83 82 decap_w0
xfeed_96 83 82 tie
xsubckt_1138_and2_x1 83 82 2275 2284 868 and2_x1
xsubckt_1010_and3_x1 83 82 2396 2397 2398 447 and3_x1
xsubckt_810_or2_x1 83 82 152 2586 2649 or2_x1
xsubckt_1962_nand2_x0 83 82 1469 1471 671 nand2_x0
xsubckt_2089_and2_x1 83 82 1344 1345 658 and2_x1
xfeed_1175 83 82 decap_w0
xfeed_954 83 82 decap_w0
xfeed_521 83 82 decap_w0
xfeed_95 83 82 tie
xsubckt_1007_nexor2_x0 83 82 32 33 2399 nexor2_x0
xsubckt_739_or21nand_x0 83 82 2652 2654 2655 442 or21nand_x0
xsubckt_667_or21nand_x0 83 82 308 327 326 325 or21nand_x0
xsubckt_2044_nand3_x0 83 82 1389 673 857 250 nand3_x0
xsubckt_2074_or21nand_x0 83 82 1359 1407 1412 1413 or21nand_x0
xsubckt_2328_and3_x1 83 82 1111 673 76 250 and3_x1
xsubckt_2483_mux2_x1 83 82 90 806 798 961 mux2_x1
xfeed_1174 83 82 decap_w0
xfeed_955 83 82 decap_w0
xfeed_520 83 82 decap_w0
xfeed_94 83 82 tie
xsubckt_2655_dff_x1 83 82 128 2761 25 dff_x1
xsubckt_1061_nand2_x0 83 82 2348 11 34 nand2_x0
xsubckt_1015_nexor2_x0 83 82 2392 2395 2391 nexor2_x0
xsubckt_1292_nand2_x0 83 82 2124 2126 437 nand2_x0
xsubckt_1345_nand3_x0 83 82 2072 686 823 865 nand3_x0
xfeed_1173 83 82 decap_w0
xfeed_1029 83 82 decap_w0
xfeed_952 83 82 decap_w0
xfeed_527 83 82 decap_w0
xfeed_93 83 82 tie
xsubckt_738_and2_x1 83 82 2653 2654 2655 and2_x1
xsubckt_184_nand2_x0 83 82 748 751 266 nand2_x0
xsubckt_131_and3_x1 83 82 245 786 787 792 and3_x1
xsubckt_346_and21nor_x0 83 82 606 609 608 607 and21nor_x0
xsubckt_1331_nand3_x0 83 82 2086 673 826 250 nand3_x0
xfeed_1172 83 82 decap_w0
xfeed_1028 83 82 decap_w0
xfeed_953 83 82 decap_w0
xfeed_92 83 82 tie
xsubckt_1163_nand3_x0 83 82 2250 2252 2270 79 nand3_x0
xsubckt_1058_or21nand_x0 83 82 2350 2351 2357 446 or21nand_x0
xsubckt_1467_nand2_x0 83 82 1952 1953 2275 nand2_x0
xsubckt_1633_nexor2_x0 83 82 1809 1810 1789 nexor2_x0
xfeed_1171 83 82 decap_w0
xfeed_950 83 82 decap_w0
xfeed_525 83 82 tie
xfeed_309 83 82 tie
xsubckt_317_or21nand_x0 83 82 634 663 665 666 or21nand_x0
xsubckt_1479_or21nand_x0 83 82 1940 1948 1943 1941 or21nand_x0
xsubckt_1941_or21nand_x0 83 82 1490 1509 1516 1517 or21nand_x0
xsubckt_2504_or21nand_x0 83 82 944 869 694 945 or21nand_x0
xfeed_1170 83 82 decap_w0
xfeed_951 83 82 decap_w0
xfeed_524 83 82 tie
xfeed_308 83 82 tie
xsubckt_806_nand4_x0 83 82 2589 2593 2598 2608 2625 nand4_x0
xsubckt_642_nand2_x0 83 82 332 75 76 nand2_x0
xsubckt_215_nand2_x0 83 82 257 727 728 nand2_x0
xsubckt_39_inv_x0 83 82 2697 876 inv_x0
xsubckt_404_nand2_x0 83 82 551 574 577 nand2_x0
xsubckt_427_and2_x1 83 82 529 547 554 and2_x1
xsubckt_608_and21nor_x0 83 82 364 45 435 442 and21nor_x0
xsubckt_1629_nand4_x0 83 82 1793 93 838 867 868 nand4_x0
xsubckt_2055_nand2_x0 83 82 1378 1380 683 nand2_x0
xfeed_736 83 82 tie
xspare_feed_39 83 82 tie
xsubckt_1255_nand4_x0 83 82 2160 2161 2163 2284 868 nand4_x0
xsubckt_647_and21nor_x0 83 82 327 351 350 349 and21nor_x0
xsubckt_298_or21nand_x0 83 82 652 869 693 653 or21nand_x0
xsubckt_1309_nand2_x0 83 82 2107 2108 675 nand2_x0
xsubckt_1386_and2_x1 83 82 164 2032 2053 and2_x1
xsubckt_2516_and2_x1 83 82 223 937 2719 and2_x1
xsubckt_2535_mux2_x1 83 82 106 77 943 927 mux2_x1
xfeed_737 83 82 tie
xspare_feed_38 83 82 tie
xsubckt_1022_nexor2_x0 83 82 2385 2388 2384 nexor2_x0
xsubckt_259_or21nand_x0 83 82 688 869 693 868 or21nand_x0
xsubckt_73_inv_x0 83 82 42 842 inv_x0
xsubckt_606_or21nand_x0 83 82 366 389 387 388 or21nand_x0
xsubckt_1623_and21nor_x0 83 82 1799 2275 1803 1800 and21nor_x0
xsubckt_1992_nand3_x0 83 82 1440 2269 64 863 nand3_x0
xsubckt_2019_or21nand_x0 83 82 1413 1421 1443 821 or21nand_x0
xfeed_734 83 82 decap_w0
xsubckt_977_nand2_x0 83 82 2427 2428 442 nand2_x0
xsubckt_1398_nand2_x0 83 82 2020 2021 437 nand2_x0
xfeed_735 83 82 tie
xsubckt_97_inv_x0 83 82 24 818 inv_x0
xfeed_732 83 82 tie
xsubckt_1144_and2_x1 83 82 2269 249 248 and2_x1
xsubckt_1499_nand2_x0 83 82 1921 1922 1936 nand2_x0
xsubckt_1576_and21nor_x0 83 82 1845 91 1846 2289 and21nor_x0
xsubckt_2245_nand2_x0 83 82 1192 1194 1210 nand2_x0
xsubckt_2517_mux2_x1 83 82 99 24 943 936 mux2_x1
xfeed_733 83 82 tie
xsubckt_803_nand3_x0 83 82 2592 2608 2620 2625 nand3_x0
xsubckt_1888_and2_x1 83 82 142 1542 1548 and2_x1
xfeed_730 83 82 decap_w0
xfeed_208 83 82 tie
xsubckt_1869_and2_x1 83 82 1560 1561 624 and2_x1
xsubckt_1926_nand3_x0 83 82 1504 1505 1506 659 nand3_x0
xsubckt_2228_nand3_x0 83 82 1209 2269 73 863 nand3_x0
xfeed_731 83 82 tie
xsubckt_80_inv_x0 83 82 52 835 inv_x0
xsubckt_391_nexor2_x0 83 82 712 876 563 nexor2_x0
xsubckt_514_and3_x1 83 82 179 452 453 884 and3_x1
xsubckt_1446_nand3_x0 83 82 1973 646 25 249 nand3_x0
xsubckt_1482_and2_x1 83 82 162 1938 1958 and2_x1
xsubckt_1959_nand2_x0 83 82 1472 1474 437 nand2_x0
xsubckt_2344_and2_x1 83 82 1095 1746 2282 and2_x1
xsubckt_2345_mux2_x1 83 82 90 816 798 1094 mux2_x1
xspare_feed_31 83 82 tie
xsubckt_891_nor3_x0 83 82 2510 2530 2547 2549 nor3_x0
xsubckt_253_nexor2_x0 83 82 695 2701 694 nexor2_x0
xsubckt_154_and2_x1 83 82 769 63 2725 and2_x1
xsubckt_442_nexor2_x0 83 82 516 2694 515 nexor2_x0
xsubckt_1442_nand2_x0 83 82 1977 1978 683 nand2_x0
xsubckt_2124_nand2_x0 83 82 1310 44 91 nand2_x0
xsubckt_2326_nand2_x0 83 82 1113 1114 437 nand2_x0
xspare_feed_30 83 82 tie
xsubckt_1003_or21nand_x0 83 82 2402 2411 2410 2406 or21nand_x0
xsubckt_168_and2_x1 83 82 760 262 912 and2_x1
xsubckt_118_inv_x0 83 82 39 797 inv_x0
xsubckt_574_and21nor_x0 83 82 150 446 397 410 and21nor_x0
xsubckt_1807_nand4_x0 83 82 1619 93 833 867 868 nand4_x0
xspare_feed_33 83 82 tie
xsubckt_1047_and2_x1 83 82 2361 12 35 and2_x1
xsubckt_940_xor2_x0 83 82 35 36 2463 xor2_x0
xsubckt_483_and3_x1 83 82 479 486 527 2704 and3_x1
xsubckt_1963_and21nor_x0 83 82 1468 1475 1473 1469 and21nor_x0
xsubckt_2265_and21nor_x0 83 82 1172 1226 1233 1236 and21nor_x0
xsubckt_2277_nand3_x0 83 82 1161 686 843 865 nand3_x0
xfeed_205 83 82 tie
xspare_feed_32 83 82 tie
xsubckt_2691_dff_x1 83 82 122 2763 11 dff_x1
xsubckt_437_and21nor_x0 83 82 520 553 542 521 and21nor_x0
xsubckt_1792_nexor2_x0 83 82 1636 1638 1634 nexor2_x0
xfeed_202 83 82 tie
xspare_feed_35 83 82 tie
xsubckt_2643_dff_x1 83 82 170 2773 75 dff_x1
xsubckt_1147_and3_x1 83 82 2266 250 249 248 and3_x1
xsubckt_1936_or21nand_x0 83 82 1494 1507 1508 675 or21nand_x0
xsubckt_2240_nand3_x0 83 82 1197 646 77 249 nand3_x0
xsubckt_2295_and2_x1 83 82 1143 1150 818 and2_x1
xfeed_203 83 82 tie
xspare_feed_34 83 82 tie
xsubckt_998_nand2_x0 83 82 2407 33 34 nand2_x0
xsubckt_518_or3_x1 83 82 449 247 248 271 or3_x1
xsubckt_1476_and21nor_x0 83 82 1943 91 1945 2289 and21nor_x0
xsubckt_1515_or21nand_x0 83 82 1905 1957 1962 1966 or21nand_x0
xsubckt_1765_and2_x1 83 82 1660 1661 658 and2_x1
xsubckt_1947_and4_x1 83 82 1484 1485 1486 1487 647 and4_x1
xfeed_738 83 82 tie
xfeed_200 83 82 tie
xspare_feed_37 83 82 tie
xsubckt_813_nexor2_x0 83 82 48 72 2583 nexor2_x0
xsubckt_515_nand2_x0 83 82 451 453 249 nand2_x0
xsubckt_1543_nand4_x0 83 82 1878 34 250 864 248 nand4_x0
xsubckt_1612_nexor2_x0 83 82 1820 849 1810 nexor2_x0
xsubckt_1696_and2_x1 83 82 1728 1729 2285 and2_x1
xsubckt_2220_and4_x1 83 82 1216 93 811 867 868 and4_x1
xsubckt_2225_and21nor_x0 83 82 1211 659 1220 1212 and21nor_x0
xsubckt_2302_nand2_x0 83 82 1136 1137 675 nand2_x0
xfeed_739 83 82 decap_w0
xfeed_201 83 82 tie
xspare_feed_36 83 82 tie
xsubckt_884_xor2_x0 83 82 6 29 2516 xor2_x0
xsubckt_129_or21nand_x0 83 82 787 269 790 907 or21nand_x0
xsubckt_610_or2_x1 83 82 362 45 65 or2_x1
xsubckt_1339_nand2_x0 83 82 2078 2080 624 nand2_x0
xsubckt_2066_or21nand_x0 83 82 1367 1377 1373 1370 or21nand_x0
xsubckt_2176_nand2_x0 83 82 1259 1260 884 nand2_x0
xsubckt_2367_mux2_x1 83 82 843 1075 671 1073 mux2_x1
xfeed_703 83 82 tie
xspare_feed_26 83 82 tie
xsubckt_2610_dff_x1 83 82 179 2744 250 dff_x1
xsubckt_1211_nand4_x0 83 82 2203 2210 2211 2213 2285 nand4_x0
xsubckt_164_mux2_x1 83 82 763 764 772 208 mux2_x1
xsubckt_1435_nand4_x0 83 82 1984 34 250 249 248 nand4_x0
xsubckt_1478_and2_x1 83 82 1941 1942 866 and2_x1
xsubckt_2022_nexor2_x0 83 82 1419 30 1410 nexor2_x0
xsubckt_2371_nand2_x0 83 82 1069 1074 36 nand2_x0
xsubckt_2469_nand2_x0 83 82 974 975 976 nand2_x0
xsubckt_2505_and2_x1 83 82 238 944 2714 and2_x1
xfeed_702 83 82 tie
xsubckt_428_nand2_x0 83 82 528 547 554 nand2_x0
xsubckt_1329_and2_x1 83 82 165 2088 2107 and2_x1
xsubckt_1686_nexor2_x0 83 82 1798 805 1737 nexor2_x0
xsubckt_1737_mux2_x1 83 82 59 1688 884 171 mux2_x1
xsubckt_1897_and2_x1 83 82 1533 1534 624 and2_x1
xfeed_701 83 82 decap_w0
xfeed_239 83 82 tie
xspare_feed_24 83 82 tie
xsubckt_820_nand3_x0 83 82 2576 2577 2578 442 nand3_x0
xsubckt_650_xor2_x0 83 82 43 66 324 xor2_x0
xsubckt_270_and21nor_x0 83 82 679 110 694 681 and21nor_x0
xsubckt_249_nor2_x0 83 82 698 699 705 nor2_x0
xsubckt_602_nexor2_x0 83 82 372 374 370 nexor2_x0
xsubckt_1722_and2_x1 83 82 1702 1707 76 and2_x1
xfeed_700 83 82 decap_w0
xfeed_238 83 82 tie
xsubckt_680_or21nand_x0 83 82 295 303 302 296 or21nand_x0
xfeed_707 83 82 tie
xspare_feed_22 83 82 tie
xsubckt_859_nexor2_x0 83 82 2541 2544 2540 nexor2_x0
xsubckt_145_nand3_x0 83 82 776 791 898 913 nand3_x0
xsubckt_377_nand2_x0 83 82 577 672 876 nand2_x0
xsubckt_629_and21nor_x0 83 82 344 362 359 361 and21nor_x0
xfeed_706 83 82 tie
xspare_feed_23 83 82 tie
xsubckt_1065_and21nor_x0 83 82 2344 803 435 442 and21nor_x0
xsubckt_1050_or21nand_x0 83 82 2358 12 436 441 or21nand_x0
xsubckt_907_xor2_x0 83 82 5 25 2494 xor2_x0
xsubckt_1458_and21nor_x0 83 82 1961 1988 2009 2013 and21nor_x0
xsubckt_1880_nand3_x0 83 82 1549 1552 1566 797 nand3_x0
xsubckt_1994_and4_x1 83 82 1438 1439 1440 1441 647 and4_x1
xsubckt_2667_dff_x1 83 82 148 2732 45 dff_x1
xsubckt_2595_dff_x1 83 82 225 2779 102 dff_x1
xsubckt_825_and3_x1 83 82 2572 673 29 250 and3_x1
xsubckt_212_nand2_x0 83 82 258 729 730 nand2_x0
xsubckt_633_nexor2_x0 83 82 341 344 340 nexor2_x0
xsubckt_1690_nand3_x0 83 82 1733 1734 1748 1753 nand3_x0
xsubckt_1695_and21nor_x0 83 82 1729 804 2282 1730 and21nor_x0
xsubckt_2052_nand2_x0 83 82 1381 1383 624 nand2_x0
xsubckt_2459_nexor2_x0 83 82 987 33 984 nexor2_x0
xfeed_704 83 82 tie
xsubckt_1114_nexor2_x0 83 82 2300 2301 2298 nexor2_x0
xsubckt_1041_nor2_x0 83 82 2366 2367 2373 nor2_x0
xsubckt_382_or2_x1 83 82 572 574 576 or2_x1
xsubckt_593_nexor2_x0 83 82 379 382 378 nexor2_x0
xsubckt_1327_nexor2_x0 83 82 2091 2112 2089 nexor2_x0
xsubckt_1418_mux2_x1 83 82 90 857 798 2000 mux2_x1
xsubckt_1687_or21nand_x0 83 82 1736 2285 1738 1740 or21nand_x0
xsubckt_2384_nexor2_x0 83 82 1058 1063 1056 nexor2_x0
xsubckt_2466_and21nor_x0 83 82 977 1000 996 999 and21nor_x0
xsubckt_2475_nand4_x0 83 82 968 93 801 867 868 nand4_x0
xfeed_233 83 82 tie
xsubckt_1033_or21nand_x0 83 82 2374 13 436 441 or21nand_x0
xsubckt_905_or2_x1 83 82 2496 5 25 or2_x1
xsubckt_892_nand2_x0 83 82 2509 2529 2548 nand2_x0
xsubckt_795_nand2_x0 83 82 2600 49 72 nand2_x0
xsubckt_517_and21nor_x0 83 82 178 450 451 251 and21nor_x0
xsubckt_1546_nand3_x0 83 82 1875 686 814 865 nand3_x0
xsubckt_1575_nexor2_x0 83 82 1897 809 1846 nexor2_x0
xsubckt_2202_and2_x1 83 82 1234 1238 26 and2_x1
xsubckt_2272_mux2_x1 83 82 64 72 2269 1166 mux2_x1
xsubckt_2418_and21nor_x0 83 82 1023 659 1032 1024 and21nor_x0
xfeed_232 83 82 decap_w0
xsubckt_2648_dff_x1 83 82 141 2745 38 dff_x1
xsubckt_1229_nand2_x0 83 82 2186 2268 824 nand2_x0
xsubckt_1106_nand4_x0 83 82 2305 2309 2314 2324 2341 nand4_x0
xsubckt_1000_nexor2_x0 83 82 33 34 2405 nexor2_x0
xsubckt_652_and2_x1 83 82 322 323 436 and2_x1
xsubckt_37_inv_x0 83 82 2695 878 inv_x0
xsubckt_410_and2_x1 83 82 545 672 2697 and2_x1
xsubckt_462_and21nor_x0 83 82 497 499 502 506 and21nor_x0
xsubckt_1317_nand4_x0 83 82 2099 93 46 867 868 nand4_x0
xsubckt_2095_nand4_x0 83 82 1339 77 250 864 248 nand4_x0
xfeed_709 83 82 tie
xfeed_231 83 82 tie
xsubckt_1816_or2_x1 83 82 1611 1613 839 or2_x1
xsubckt_2012_or21nand_x0 83 82 1420 1430 1426 1423 or21nand_x0
xsubckt_2427_or21nand_x0 83 82 1015 2274 1621 1016 or21nand_x0
xfeed_708 83 82 tie
xsubckt_1169_nand3_x0 83 82 2245 2269 26 863 nand3_x0
xsubckt_283_and2_x1 83 82 667 670 2707 and2_x1
xsubckt_22_inv_x0 83 82 61 893 inv_x0
xsubckt_334_and21nor_x0 83 82 618 622 624 871 and21nor_x0
xfeed_237 83 82 tie
xsubckt_597_nand2_x0 83 82 375 394 414 nand2_x0
xsubckt_1323_nand2_x0 83 82 2093 2094 2098 nand2_x0
xsubckt_1472_and4_x1 83 82 1947 2097 813 815 817 and4_x1
xsubckt_1900_and2_x1 83 82 1530 1531 683 and2_x1
xsubckt_2123_nexor2_x0 83 82 1313 1319 1311 nexor2_x0
xsubckt_2284_nand3_x0 83 82 1154 673 847 250 nand3_x0
xsubckt_2379_or21nand_x0 83 82 1061 1086 1100 1101 or21nand_x0
xsubckt_2461_or21nand_x0 83 82 982 990 1003 1004 or21nand_x0
xsubckt_2500_nand4_x0 83 82 947 250 249 248 271 nand4_x0
xfeed_236 83 82 tie
xsubckt_2608_dff_x1 83 82 216 2741 93 dff_x1
xsubckt_450_and2_x1 83 82 508 509 513 and2_x1
xfeed_235 83 82 tie
xspare_feed_28 83 82 tie
xsubckt_898_nor2_x0 83 82 2503 5 28 nor2_x0
xsubckt_876_nor2_x0 83 82 2524 6 26 nor2_x0
xsubckt_507_nand3_x0 83 82 457 271 2702 883 nand3_x0
xsubckt_1539_nand3_x0 83 82 1882 1884 1885 1886 nand3_x0
xsubckt_1978_and3_x1 83 82 1453 2161 2163 2282 and3_x1
xfeed_234 83 82 tie
xspare_feed_29 83 82 tie
xsubckt_2642_dff_x1 83 82 171 2774 76 dff_x1
xsubckt_13_inv_x0 83 82 263 902 inv_x0
xsubckt_571_nexor2_x0 83 82 400 403 399 nexor2_x0
xsubckt_1281_nand2_x0 83 82 2135 2268 821 nand2_x0
xsubckt_2494_nexor2_x0 83 82 951 1584 950 nexor2_x0
xfeed_871 83 82 tie
xfeed_567 83 82 tie
xspare_buffer_42 83 82 2768 2762 buf_x4
xsubckt_846_nexor2_x0 83 82 2553 2556 2552 nexor2_x0
xsubckt_328_nand2_x0 83 82 624 626 248 nand2_x0
xsubckt_368_and21nor_x0 83 82 585 694 110 251 and21nor_x0
xsubckt_1550_or21nand_x0 83 82 1871 1881 1876 1874 or21nand_x0
xsubckt_1708_nand3_x0 83 82 1716 686 808 865 nand3_x0
xsubckt_2465_or21nand_x0 83 82 978 1001 995 998 or21nand_x0
xfeed_870 83 82 decap_w0
xfeed_566 83 82 decap_w0
xspare_buffer_43 83 82 2723 2721 buf_x4
xsubckt_2640_dff_x1 83 82 159 2771 64 dff_x1
xsubckt_1242_nand3_x0 83 82 2173 2177 2191 855 nand3_x0
xsubckt_392_nand2_x0 83 82 562 563 884 nand2_x0
xsubckt_637_and21nor_x0 83 82 147 446 338 337 and21nor_x0
xsubckt_1718_and2_x1 83 82 1706 1707 845 and2_x1
xsubckt_2002_and21nor_x0 83 82 1430 1437 1435 1431 and21nor_x0
xfeed_918 83 82 tie
xfeed_873 83 82 decap_w0
xfeed_565 83 82 decap_w0
xspare_buffer_40 83 82 2768 2764 buf_x4
xsubckt_720_xor2_x0 83 82 40 74 2670 xor2_x0
xsubckt_1325_and21nor_x0 83 82 2091 2167 2173 2176 and21nor_x0
xsubckt_1509_nor2_x0 83 82 1911 1914 1916 nor2_x0
xfeed_919 83 82 decap_w0
xfeed_872 83 82 tie
xfeed_564 83 82 tie
xspare_buffer_41 83 82 2768 2763 buf_x4
xsubckt_1100_and21nor_x0 83 82 2311 801 435 442 and21nor_x0
xsubckt_782_nexor2_x0 83 82 2613 2616 2612 nexor2_x0
xsubckt_1566_and3_x1 83 82 1855 1954 840 842 and3_x1
xsubckt_1791_or21nand_x0 83 82 1635 1656 1676 1680 or21nand_x0
xfeed_875 83 82 decap_w0
xfeed_563 83 82 decap_w0
xspare_buffer_46 83 82 2768 2759 buf_x4
xsubckt_856_nor2_x0 83 82 2543 30 7 nor2_x0
xsubckt_218_nand2_x0 83 82 256 725 726 nand2_x0
xsubckt_139_or21nand_x0 83 82 780 269 790 901 or21nand_x0
xsubckt_1330_and3_x1 83 82 2087 673 826 250 and3_x1
xsubckt_1648_and21nor_x0 83 82 1775 1782 1780 1778 and21nor_x0
xfeed_874 83 82 decap_w0
xfeed_562 83 82 tie
xspare_buffer_47 83 82 2723 2720 buf_x4
xsubckt_393_and2_x1 83 82 561 562 584 and2_x1
xsubckt_1492_nand2_x0 83 82 1928 1929 683 nand2_x0
xsubckt_1920_and3_x1 83 82 1510 1552 1566 39 and3_x1
xfeed_877 83 82 decap_w0
xfeed_561 83 82 tie
xspare_buffer_44 83 82 2768 2761 buf_x4
xsubckt_1133_and2_x1 83 82 2280 93 91 and2_x1
xsubckt_985_and2_x1 83 82 2420 2421 436 and2_x1
xsubckt_1862_or21nand_x0 83 82 167 1567 1570 1614 or21nand_x0
xsubckt_1923_and21nor_x0 83 82 1507 1513 1511 1509 and21nor_x0
xfeed_876 83 82 decap_w0
xfeed_560 83 82 tie
xspare_buffer_45 83 82 2768 2760 buf_x4
xsubckt_607_nexor2_x0 83 82 366 367 365 nexor2_x0
xsubckt_1635_nexor2_x0 83 82 1807 1811 1787 nexor2_x0
xsubckt_2191_nand3_x0 83 82 1245 686 847 865 nand3_x0
xsubckt_2443_and2_x1 83 82 999 1006 810 and2_x1
xsubckt_2525_mux2_x1 83 82 95 34 943 932 mux2_x1
xfeed_879 83 82 decap_w0
xfeed_53 83 82 tie
xsubckt_2300_or21nand_x0 83 82 1138 1173 1187 1188 or21nand_x0
xsubckt_2487_and3_x1 83 82 957 958 959 658 and3_x1
xsubckt_2546_nand2_x0 83 82 921 734 795 nand2_x0
xfeed_913 83 82 tie
xfeed_878 83 82 decap_w0
xsubckt_657_xor2_x0 83 82 43 77 317 xor2_x0
xsubckt_1471_and2_x1 83 82 1948 1949 1952 and2_x1
xsubckt_1601_and21nor_x0 83 82 1821 1826 1822 1823 and21nor_x0
xsubckt_2388_and4_x1 83 82 1052 93 804 867 868 and4_x1
xfeed_910 83 82 tie
xfeed_51 83 82 tie
xspare_buffer_48 83 82 2768 2758 buf_x4
xsubckt_2645_dff_x1 83 82 168 2779 73 dff_x1
xsubckt_717_and21nor_x0 83 82 2673 278 275 277 and21nor_x0
xsubckt_685_nand2_x0 83 82 291 73 74 nand2_x0
xsubckt_1726_nexor2_x0 83 82 1708 845 1698 nexor2_x0
xsubckt_2181_nand3_x0 83 82 1255 673 851 250 nand3_x0
xsubckt_2236_and21nor_x0 83 82 1201 1202 1205 684 and21nor_x0
xfeed_911 83 82 tie
xfeed_50 83 82 tie
xspare_buffer_49 83 82 2768 2757 buf_x4
xsubckt_702_nexor2_x0 83 82 275 276 274 nexor2_x0
xsubckt_697_or21nand_x0 83 82 279 840 436 441 or21nand_x0
xsubckt_385_or21nand_x0 83 82 569 592 597 600 or21nand_x0
xsubckt_594_or21nand_x0 83 82 377 378 441 446 or21nand_x0
xsubckt_1793_nand2_x0 83 82 1633 1634 675 nand2_x0
xsubckt_1855_and2_x1 83 82 1573 1574 658 and2_x1
xsubckt_1867_nand4_x0 83 82 1562 1563 1564 1565 647 nand4_x0
xsubckt_2383_or21nand_x0 83 82 1057 1098 1099 1103 or21nand_x0
xfeed_916 83 82 decap_w0
xfeed_57 83 82 tie
xsubckt_241_nor4_x0 83 82 706 2694 2693 2706 2705 nor4_x0
xsubckt_526_and3_x1 83 82 442 673 247 250 and3_x1
xsubckt_1670_or2_x1 83 82 1753 1754 658 or2_x1
xsubckt_1805_nexor2_x0 83 82 1666 802 1621 nexor2_x0
xfeed_917 83 82 decap_w0
xsubckt_678_nexor2_x0 83 82 298 301 297 nexor2_x0
xsubckt_103_inv_x0 83 82 35 812 inv_x0
xsubckt_133_nand3_x0 83 82 784 791 906 913 nand3_x0
xfeed_914 83 82 tie
xfeed_569 83 82 tie
xfeed_55 83 82 tie
xsubckt_1192_and21nor_x0 83 82 2222 2225 2246 78 and21nor_x0
xsubckt_916_nexor2_x0 83 82 36 37 2486 nexor2_x0
xfeed_915 83 82 tie
xfeed_568 83 82 tie
xfeed_54 83 82 tie
xsubckt_716_or21nand_x0 83 82 2674 40 436 441 or21nand_x0
xsubckt_2159_nexor2_x0 83 82 1283 27 1276 nexor2_x0
xdiode_7 83 82 248 diode_w1
xfeed_772 83 82 tie
xspare_feed_75 83 82 tie
xsubckt_399_nand2_x0 83 82 556 557 2696 nand2_x0
xsubckt_2098_nand2_x0 83 82 1336 2268 857 nand2_x0
xdiode_6 83 82 248 diode_w1
xfeed_773 83 82 tie
xspare_feed_74 83 82 tie
xsubckt_2653_dff_x1 83 82 130 2761 27 dff_x1
xsubckt_725_or21nand_x0 83 82 2666 74 72 73 or21nand_x0
xsubckt_176_mux2_x1 83 82 755 756 772 204 mux2_x1
xsubckt_1605_nor2_x0 83 82 1817 1820 849 nor2_x0
xdiode_5 83 82 248 diode_w1
xfeed_770 83 82 tie
xfeed_248 83 82 decap_w0
xsubckt_651_nexor2_x0 83 82 324 327 323 nexor2_x0
xsubckt_222_nand3_x0 83 82 722 96 86 85 nand3_x0
xsubckt_519_nand2_x0 83 82 448 449 884 nand2_x0
xsubckt_1393_and2_x1 83 82 2025 2026 624 and2_x1
xsubckt_1668_and21nor_x0 83 82 1755 1814 1809 1813 and21nor_x0
xsubckt_2224_or2_x1 83 82 1212 1213 251 or2_x1
xdiode_4 83 82 72 diode_w1
xfeed_249 83 82 decap_w0
xspare_feed_76 83 82 tie
xsubckt_1222_and2_x1 83 82 173 2193 2199 and2_x1
xsubckt_214_nand3_x0 83 82 727 107 885 85 nand3_x0
xsubckt_1555_mux2_x1 83 82 818 1870 671 1866 mux2_x1
xsubckt_1933_nand2_x0 83 82 1497 1498 1500 nand2_x0
xsubckt_2239_nand2_x0 83 82 1198 77 865 nand2_x0
xdiode_3 83 82 72 diode_w1
xfeed_776 83 82 tie
xspare_feed_71 83 82 tie
xsubckt_2614_dff_x1 83 82 175 2744 90 dff_x1
xsubckt_1159_nand3_x0 83 82 2254 646 31 249 nand3_x0
xsubckt_2206_and2_x1 83 82 1230 1238 823 and2_x1
xsubckt_2218_mux2_x1 83 82 867 26 798 1218 mux2_x1
xdiode_2 83 82 72 diode_w1
xfeed_777 83 82 tie
xspare_feed_70 83 82 tie
xsubckt_1201_nand4_x0 83 82 2213 93 14 90 91 nand4_x0
xsubckt_771_or2_x1 83 82 2622 2623 2624 or2_x1
xsubckt_600_xor2_x0 83 82 77 64 372 xor2_x0
xsubckt_2172_or21nand_x0 83 82 1263 1268 1265 1264 or21nand_x0
xdiode_1 83 82 90 diode_w1
xfeed_428 83 82 decap_w0
xspare_feed_73 83 82 tie
xsubckt_850_or21nand_x0 83 82 2549 26 28 27 or21nand_x0
xsubckt_199_nand2_x0 83 82 738 751 261 nand2_x0
xsubckt_128_and3_x1 83 82 246 788 789 792 and3_x1
xsubckt_1759_and4_x1 83 82 1666 1798 803 804 805 and4_x1
xsubckt_2004_nand3_x0 83 82 1428 686 858 865 nand3_x0
xdiode_0 83 82 90 diode_w1
xfeed_775 83 82 tie
xfeed_429 83 82 tie
xspare_feed_72 83 82 tie
xsubckt_243_and2_x1 83 82 704 706 881 and2_x1
xsubckt_233_or3_x1 83 82 714 2700 2708 2707 or3_x1
xsubckt_372_nand2_x0 83 82 581 582 584 nand2_x0
xsubckt_636_and2_x1 83 82 337 352 447 and2_x1
xsubckt_1799_and21nor_x0 83 82 1627 90 93 74 and21nor_x0
xsubckt_1948_nand4_x0 83 82 1483 1485 1486 1487 647 nand4_x0
xsubckt_2146_nand3_x0 83 82 1289 686 64 865 nand3_x0
xfeed_426 83 82 tie
xsubckt_670_xor2_x0 83 82 42 65 305 xor2_x0
xsubckt_661_and21nor_x0 83 82 146 446 314 328 and21nor_x0
xsubckt_228_nand3_x0 83 82 718 94 86 85 nand3_x0
xsubckt_127_nand3_x0 83 82 788 791 911 913 nand3_x0
xsubckt_1488_nand4_x0 83 82 1932 1933 1934 1935 647 nand4_x0
xsubckt_1495_nand2_x0 83 82 1925 1926 437 nand2_x0
xsubckt_1683_and2_x1 83 82 1740 1741 866 and2_x1
xsubckt_1983_nand2_x0 83 82 1448 1449 1450 nand2_x0
xsubckt_2558_buf_x1 83 82 85 87 buf_x1
xfeed_427 83 82 tie
xsubckt_952_or21nand_x0 83 82 2451 813 436 441 or21nand_x0
xsubckt_505_and3_x1 83 82 459 473 528 2702 and3_x1
xsubckt_1414_and3_x1 83 82 2004 2106 846 848 and3_x1
xsubckt_1567_nexor2_x0 83 82 1903 840 1854 nexor2_x0
xsubckt_1762_and21nor_x0 83 82 1663 2275 1668 1667 and21nor_x0
xsubckt_1821_and3_x1 83 82 1606 1671 832 833 and3_x1
xsubckt_2100_nand3_x0 83 82 1334 626 849 248 nand3_x0
xsubckt_2198_and21nor_x0 83 82 1238 1240 1242 1256 and21nor_x0
xfeed_778 83 82 decap_w0
xfeed_424 83 82 tie
xfeed_240 83 82 tie
xsubckt_119_inv_x0 83 82 92 796 inv_x0
xsubckt_1462_and21nor_x0 83 82 1957 2006 2008 2011 and21nor_x0
xsubckt_1901_nand2_x0 83 82 1529 1531 683 nand2_x0
xfeed_779 83 82 decap_w0
xfeed_425 83 82 tie
xfeed_241 83 82 tie
xsubckt_2682_dff_x1 83 82 117 2732 6 dff_x1
xsubckt_1034_and21nor_x0 83 82 2373 436 2375 2374 and21nor_x0
xsubckt_957_nexor2_x0 83 82 2447 2450 2446 nexor2_x0
xsubckt_389_and21nor_x0 83 82 565 110 694 566 and21nor_x0
xsubckt_1625_nand4_x0 83 82 1797 1947 807 809 811 nand4_x0
xsubckt_1824_nexor2_x0 83 82 1629 49 1603 nexor2_x0
xfeed_422 83 82 decap_w0
xfeed_246 83 82 tie
xsubckt_2636_dff_x1 83 82 163 2761 68 dff_x1
xsubckt_733_or21nand_x0 83 82 2658 53 436 441 or21nand_x0
xsubckt_138_nand3_x0 83 82 781 791 902 913 nand3_x0
xsubckt_440_nand3_x0 83 82 517 694 708 110 nand3_x0
xfeed_423 83 82 tie
xfeed_247 83 82 decap_w0
xspare_feed_78 83 82 tie
xsubckt_920_and2_x1 83 82 2482 4 27 and2_x1
xsubckt_910_nand2_x0 83 82 2491 2492 442 nand2_x0
xsubckt_2541_mux2_x1 83 82 103 74 943 924 mux2_x1
xdiode_9 83 82 248 diode_w1
xfeed_420 83 82 tie
xfeed_244 83 82 tie
xsubckt_102_inv_x0 83 82 3 813 inv_x0
xsubckt_577_nand2_x0 83 82 394 64 65 nand2_x0
xsubckt_1308_nexor2_x0 83 82 2110 2111 2108 nexor2_x0
xdiode_8 83 82 248 diode_w1
xfeed_421 83 82 tie
xfeed_245 83 82 tie
xsubckt_1253_nor3_x0 83 82 2162 47 54 55 nor3_x0
xsubckt_912_mux2_x1 83 82 2490 2504 447 116 mux2_x1
xsubckt_311_nexor2_x0 83 82 644 2700 640 nexor2_x0
xsubckt_1368_or21nand_x0 83 82 2049 2112 2091 2051 or21nand_x0
xsubckt_1838_and21nor_x0 83 82 1589 1636 1643 1646 and21nor_x0
xsubckt_2303_and21nor_x0 83 82 1135 1185 1187 1191 and21nor_x0
xdiode_56 83 82 659 diode_w1
xfeed_695 83 82 decap_w0
xsubckt_2676_dff_x1 83 82 153 2762 50 dff_x1
xsubckt_2580_dff_x1 83 82 201 2774 21 dff_x1
xsubckt_728_nor2_x0 83 82 2663 53 76 nor2_x0
xsubckt_293_and2_x1 83 82 657 682 2708 and2_x1
xsubckt_269_nand2_x0 83 82 680 682 271 nand2_x0
xsubckt_188_nand2_x0 83 82 745 753 21 nand2_x0
xsubckt_395_or21nand_x0 83 82 184 564 561 560 or21nand_x0
xsubckt_443_mux2_x1 83 82 2686 515 884 181 mux2_x1
xsubckt_1669_nexor2_x0 83 82 1756 1757 1754 nexor2_x0
xdiode_57 83 82 659 diode_w1
xfeed_1121 83 82 tie
xfeed_694 83 82 decap_w0
xsubckt_1274_nor2_x0 83 82 2141 2142 251 nor2_x0
xsubckt_2024_and21nor_x0 83 82 1408 1490 1460 1463 and21nor_x0
xsubckt_2477_and21nor_x0 83 82 966 973 970 967 and21nor_x0
xdiode_54 83 82 659 diode_w1
xfeed_1122 83 82 tie
xfeed_697 83 82 decap_w0
xsubckt_2674_dff_x1 83 82 155 2762 52 dff_x1
xsubckt_2582_dff_x1 83 82 199 2778 19 dff_x1
xsubckt_878_xor2_x0 83 82 6 26 2522 xor2_x0
xsubckt_479_and2_x1 83 82 482 483 2704 and2_x1
xsubckt_1528_and2_x1 83 82 1892 1893 866 and2_x1
xsubckt_2406_nexor2_x0 83 82 1041 812 1035 nexor2_x0
xsubckt_2536_and2_x1 83 82 229 927 2719 and2_x1
xdiode_55 83 82 659 diode_w1
xfeed_1123 83 82 tie
xfeed_696 83 82 decap_w0
xsubckt_1091_nand3_x0 83 82 2319 2320 2321 442 nand3_x0
xsubckt_619_xor2_x0 83 82 76 77 354 xor2_x0
xsubckt_1486_nand3_x0 83 82 1934 2269 34 863 nand3_x0
xsubckt_1624_and4_x1 83 82 1798 1947 807 809 811 and4_x1
xsubckt_1636_and21nor_x0 83 82 1786 675 1787 1790 and21nor_x0
xdiode_52 83 82 646 diode_w1
xfeed_1124 83 82 tie
xfeed_691 83 82 decap_w0
xsubckt_1187_nand2_x0 83 82 2227 2229 671 nand2_x0
xsubckt_931_or21nand_x0 83 82 2471 2479 2478 2472 or21nand_x0
xsubckt_315_nand2_x0 83 82 636 637 659 nand2_x0
xsubckt_121_and2_x1 83 82 794 268 269 and2_x1
xsubckt_565_nexor2_x0 83 82 406 409 405 nexor2_x0
xsubckt_1356_or21nand_x0 83 82 2061 2065 2087 69 or21nand_x0
xsubckt_1778_and3_x1 83 82 1648 1649 1650 1651 and3_x1
xsubckt_2448_nexor2_x0 83 82 996 997 994 nexor2_x0
xdiode_53 83 82 646 diode_w1
xfeed_1125 83 82 decap_w0
xfeed_690 83 82 tie
xsubckt_1025_or21nand_x0 83 82 2382 34 32 33 or21nand_x0
xsubckt_883_and2_x1 83 82 2517 6 29 and2_x1
xsubckt_837_xor2_x0 83 82 31 14 2561 xor2_x0
xsubckt_338_nand2_x0 83 82 614 615 616 nand2_x0
xsubckt_1564_and21nor_x0 83 82 1857 1905 1913 1916 and21nor_x0
xdiode_50 83 82 646 diode_w1
xfeed_1126 83 82 decap_w0
xfeed_693 83 82 decap_w0
xsubckt_601_or21nand_x0 83 82 371 376 375 372 or21nand_x0
xdiode_51 83 82 646 diode_w1
xfeed_1127 83 82 decap_w0
xfeed_692 83 82 decap_w0
xsubckt_2615_dff_x1 83 82 195 2745 2708 dff_x1
xsubckt_1250_or21nand_x0 83 82 2165 2172 2170 2167 or21nand_x0
xsubckt_1166_and21nor_x0 83 82 174 2248 2271 251 and21nor_x0
xsubckt_1131_and3_x1 83 82 2282 93 90 91 and3_x1
xsubckt_972_and21nor_x0 83 82 2432 2450 2449 2448 and21nor_x0
xsubckt_621_nexor2_x0 83 82 354 355 352 nexor2_x0
xsubckt_1981_or4_x1 83 82 1450 1451 1452 1453 2286 or4_x1
xsubckt_2410_and2_x1 83 82 1031 1669 2282 and2_x1
xfeed_1263 83 82 tie
xfeed_1128 83 82 decap_w0
xfeed_22 83 82 tie
xsubckt_939_nand2_x0 83 82 2464 35 36 nand2_x0
xsubckt_749_nexor2_x0 83 82 2644 2647 2643 nexor2_x0
xsubckt_700_xor2_x0 83 82 41 75 276 xor2_x0
xsubckt_272_nand2_x0 83 82 677 679 873 nand2_x0
xsubckt_581_nand3_x0 83 82 390 391 392 447 nand3_x0
xsubckt_1514_and21nor_x0 83 82 1906 1956 1963 1967 and21nor_x0
xsubckt_2032_nand2_x0 83 82 1400 1401 1402 nand2_x0
xfeed_1129 83 82 decap_w0
xfeed_23 83 82 tie
xsubckt_2135_and2_x1 83 82 131 1300 1314 and2_x1
xsubckt_2273_mux2_x1 83 82 839 1167 647 1165 mux2_x1
xfeed_1261 83 82 tie
xfeed_20 83 82 tie
xsubckt_1226_nand4_x0 83 82 2189 26 250 864 248 nand4_x0
xsubckt_1181_or21nand_x0 83 82 2233 2242 2238 2236 or21nand_x0
xsubckt_1160_and2_x1 83 82 2253 2254 671 and2_x1
xsubckt_1085_or2_x1 83 82 2325 10 32 or2_x1
xsubckt_1032_nexor2_x0 83 82 2376 2377 2375 nexor2_x0
xsubckt_318_and2_x1 83 82 633 634 639 and2_x1
xsubckt_1803_and2_x1 83 82 1623 1666 802 and2_x1
xfeed_1260 83 82 tie
xfeed_21 83 82 tie
xsubckt_658_nexor2_x0 83 82 317 320 316 nexor2_x0
xsubckt_1638_nand2_x0 83 82 1785 251 892 nand2_x0
xfeed_1267 83 82 tie
xfeed_699 83 82 decap_w0
xfeed_26 83 82 tie
xsubckt_1182_nand3_x0 83 82 2232 686 828 865 nand3_x0
xsubckt_1168_nand3_x0 83 82 2246 673 824 250 nand3_x0
xsubckt_1158_and21nor_x0 83 82 2255 2262 2260 2256 and21nor_x0
xsubckt_310_nand3_x0 83 82 641 645 647 2700 nand3_x0
xsubckt_1456_nexor2_x0 83 82 1969 858 1963 nexor2_x0
xfeed_1266 83 82 tie
xfeed_698 83 82 decap_w0
xsubckt_1178_and2_x1 83 82 2236 2237 683 and2_x1
xsubckt_1119_or21nand_x0 83 82 2293 2317 2307 2300 or21nand_x0
xsubckt_779_or2_x1 83 82 2615 50 73 or2_x1
xsubckt_321_and21nor_x0 83 82 630 675 632 631 and21nor_x0
xsubckt_1457_nexor2_x0 83 82 1969 67 1962 nexor2_x0
xsubckt_1927_nand3_x0 83 82 1503 2206 2284 868 nand3_x0
xsubckt_1937_and21nor_x0 83 82 1493 866 1495 675 and21nor_x0
xfeed_1265 83 82 tie
xdiode_58 83 82 659 diode_w1
xfeed_24 83 82 tie
xsubckt_2641_dff_x1 83 82 172 2773 77 dff_x1
xsubckt_1219_or21nand_x0 83 82 2195 2220 2218 2198 or21nand_x0
xsubckt_1130_nand2_x0 83 82 2283 93 90 nand2_x0
xsubckt_1077_mux2_x1 83 82 32 2333 446 122 mux2_x1
xsubckt_772_and2_x1 83 82 2621 2623 2624 and2_x1
xsubckt_47_inv_x0 83 82 91 868 inv_x0
xsubckt_1615_and21nor_x0 83 82 1807 1838 1859 1862 and21nor_x0
xsubckt_2070_and21nor_x0 83 82 1363 1367 1389 828 and21nor_x0
xsubckt_2256_mux2_x1 83 82 90 820 798 1181 mux2_x1
xfeed_1264 83 82 tie
xdiode_59 83 82 659 diode_w1
xfeed_25 83 82 tie
xsubckt_1099_nexor2_x0 83 82 2313 2315 2312 nexor2_x0
xsubckt_1966_and21nor_x0 83 82 1465 1467 1488 824 and21nor_x0
xsubckt_2497_or21nand_x0 83 82 948 85 885 92 or21nand_x0
xdiode_63 83 82 658 diode_w1
xfeed_682 83 82 tie
xsubckt_737_and21nor_x0 83 82 2654 2673 2671 2672 and21nor_x0
xsubckt_489_and3_x1 83 82 474 271 2704 2703 and3_x1
xsubckt_1517_and2_x1 83 82 1903 1954 842 and2_x1
xsubckt_1999_nand3_x0 83 82 1433 626 66 248 nand3_x0
xsubckt_2003_or21nand_x0 83 82 1429 1438 1434 1432 or21nand_x0
xsubckt_2010_nand2_x0 83 82 1422 1425 671 nand2_x0
xdiode_62 83 82 658 diode_w1
xfeed_683 83 82 tie
xfeed_16 83 82 tie
xsubckt_2635_dff_x1 83 82 164 2741 69 dff_x1
xsubckt_2009_and2_x1 83 82 1423 1425 671 and2_x1
xdiode_61 83 82 659 diode_w1
xfeed_680 83 82 tie
xsubckt_72_inv_x0 83 82 75 843 inv_x0
xsubckt_1813_nand2_x0 83 82 1614 251 56 nand2_x0
xsubckt_2126_nand2_x0 83 82 1308 1996 2275 nand2_x0
xsubckt_2324_and21nor_x0 83 82 1115 1116 1121 684 and21nor_x0
xsubckt_2472_mux2_x1 83 82 90 808 798 971 mux2_x1
xsubckt_2489_or21nand_x0 83 82 955 978 984 985 or21nand_x0
xdiode_60 83 82 659 diode_w1
xfeed_681 83 82 tie
xfeed_14 83 82 tie
xsubckt_2611_dff_x1 83 82 178 2743 249 dff_x1
xsubckt_1142_nand2_x0 83 82 2271 2272 2273 nand2_x0
xsubckt_1531_and21nor_x0 83 82 1889 659 1904 1890 and21nor_x0
xsubckt_1789_nexor2_x0 83 82 1648 74 1637 nexor2_x0
xsubckt_1950_and2_x1 83 82 1481 1482 624 and2_x1
xdiode_89 83 82 673 diode_w1
xdiode_67 83 82 250 diode_w1
xfeed_686 83 82 tie
xfeed_13 83 82 tie
xsubckt_1266_or21nand_x0 83 82 2149 2150 2151 658 or21nand_x0
xsubckt_1002_and21nor_x0 83 82 2403 2442 2409 2405 and21nor_x0
xsubckt_849_nand2_x0 83 82 125 2550 2565 nand2_x0
xsubckt_671_nexor2_x0 83 82 305 308 304 nexor2_x0
xsubckt_1934_nand4_x0 83 82 1496 93 14 867 868 nand4_x0
xdiode_88 83 82 868 diode_w1
xdiode_66 83 82 250 diode_w1
xfeed_687 83 82 tie
xsubckt_1080_and2_x1 83 82 2330 10 33 and2_x1
xsubckt_1376_and2_x1 83 82 2041 2042 2045 and2_x1
xdiode_65 83 82 250 diode_w1
xfeed_749 83 82 tie
xfeed_684 83 82 tie
xsubckt_894_nand2_x0 83 82 2507 37 24 nand2_x0
xsubckt_186_and21nor_x0 83 82 202 747 748 914 and21nor_x0
xsubckt_1989_and3_x1 83 82 1443 673 859 250 and3_x1
xsubckt_2027_and21nor_x0 83 82 1405 1407 1410 674 and21nor_x0
xsubckt_2293_and2_x1 83 82 1145 1151 24 and2_x1
xdiode_64 83 82 250 diode_w1
xfeed_748 83 82 tie
xfeed_685 83 82 tie
xsubckt_455_and3_x1 83 82 504 2695 2694 2693 and3_x1
xsubckt_1481_and21nor_x0 83 82 1938 659 1955 1939 and21nor_x0
xsubckt_1518_nexor2_x0 83 82 1954 42 1902 nexor2_x0
xsubckt_1594_nand3_x0 83 82 1828 626 810 248 nand3_x0
xdiode_85 83 82 866 diode_w1
xfeed_747 83 82 decap_w0
xsubckt_2632_dff_x1 83 82 173 2745 78 dff_x1
xsubckt_1128_nand3_x0 83 82 2285 93 867 91 nand3_x0
xsubckt_1020_nand2_x0 83 82 2386 0 34 nand2_x0
xsubckt_92_inv_x0 83 82 26 823 inv_x0
xsubckt_2192_and2_x1 83 82 1244 1245 437 and2_x1
xsubckt_2506_and3_x1 83 82 943 92 86 886 and3_x1
xdiode_84 83 82 866 diode_w1
xfeed_746 83 82 decap_w0
xsubckt_2604_dff_x1 83 82 235 2780 251 dff_x1
xsubckt_796_xor2_x0 83 82 49 72 2599 xor2_x0
xsubckt_735_and2_x1 83 82 2656 53 73 and2_x1
xsubckt_367_nand2_x0 83 82 586 587 593 nand2_x0
xsubckt_1548_nand2_x0 83 82 1873 1875 437 nand2_x0
xsubckt_1617_and4_x1 83 82 1805 1954 838 840 842 and4_x1
xsubckt_2037_nand4_x0 83 82 1395 93 6 867 868 nand4_x0
xsubckt_2355_nexor2_x0 83 82 1086 1100 1084 nexor2_x0
xsubckt_2442_nand4_x0 83 82 1000 1008 1009 1010 34 nand4_x0
xdiode_87 83 82 868 diode_w1
xdiode_69 83 82 250 diode_w1
xfeed_745 83 82 tie
xfeed_688 83 82 tie
xsubckt_967_and2_x1 83 82 2437 2 25 and2_x1
xsubckt_2042_and2_x1 83 82 133 1391 1400 and2_x1
xsubckt_2108_nor2_x0 83 82 1326 1327 1329 nor2_x0
xdiode_86 83 82 868 diode_w1
xdiode_68 83 82 250 diode_w1
xfeed_744 83 82 decap_w0
xfeed_689 83 82 tie
xsubckt_1110_or2_x1 83 82 120 2302 2365 or2_x1
xdiode_81 83 82 867 diode_w1
xfeed_743 83 82 decap_w0
xsubckt_1280_and21nor_x0 83 82 2136 248 249 30 and21nor_x0
xsubckt_1028_nor2_x0 83 82 2379 13 36 nor2_x0
xsubckt_751_and21nor_x0 83 82 2641 436 2643 2642 and21nor_x0
xsubckt_626_nexor2_x0 83 82 348 351 347 nexor2_x0
xsubckt_1359_nexor2_x0 83 82 2063 69 2058 nexor2_x0
xsubckt_1740_or2_x1 83 82 1685 1718 806 or2_x1
xsubckt_2114_nand3_x0 83 82 1320 1325 1340 28 nand3_x0
xsubckt_2372_and2_x1 83 82 1068 1073 36 and2_x1
xsubckt_2480_and2_x1 83 82 963 251 16 and2_x1
xdiode_80 83 82 867 diode_w1
xfeed_742 83 82 tie
xsubckt_663_or2_x1 83 82 312 74 75 or2_x1
xsubckt_1351_nand2_x0 83 82 2066 2069 671 nand2_x0
xsubckt_1798_nexor2_x0 83 82 1671 50 1628 nexor2_x0
xsubckt_1817_nexor2_x0 83 82 1613 839 1610 nexor2_x0
xsubckt_1836_and21nor_x0 83 82 1591 659 1607 1592 and21nor_x0
xsubckt_2527_mux2_x1 83 82 94 33 943 931 mux2_x1
xdiode_83 83 82 866 diode_w1
xfeed_741 83 82 tie
xfeed_19 83 82 tie
xsubckt_802_nand3_x0 83 82 2593 2609 2623 2624 nand3_x0
xsubckt_714_nexor2_x0 83 82 2677 2680 2676 nexor2_x0
xsubckt_226_nand3_x0 83 82 719 103 885 85 nand3_x0
xsubckt_191_nand2_x0 83 82 743 753 20 nand2_x0
xsubckt_530_and2_x1 83 82 438 646 249 and2_x1
xsubckt_1938_and21nor_x0 83 82 1492 1493 1504 251 and21nor_x0
xsubckt_2323_and2_x1 83 82 1116 1122 1198 and2_x1
xsubckt_2492_or21nand_x0 83 82 952 953 954 956 or21nand_x0
xdiode_82 83 82 867 diode_w1
xfeed_740 83 82 tie
xfeed_18 83 82 tie
xsubckt_1087_xor2_x0 83 82 10 32 2323 xor2_x0
xsubckt_1069_xor2_x0 83 82 11 32 2340 xor2_x0
xsubckt_1005_and21nor_x0 83 82 112 446 2412 2401 and21nor_x0
xsubckt_687_nexor2_x0 83 82 73 74 289 nexor2_x0
xsubckt_1896_nand4_x0 83 82 1534 67 250 864 248 nand4_x0
xsubckt_1922_and3_x1 83 82 1508 1509 1511 1513 and3_x1
xfeed_1043 83 82 decap_w0
xfeed_589 83 82 tie
xfeed_480 83 82 tie
xfeed_156 83 82 tie
xsubckt_172_and2_x1 83 82 757 57 2725 and2_x1
xsubckt_1_inv_x0 83 82 2727 914 inv_x0
xfeed_1042 83 82 tie
xfeed_588 83 82 tie
xfeed_481 83 82 tie
xfeed_157 83 82 tie
xsubckt_1216_and3_x1 83 82 2198 2252 2270 799 and3_x1
xsubckt_1105_nand3_x0 83 82 2306 2308 2315 2325 nand3_x0
xsubckt_901_or21nand_x0 83 82 2500 2519 2517 2518 or21nand_x0
xsubckt_20_inv_x0 83 82 2685 895 inv_x0
xsubckt_1905_and2_x1 83 82 1525 1526 437 and2_x1
xsubckt_2096_nand3_x0 83 82 1338 2269 845 863 nand3_x0
xsubckt_2444_nand2_x0 83 82 998 1006 810 nand2_x0
xsubckt_2548_and2_x1 83 82 919 920 922 and2_x1
xfeed_1041 83 82 tie
xfeed_482 83 82 tie
xfeed_468 83 82 tie
xfeed_154 83 82 tie
xsubckt_1220_and21nor_x0 83 82 2194 2195 2196 674 and21nor_x0
xsubckt_897_nexor2_x0 83 82 2506 2508 2504 nexor2_x0
xsubckt_879_nexor2_x0 83 82 2522 2525 2521 nexor2_x0
xfeed_1040 83 82 tie
xfeed_483 83 82 decap_w0
xfeed_469 83 82 tie
xsubckt_1247_and21nor_x0 83 82 2168 2251 2221 2224 and21nor_x0
xsubckt_1231_nand3_x0 83 82 2184 626 827 248 nand3_x0
xsubckt_40_inv_x0 83 82 2698 875 inv_x0
xsubckt_1733_or21nand_x0 83 82 1691 1752 1758 1759 or21nand_x0
xsubckt_1925_nand3_x0 83 82 1505 1511 1513 1549 nand3_x0
xfeed_1047 83 82 tie
xfeed_839 83 82 decap_w0
xfeed_484 83 82 decap_w0
xfeed_152 83 82 tie
xsubckt_2672_dff_x1 83 82 143 2756 40 dff_x1
xsubckt_2584_dff_x1 83 82 197 2774 17 dff_x1
xsubckt_1037_and21nor_x0 83 82 2370 2388 2386 2387 and21nor_x0
xsubckt_969_nexor2_x0 83 82 2436 2439 2435 nexor2_x0
xsubckt_1980_and2_x1 83 82 1451 2283 31 and2_x1
xsubckt_2531_mux2_x1 83 82 108 65 943 929 mux2_x1
xfeed_1046 83 82 decap_w0
xfeed_838 83 82 tie
xfeed_485 83 82 decap_w0
xfeed_153 83 82 tie
xsubckt_919_or2_x1 83 82 2483 4 27 or2_x1
xsubckt_476_nor3_x0 83 82 485 701 869 2701 nor3_x0
xsubckt_2148_nand3_x0 83 82 1287 646 851 249 nand3_x0
xfeed_1045 83 82 decap_w0
xfeed_486 83 82 decap_w0
xfeed_150 83 82 tie
xsubckt_469_and21nor_x0 83 82 491 492 493 506 and21nor_x0
xsubckt_1552_nand2_x0 83 82 1869 1871 1887 nand2_x0
xsubckt_1979_and4_x1 83 82 1452 2154 2156 2284 868 and4_x1
xsubckt_2467_nand2_x0 83 82 976 977 983 nand2_x0
xsubckt_2545_nand3_x0 83 82 922 796 86 886 nand3_x0
xfeed_1044 83 82 decap_w0
xfeed_487 83 82 tie
xfeed_151 83 82 tie
xsubckt_1210_nand4_x0 83 82 2204 2205 93 867 91 nand4_x0
xsubckt_1198_nand3_x0 83 82 2216 2217 2219 2250 nand3_x0
xsubckt_669_and2_x1 83 82 306 42 65 and2_x1
xsubckt_31_inv_x0 83 82 251 884 inv_x0
xsubckt_1298_and21nor_x0 83 82 2118 2120 2122 2572 and21nor_x0
xsubckt_1753_nand2_x0 83 82 1672 2278 843 nand2_x0
xsubckt_1774_and2_x1 83 82 1652 251 891 and2_x1
xsubckt_1814_mux2_x1 83 82 808 806 557 1613 mux2_x1
xsubckt_2134_and21nor_x0 83 82 1300 659 1311 1301 and21nor_x0
xsubckt_2332_and21nor_x0 83 82 1107 437 1117 1108 and21nor_x0
xfeed_835 83 82 tie
xfeed_488 83 82 tie
xfeed_462 83 82 decap_w0
xsubckt_666_nexor2_x0 83 82 310 313 309 nexor2_x0
xsubckt_81_inv_x0 83 82 51 834 inv_x0
xsubckt_1411_and21nor_x0 83 82 2007 2049 2057 2060 and21nor_x0
xsubckt_1775_nand3_x0 83 82 1651 673 33 250 nand3_x0
xsubckt_2014_and3_x1 83 82 1418 1420 1442 821 and3_x1
xsubckt_2199_or21nand_x0 83 82 1237 1239 1243 1255 or21nand_x0
xfeed_834 83 82 decap_w0
xfeed_580 83 82 decap_w0
xfeed_489 83 82 tie
xsubckt_279_nand2_x0 83 82 671 673 250 nand2_x0
xsubckt_1537_nand4_x0 83 82 1884 32 250 249 248 nand4_x0
xsubckt_2409_nexor2_x0 83 82 1034 1035 1032 nexor2_x0
xsubckt_2455_and21nor_x0 83 82 137 988 992 1018 and21nor_x0
xfeed_1049 83 82 decap_w0
xfeed_837 83 82 tie
xfeed_583 83 82 tie
xfeed_460 83 82 tie
xsubckt_2609_dff_x1 83 82 215 2780 92 dff_x1
xsubckt_1140_nand3_x0 83 82 2273 93 861 868 nand3_x0
xsubckt_1066_or21nand_x0 83 82 2343 435 2345 2344 or21nand_x0
xsubckt_1014_nexor2_x0 83 82 0 37 2392 nexor2_x0
xsubckt_794_and2_x1 83 82 2601 49 72 and2_x1
xsubckt_674_and21nor_x0 83 82 301 320 319 318 and21nor_x0
xsubckt_213_nand3_x0 83 82 728 99 86 85 nand3_x0
xsubckt_1535_nand3_x0 83 82 1886 2269 33 863 nand3_x0
xsubckt_2053_nand3_x0 83 82 1380 626 65 248 nand3_x0
xsubckt_2109_or2_x1 83 82 1325 1327 1329 or2_x1
xfeed_1048 83 82 decap_w0
xfeed_836 83 82 tie
xfeed_582 83 82 tie
xfeed_461 83 82 tie
xsubckt_2646_dff_x1 83 82 167 2779 72 dff_x1
xsubckt_659_nand2_x0 83 82 315 316 442 nand2_x0
xsubckt_235_and21nor_x0 83 82 712 714 2699 2698 and21nor_x0
xsubckt_580_or2_x1 83 82 391 393 396 or2_x1
xsubckt_1464_nexor2_x0 83 82 1957 1962 1955 nexor2_x0
xsubckt_1850_nand2_x0 83 82 1578 1579 2285 nand2_x0
xsubckt_2075_and21nor_x0 83 82 1358 1408 1411 1414 and21nor_x0
xfeed_831 83 82 tie
xfeed_466 83 82 tie
xspare_buffer_82 83 82 2742 2730 buf_x4
xsubckt_165_and2_x1 83 82 762 263 912 and2_x1
xsubckt_1640_and3_x1 83 82 1783 1784 1832 647 and3_x1
xsubckt_1720_and2_x1 83 82 1704 1708 76 and2_x1
xsubckt_1738_nand2_x0 83 82 1687 251 58 nand2_x0
xfeed_830 83 82 tie
xfeed_467 83 82 tie
xspare_buffer_83 83 82 2713 2709 buf_x4
xsubckt_55_inv_x0 83 82 78 860 inv_x0
xsubckt_1448_and2_x1 83 82 1971 1973 671 and2_x1
xsubckt_2433_or21nand_x0 83 82 1009 248 249 72 or21nand_x0
xfeed_833 83 82 decap_w0
xfeed_464 83 82 tie
xfeed_158 83 82 tie
xspare_buffer_80 83 82 2742 2732 buf_x4
xsubckt_970_and2_x1 83 82 2434 2435 436 and2_x1
xsubckt_90_inv_x0 83 82 14 825 inv_x0
xsubckt_523_and2_x1 83 82 445 857 67 and2_x1
xfeed_832 83 82 tie
xfeed_465 83 82 tie
xfeed_159 83 82 tie
xspare_buffer_81 83 82 2742 2731 buf_x4
xsubckt_1132_nand3_x0 83 82 2281 93 90 91 nand3_x0
xsubckt_1054_nand2_x0 83 82 2354 12 32 nand2_x0
xsubckt_294_nexor2_x0 83 82 657 665 656 nexor2_x0
xsubckt_2115_nexor2_x0 83 82 1324 28 1319 nexor2_x0
xsubckt_2244_mux2_x1 83 82 64 1195 671 1193 mux2_x1
xdiode_119 83 82 247 diode_w1
xdiode_12 83 82 248 diode_w1
xfeed_1227 83 82 decap_w0
xfeed_651 83 82 tie
xsubckt_1249_nand3_x0 83 82 2166 2168 2169 2171 nand3_x0
xsubckt_929_nexor2_x0 83 82 2474 2477 2473 nexor2_x0
xsubckt_1367_and21nor_x0 83 82 2050 2111 2090 2052 and21nor_x0
xsubckt_1406_nand2_x0 83 82 2012 2014 68 nand2_x0
xsubckt_1650_and2_x1 83 82 1773 1774 437 and2_x1
xdiode_118 83 82 247 diode_w1
xdiode_13 83 82 248 diode_w1
xfeed_1226 83 82 decap_w0
xfeed_650 83 82 tie
xdiode_10 83 82 248 diode_w1
xfeed_1225 83 82 decap_w0
xfeed_653 83 82 decap_w0
xsubckt_1679_mux2_x1 83 82 90 847 798 1744 mux2_x1
xdiode_11 83 82 248 diode_w1
xfeed_1224 83 82 decap_w0
xfeed_652 83 82 decap_w0
xsubckt_852_nexor2_x0 83 82 25 26 2547 nexor2_x0
xsubckt_727_and21nor_x0 83 82 2664 288 2683 2665 and21nor_x0
xsubckt_387_nand2_x0 83 82 567 568 675 nand2_x0
xsubckt_1322_nand2_x0 83 82 2094 2096 2286 nand2_x0
xsubckt_1706_and21nor_x0 83 82 1718 250 249 248 and21nor_x0
xsubckt_2147_nand2_x0 83 82 1288 1289 437 nand2_x0
xsubckt_2381_nand2_x0 83 82 1059 1060 675 nand2_x0
xsubckt_2403_and2_x1 83 82 1038 1041 35 and2_x1
xsubckt_2435_and3_x1 83 82 1007 1008 1009 1010 and3_x1
xdiode_16 83 82 248 diode_w1
xfeed_1223 83 82 decap_w0
xfeed_655 83 82 decap_w0
xspare_feed_112 83 82 tie
xsubckt_1997_and2_x1 83 82 1435 1436 624 and2_x1
xsubckt_2402_or2_x1 83 82 1039 1041 812 or2_x1
xdiode_17 83 82 37 diode_w1
xfeed_1222 83 82 decap_w0
xfeed_654 83 82 decap_w0
xspare_feed_113 83 82 tie
xsubckt_77_inv_x0 83 82 40 838 inv_x0
xsubckt_1413_nexor2_x0 83 82 2007 2009 2005 nexor2_x0
xsubckt_2005_and2_x1 83 82 1427 1428 437 and2_x1
xsubckt_2190_or21nand_x0 83 82 1246 1251 1249 1247 or21nand_x0
xdiode_14 83 82 248 diode_w1
xfeed_1221 83 82 decap_w0
xfeed_657 83 82 tie
xspare_feed_110 83 82 tie
xsubckt_1039_or21nand_x0 83 82 2368 2370 2371 442 or21nand_x0
xsubckt_384_and21nor_x0 83 82 570 591 598 601 and21nor_x0
xsubckt_595_or21nand_x0 83 82 149 377 383 390 or21nand_x0
xsubckt_1627_nexor2_x0 83 82 1849 807 1795 nexor2_x0
xsubckt_2382_and21nor_x0 83 82 1058 1097 1100 1104 and21nor_x0
xdiode_15 83 82 248 diode_w1
xfeed_1220 83 82 tie
xfeed_656 83 82 tie
xspare_feed_111 83 82 decap_w0
xsubckt_2606_dff_x1 83 82 238 2743 271 dff_x1
xsubckt_1052_and21nor_x0 83 82 2356 2370 2371 2372 and21nor_x0
xsubckt_965_or21nand_x0 83 82 2439 2457 2456 2455 or21nand_x0
xsubckt_930_nand2_x0 83 82 2472 2473 442 nand2_x0
xsubckt_261_nexor2_x0 83 82 690 867 687 nexor2_x0
xsubckt_563_nand2_x0 83 82 407 70 47 nand2_x0
xsubckt_1522_or21nand_x0 83 82 1898 2274 1902 1899 or21nand_x0
xsubckt_2040_or21nand_x0 83 82 1392 1393 1396 884 or21nand_x0
xsubckt_2356_nand2_x0 83 82 1083 1084 675 nand2_x0
xdiode_111 83 82 447 diode_w1
xfeed_659 83 82 tie
xsubckt_1048_xor2_x0 83 82 12 35 2360 xor2_x0
xsubckt_312_nexor2_x0 83 82 644 872 639 nexor2_x0
xsubckt_1336_nand4_x0 83 82 2081 2083 2084 2085 647 nand4_x0
xsubckt_1352_and21nor_x0 83 82 2065 2073 2071 2066 and21nor_x0
xsubckt_2111_and21nor_x0 83 82 1323 1325 1340 826 and21nor_x0
xsubckt_2485_nand4_x0 83 82 959 93 800 867 868 nand4_x0
xdiode_110 83 82 446 diode_w1
xfeed_658 83 82 tie
xsubckt_51_inv_x0 83 82 249 864 inv_x0
xsubckt_453_and3_x1 83 82 506 702 110 883 and3_x1
xsubckt_2193_and2_x1 83 82 1243 1244 1246 and2_x1
xsubckt_2540_and2_x1 83 82 227 925 2721 and2_x1
xdiode_113 83 82 447 diode_w1
xdiode_18 83 82 37 diode_w1
xsubckt_2656_dff_x1 83 82 127 2767 24 dff_x1
xsubckt_1711_nand3_x0 83 82 1713 646 34 249 nand3_x0
xsubckt_2073_nexor2_x0 83 82 1366 29 1360 nexor2_x0
xsubckt_2150_and2_x1 83 82 1285 1287 671 and2_x1
xsubckt_2373_nand2_x0 83 82 1067 1073 36 nand2_x0
xdiode_112 83 82 447 diode_w1
xdiode_19 83 82 37 diode_w1
xsubckt_918_or21nand_x0 83 82 2484 2503 2500 2502 or21nand_x0
xsubckt_136_or21nand_x0 83 82 782 269 790 903 or21nand_x0
xsubckt_457_nand2_x0 83 82 502 504 527 nand2_x0
xsubckt_614_nexor2_x0 83 82 359 360 358 nexor2_x0
xsubckt_615_nand2_x0 83 82 357 358 442 nand2_x0
xsubckt_1751_and21nor_x0 83 82 1674 1701 1696 1700 and21nor_x0
xsubckt_2060_nand2_x0 83 82 1373 1375 437 nand2_x0
xsubckt_2241_and2_x1 83 82 1196 1197 671 and2_x1
xsubckt_2363_mux2_x1 83 82 839 1080 683 1077 mux2_x1
xsubckt_2495_mux2_x1 83 82 950 952 674 949 mux2_x1
xdiode_115 83 82 65 diode_w1
xsubckt_2575_dff_x1 83 82 206 2774 58 dff_x1
xsubckt_809_and21nor_x0 83 82 2586 2587 2594 447 and21nor_x0
xsubckt_773_nand2_x0 83 82 2620 2623 2624 nand2_x0
xsubckt_654_or21nand_x0 83 82 320 344 343 342 or21nand_x0
xsubckt_1382_and2_x1 83 82 2035 2036 866 and2_x1
xsubckt_1954_nand2_x0 83 82 1477 1479 683 nand2_x0
xsubckt_2512_and2_x1 83 82 233 939 2715 and2_x1
xdiode_114 83 82 65 diode_w1
xsubckt_2693_dff_x1 83 82 120 2764 9 dff_x1
xsubckt_1097_nexor2_x0 83 82 9 32 2314 nexor2_x0
xsubckt_848_or21nand_x0 83 82 2550 2551 2557 446 or21nand_x0
xsubckt_726_nand3_x0 83 82 2665 2666 558 247 nand3_x0
xsubckt_1673_and2_x1 83 82 1750 1751 1757 and2_x1
xsubckt_1719_nand2_x0 83 82 1705 1707 845 nand2_x0
xdiode_117 83 82 76 diode_w1
xfeed_1229 83 82 decap_w0
xsubckt_2577_dff_x1 83 82 204 2774 56 dff_x1
xsubckt_979_mux2_x1 83 82 2426 2440 447 113 mux2_x1
xsubckt_1343_and21nor_x0 83 82 2074 2081 2079 2075 and21nor_x0
xsubckt_1570_nand2_x0 83 82 1851 1852 2285 nand2_x0
xsubckt_2237_nand3_x0 83 82 1200 686 845 865 nand3_x0
xdiode_116 83 82 76 diode_w1
xfeed_1228 83 82 decap_w0
xsubckt_1074_and21nor_x0 83 82 2335 2339 2340 441 and21nor_x0
xsubckt_1846_nexor2_x0 83 82 1606 831 1582 nexor2_x0
xsubckt_2230_and2_x1 83 82 1207 72 248 and2_x1
xfeed_538 83 82 tie
xfeed_314 83 82 tie
xfeed_105 83 82 decap_w0
xspare_buffer_33 83 82 2781 2770 buf_x4
xsubckt_1240_or21nand_x0 83 82 2175 2178 2192 71 or21nand_x0
xsubckt_1112_xor2_x0 83 82 8 32 2300 xor2_x0
xsubckt_219_nand3_x0 83 82 724 97 86 85 nand3_x0
xsubckt_12_inv_x0 83 82 2689 903 inv_x0
xsubckt_408_nand3_x0 83 82 547 550 552 577 nand3_x0
xsubckt_1360_nexor2_x0 83 82 2063 859 2057 nexor2_x0
xsubckt_2343_nexor2_x0 83 82 1098 1099 1096 nexor2_x0
xsubckt_2474_nand4_x0 83 82 969 93 832 867 91 nand4_x0
xfeed_1033 83 82 tie
xfeed_539 83 82 decap_w0
xfeed_315 83 82 tie
xfeed_104 83 82 tie
xspare_buffer_32 83 82 2781 2771 buf_x4
xsubckt_832_nexor2_x0 83 82 2574 823 2566 nexor2_x0
xsubckt_200_nand2_x0 83 82 737 753 17 nand2_x0
xsubckt_1454_and21nor_x0 83 82 1965 1970 1985 858 and21nor_x0
xsubckt_1835_or2_x1 83 82 1592 1593 675 or2_x1
xsubckt_2341_or21nand_x0 83 82 1098 1145 1134 1142 or21nand_x0
xsubckt_2417_nand2_x0 83 82 1024 1025 674 nand2_x0
xfeed_1030 83 82 decap_w0
xfeed_969 83 82 decap_w0
xfeed_107 83 82 decap_w0
xspare_buffer_31 83 82 2728 2725 buf_x4
xsubckt_853_nexor2_x0 83 82 2547 2549 2546 nexor2_x0
xsubckt_245_or21nand_x0 83 82 702 878 709 707 or21nand_x0
xsubckt_1707_nand2_x0 83 82 1717 1718 814 nand2_x0
xsubckt_1868_nand4_x0 83 82 1561 857 250 864 248 nand4_x0
xsubckt_2056_and21nor_x0 83 82 1377 1384 1382 1378 and21nor_x0
xsubckt_2424_and2_x1 83 82 1018 251 887 and2_x1
xfeed_968 83 82 decap_w0
xfeed_106 83 82 decap_w0
xspare_buffer_30 83 82 2781 2772 buf_x4
xsubckt_2677_dff_x1 83 82 152 2764 49 dff_x1
xsubckt_2581_dff_x1 83 82 200 2778 20 dff_x1
xsubckt_1450_mux2_x1 83 82 26 1972 671 1969 mux2_x1
xsubckt_1554_nand3_x0 83 82 1867 673 24 250 nand3_x0
xsubckt_1557_and21nor_x0 83 82 1864 1867 1868 851 and21nor_x0
xsubckt_2462_and21nor_x0 83 82 981 991 1002 1005 and21nor_x0
xsubckt_2484_or21nand_x0 83 82 960 2274 1576 961 or21nand_x0
xfeed_1168 83 82 decap_w0
xfeed_1036 83 82 tie
xfeed_310 83 82 decap_w0
xfeed_101 83 82 tie
xfeed_88 83 82 decap_w0
xspare_buffer_37 83 82 2768 2766 buf_x4
xsubckt_41_inv_x0 83 82 2707 874 inv_x0
xsubckt_373_or21nand_x0 83 82 580 589 586 581 or21nand_x0
xsubckt_471_or2_x1 83 82 489 491 2705 or2_x1
xsubckt_1953_and2_x1 83 82 1478 1479 683 and2_x1
xfeed_1169 83 82 decap_w0
xfeed_1037 83 82 decap_w0
xfeed_311 83 82 decap_w0
xfeed_100 83 82 tie
xspare_buffer_36 83 82 2768 2767 buf_x4
xsubckt_134_and3_x1 83 82 244 784 785 792 and3_x1
xsubckt_397_nor3_x0 83 82 558 250 249 248 nor3_x0
xsubckt_1714_and2_x1 83 82 1710 1713 671 and2_x1
xsubckt_2468_and21nor_x0 83 82 975 978 984 658 and21nor_x0
xfeed_1034 83 82 tie
xfeed_312 83 82 decap_w0
xspare_buffer_35 83 82 2728 2724 buf_x4
xsubckt_732_nexor2_x0 83 82 2660 2661 2659 nexor2_x0
xsubckt_98_inv_x0 83 82 5 817 inv_x0
xsubckt_1771_nexor2_x0 83 82 1656 1677 1654 nexor2_x0
xsubckt_1831_or21nand_x0 83 82 1596 868 1597 2290 or21nand_x0
xsubckt_2320_nand2_x0 83 82 1119 1120 1121 nand2_x0
xsubckt_2412_or21nand_x0 83 82 1029 2274 1665 1030 or21nand_x0
xfeed_1035 83 82 tie
xfeed_313 83 82 tie
xspare_buffer_34 83 82 2781 2769 buf_x4
xsubckt_1149_and4_x1 83 82 2264 26 250 249 248 and4_x1
xsubckt_438_and2_x1 83 82 519 520 675 and2_x1
xfeed_1164 83 82 decap_w0
xfeed_963 83 82 decap_w0
xfeed_530 83 82 tie
xfeed_84 83 82 tie
xsubckt_2251_nexor2_x0 83 82 1193 820 1186 nexor2_x0
xsubckt_2353_or21nand_x0 83 82 1086 1138 1147 1148 or21nand_x0
xfeed_1165 83 82 decap_w0
xfeed_962 83 82 decap_w0
xfeed_531 83 82 tie
xfeed_85 83 82 tie
xsubckt_2666_dff_x1 83 82 149 2732 46 dff_x1
xsubckt_2594_dff_x1 83 82 226 2780 103 dff_x1
xsubckt_1088_nexor2_x0 83 82 10 32 2322 nexor2_x0
xsubckt_836_and2_x1 83 82 2562 31 14 and2_x1
xsubckt_1407_and3_x1 83 82 2011 2016 2031 68 and3_x1
xfeed_1166 83 82 decap_w0
xfeed_1038 83 82 decap_w0
xfeed_961 83 82 decap_w0
xfeed_532 83 82 tie
xfeed_86 83 82 tie
xspare_buffer_39 83 82 2723 2722 buf_x4
xsubckt_1390_nand2_x0 83 82 2028 2268 28 nand2_x0
xsubckt_1750_or21nand_x0 83 82 1675 1702 1695 1699 or21nand_x0
xsubckt_1808_nand2_x0 83 82 1618 1619 866 nand2_x0
xsubckt_1843_nexor2_x0 83 82 32 72 1585 nexor2_x0
xfeed_1167 83 82 decap_w0
xfeed_1039 83 82 decap_w0
xfeed_960 83 82 decap_w0
xfeed_533 83 82 tie
xfeed_87 83 82 tie
xspare_buffer_38 83 82 2768 2765 buf_x4
xsubckt_705_and21nor_x0 83 82 144 446 272 286 and21nor_x0
xsubckt_66_inv_x0 83 82 64 849 inv_x0
xsubckt_441_and2_x1 83 82 516 517 518 and2_x1
xsubckt_1882_nand3_x0 83 82 1547 93 830 868 nand3_x0
xsubckt_2425_and2_x1 83 82 1017 1628 2282 and2_x1
xfeed_1160 83 82 decap_w0
xfeed_967 83 82 decap_w0
xfeed_534 83 82 tie
xfeed_318 83 82 tie
xfeed_109 83 82 decap_w0
xfeed_80 83 82 decap_w0
xsubckt_402_nexor2_x0 83 82 558 2696 553 nexor2_x0
xsubckt_1607_and2_x1 83 82 1815 1820 64 and2_x1
xsubckt_1649_nand3_x0 83 82 1774 686 810 865 nand3_x0
xsubckt_2090_and21nor_x0 83 82 1343 1344 1346 675 and21nor_x0
xsubckt_2201_nand2_x0 83 82 1235 1237 823 nand2_x0
xsubckt_2393_and21nor_x0 83 82 1047 659 1056 1048 and21nor_x0
xfeed_1161 83 82 decap_w0
xfeed_966 83 82 decap_w0
xfeed_535 83 82 tie
xfeed_319 83 82 decap_w0
xfeed_108 83 82 decap_w0
xfeed_81 83 82 decap_w0
xsubckt_2631_dff_x1 83 82 174 2745 79 dff_x1
xsubckt_864_xor2_x0 83 82 7 27 2535 xor2_x0
xsubckt_710_or21nand_x0 83 82 2680 285 282 284 or21nand_x0
xsubckt_267_nexor2_x0 83 82 686 248 682 nexor2_x0
xsubckt_252_and2_x1 83 82 695 696 870 and2_x1
xsubckt_33_inv_x0 83 82 2703 882 inv_x0
xsubckt_537_nand3_x0 83 82 431 433 439 55 nand3_x0
xsubckt_1559_and3_x1 83 82 1862 1867 1868 65 and3_x1
xsubckt_1678_nand4_x0 83 82 1745 93 13 90 91 nand4_x0
xfeed_1162 83 82 decap_w0
xfeed_965 83 82 decap_w0
xfeed_536 83 82 tie
xfeed_82 83 82 decap_w0
xsubckt_2678_dff_x1 83 82 151 2764 48 dff_x1
xsubckt_909_nexor2_x0 83 82 2493 2494 2492 nexor2_x0
xsubckt_1876_and2_x1 83 82 1553 1554 671 and2_x1
xsubckt_2039_nand3_x0 83 82 1393 1394 1395 866 nand3_x0
xsubckt_2560_dff_x1 83 82 237 2772 269 dff_x1
xfeed_1163 83 82 decap_w0
xfeed_964 83 82 decap_w0
xfeed_537 83 82 tie
xfeed_83 83 82 decap_w0
xsubckt_1089_or21nand_x0 83 82 2321 2342 2337 2323 or21nand_x0
xsubckt_576_nor2_x0 83 82 395 64 65 nor2_x0
xsubckt_1294_or21nand_x0 83 82 2122 2130 2127 2125 or21nand_x0
xsubckt_1489_nand4_x0 83 82 1931 812 250 864 248 nand4_x0
xsubckt_2219_and21nor_x0 83 82 1217 2275 1896 1218 and21nor_x0
xsubckt_2264_or21nand_x0 83 82 1173 1225 1234 1235 or21nand_x0
xfeed_1119 83 82 tie
xfeed_978 83 82 decap_w0
xfeed_112 83 82 decap_w0
xspare_buffer_20 83 82 2781 2780 buf_x4
xsubckt_694_or21nand_x0 83 82 282 308 306 307 or21nand_x0
xsubckt_506_mux2_x1 83 82 459 866 883 458 mux2_x1
xsubckt_1662_nand2_x0 83 82 1761 1763 77 nand2_x0
xsubckt_1676_and2_x1 83 82 1747 1805 836 and2_x1
xfeed_1118 83 82 tie
xfeed_979 83 82 decap_w0
xfeed_113 83 82 decap_w0
xspare_buffer_21 83 82 2781 2779 buf_x4
xsubckt_2576_dff_x1 83 82 205 2774 57 dff_x1
xsubckt_1254_or3_x1 83 82 2161 47 54 55 or3_x1
xsubckt_1223_and3_x1 83 82 2192 673 30 250 and3_x1
xsubckt_824_xor2_x0 83 82 28 27 2573 xor2_x0
xsubckt_379_nexor2_x0 83 82 673 2697 575 nexor2_x0
xsubckt_1545_nand3_x0 83 82 1876 1878 1879 683 nand3_x0
xfeed_363 83 82 tie
xfeed_110 83 82 decap_w0
xspare_buffer_22 83 82 2781 2778 buf_x4
xsubckt_2612_dff_x1 83 82 177 2743 248 dff_x1
xsubckt_414_nand2_x0 83 82 541 543 552 nand2_x0
xsubckt_1361_or21nand_x0 83 82 2056 2109 2114 2115 or21nand_x0
xfeed_111 83 82 decap_w0
xspare_buffer_23 83 82 2728 2727 buf_x4
xsubckt_787_xor2_x0 83 82 50 72 2607 xor2_x0
xsubckt_105_inv_x0 83 82 34 810 inv_x0
xsubckt_1427_and21nor_x0 83 82 1991 1992 1998 675 and21nor_x0
xsubckt_1913_or21nand_x0 83 82 1517 1520 1541 38 or21nand_x0
xsubckt_2249_nand3_x0 83 82 1188 1194 1210 25 nand3_x0
xsubckt_2521_mux2_x1 83 82 97 36 943 934 mux2_x1
xfeed_116 83 82 tie
xfeed_8 83 82 tie
xspare_buffer_24 83 82 2781 2777 buf_x4
xsubckt_1125_and3_x1 83 82 2288 93 867 868 and3_x1
xsubckt_1090_nand3_x0 83 82 2320 2322 2336 2341 nand3_x0
xsubckt_2456_mux2_x1 83 82 839 837 557 987 mux2_x1
xfeed_364 83 82 tie
xfeed_117 83 82 tie
xfeed_9 83 82 tie
xspare_buffer_25 83 82 2781 2776 buf_x4
xsubckt_875_and21nor_x0 83 82 2525 2538 2537 2536 and21nor_x0
xsubckt_641_and2_x1 83 82 333 75 76 and2_x1
xsubckt_413_or21nand_x0 83 82 542 576 570 544 or21nand_x0
xsubckt_1677_nexor2_x0 83 82 1805 53 1746 nexor2_x0
xdiode_29 83 82 251 diode_w1
xfeed_648 83 82 decap_w0
xfeed_114 83 82 decap_w0
xspare_buffer_26 83 82 2781 2775 buf_x4
xsubckt_1117_or2_x1 83 82 2295 2296 2297 or2_x1
xsubckt_1307_or21nand_x0 83 82 2109 2146 2170 2171 or21nand_x0
xsubckt_2185_and4_x1 83 82 1251 1252 1253 1254 647 and4_x1
xsubckt_2336_nand3_x0 83 82 1103 1106 1110 37 nand3_x0
xdiode_28 83 82 251 diode_w1
xfeed_649 83 82 tie
xfeed_115 83 82 decap_w0
xspare_buffer_27 83 82 2728 2726 buf_x4
xsubckt_1009_or21nand_x0 83 82 2397 2408 2403 2399 or21nand_x0
xsubckt_1883_nand2_x0 83 82 1546 2280 861 nand2_x0
xsubckt_2476_nand3_x0 83 82 967 968 969 866 nand3_x0
xdiode_27 83 82 251 diode_w1
xfeed_1111 83 82 decap_w0
xfeed_970 83 82 decap_w0
xfeed_646 83 82 decap_w0
xfeed_369 83 82 tie
xfeed_4 83 82 tie
xspare_buffer_28 83 82 2781 2774 buf_x4
xsubckt_2669_dff_x1 83 82 146 2738 43 dff_x1
xsubckt_2571_dff_x1 83 82 210 2772 62 dff_x1
xsubckt_668_or2_x1 83 82 307 42 65 or2_x1
xsubckt_492_and21nor_x0 83 82 471 473 528 675 and21nor_x0
xsubckt_1451_nand2_x0 83 82 1968 1970 1985 nand2_x0
xsubckt_2386_mux2_x1 83 82 867 36 798 1054 mux2_x1
xdiode_26 83 82 884 diode_w1
xfeed_1110 83 82 decap_w0
xfeed_971 83 82 decap_w0
xfeed_647 83 82 decap_w0
xfeed_5 83 82 tie
xspare_buffer_29 83 82 2781 2773 buf_x4
xsubckt_1513_nand2_x0 83 82 1907 1908 675 nand2_x0
xsubckt_1611_nexor2_x0 83 82 1820 64 1811 nexor2_x0
xsubckt_2129_and21nor_x0 83 82 1305 2282 2003 1306 and21nor_x0
xsubckt_2526_and2_x1 83 82 218 932 2727 and2_x1
xdiode_25 83 82 884 diode_w1
xfeed_1113 83 82 decap_w0
xfeed_972 83 82 decap_w0
xfeed_644 83 82 decap_w0
xfeed_6 83 82 tie
xsubckt_933_and21nor_x0 83 82 115 446 2471 2470 and21nor_x0
xsubckt_296_and21nor_x0 83 82 654 659 656 655 and21nor_x0
xsubckt_94_inv_x0 83 82 30 821 inv_x0
xsubckt_371_nand2_x0 83 82 582 583 884 nand2_x0
xsubckt_2117_and21nor_x0 83 82 1317 1358 1361 1365 and21nor_x0
xsubckt_2321_nand3_x0 83 82 1118 686 841 865 nand3_x0
xdiode_24 83 82 25 diode_w1
xfeed_1112 83 82 decap_w0
xfeed_973 83 82 tie
xfeed_645 83 82 decap_w0
xfeed_119 83 82 decap_w0
xsubckt_2633_dff_x1 83 82 166 2735 71 dff_x1
xsubckt_1277_and4_x1 83 82 2139 820 250 864 248 and4_x1
xsubckt_653_or21nand_x0 83 82 321 844 436 441 or21nand_x0
xsubckt_166_and2_x1 83 82 761 59 2725 and2_x1
xsubckt_411_or21nand_x0 83 82 544 249 248 2697 or21nand_x0
xsubckt_426_nand2_x0 83 82 530 540 556 nand2_x0
xsubckt_1889_and3_x1 83 82 1541 673 71 250 and3_x1
xdiode_23 83 82 25 diode_w1
xfeed_1115 83 82 decap_w0
xfeed_642 83 82 decap_w0
xfeed_0 83 82 decap_w0
xsubckt_2650_dff_x1 83 82 133 2741 30 dff_x1
xsubckt_781_nexor2_x0 83 82 50 73 2613 nexor2_x0
xsubckt_113_inv_x0 83 82 10 802 inv_x0
xsubckt_1716_or21nand_x0 83 82 1708 1715 1709 1711 or21nand_x0
xdiode_22 83 82 93 diode_w1
xfeed_1114 83 82 decap_w0
xfeed_975 83 82 tie
xfeed_643 83 82 decap_w0
xfeed_1 83 82 decap_w0
xsubckt_91_inv_x0 83 82 31 824 inv_x0
xsubckt_2419_or21nand_x0 83 82 1022 1061 1070 1071 or21nand_x0
xdiode_21 83 82 93 diode_w1
xfeed_1117 83 82 decap_w0
xfeed_976 83 82 tie
xfeed_640 83 82 decap_w0
xfeed_2 83 82 tie
xsubckt_32_inv_x0 83 82 2701 883 inv_x0
xsubckt_1864_nand4_x0 83 82 1565 66 250 249 248 nand4_x0
xsubckt_1967_or21nand_x0 83 82 1464 1468 1489 31 or21nand_x0
xsubckt_2261_or21nand_x0 83 82 1176 1182 1180 1177 or21nand_x0
xsubckt_2310_and4_x1 83 82 1128 93 838 867 91 and4_x1
xdiode_20 83 82 93 diode_w1
xfeed_1116 83 82 decap_w0
xfeed_977 83 82 decap_w0
xfeed_641 83 82 decap_w0
xsubckt_1104_and3_x1 83 82 2307 2308 2315 2325 and3_x1
xsubckt_974_nand2_x0 83 82 2430 2 36 nand2_x0
xsubckt_811_or21nand_x0 83 82 2585 2597 2598 2600 or21nand_x0
xsubckt_287_and2_x1 83 82 663 682 873 and2_x1
xsubckt_109_inv_x0 83 82 32 806 inv_x0
xsubckt_1341_and2_x1 83 82 2076 2077 683 and2_x1
xsubckt_2490_and2_x1 83 82 954 955 1585 and2_x1
xfeed_228 83 82 decap_w0
xspare_feed_13 83 82 tie
xsubckt_63_inv_x0 83 82 70 852 inv_x0
xfeed_711 83 82 tie
xfeed_229 83 82 decap_w0
xspare_feed_12 83 82 tie
xsubckt_1358_nand3_x0 83 82 2059 2064 2086 69 nand3_x0
xsubckt_1924_or21nand_x0 83 82 1506 1512 1514 1550 or21nand_x0
xsubckt_1986_and21nor_x0 83 82 1445 1446 1448 675 and21nor_x0
xsubckt_2415_and3_x1 83 82 1026 1027 1028 866 and3_x1
xfeed_712 83 82 tie
xsubckt_954_or2_x1 83 82 2449 3 37 or2_x1
xsubckt_1303_nand2_x0 83 82 2113 2118 70 nand2_x0
xsubckt_1871_nand2_x0 83 82 1558 1559 683 nand2_x0
xsubckt_2184_nand2_x0 83 82 1252 2268 66 nand2_x0
xsubckt_2329_nand3_x0 83 82 1110 673 76 250 nand3_x0
xfeed_713 83 82 tie
xspare_feed_10 83 82 tie
xsubckt_1258_nand4_x0 83 82 2157 2158 2159 2160 2285 nand4_x0
xsubckt_1212_nand2_x0 83 82 2202 2203 2204 nand2_x0
xsubckt_1103_nand3_x0 83 82 2308 2324 2336 2341 nand3_x0
xsubckt_789_or21nand_x0 83 82 2605 2626 2621 2607 or21nand_x0
xsubckt_592_xor2_x0 83 82 46 66 379 xor2_x0
xsubckt_1688_or2_x1 83 82 1735 1736 1742 or2_x1
xsubckt_1860_nexor2_x0 83 82 1569 1585 1568 nexor2_x0
xfeed_714 83 82 tie
xspare_feed_17 83 82 tie
xsubckt_320_nor2_x0 83 82 631 271 2700 nor2_x0
xsubckt_96_inv_x0 83 82 6 819 inv_x0
xsubckt_383_nand3_x0 83 82 571 572 573 659 nand3_x0
xsubckt_433_nexor2_x0 83 82 524 878 523 nexor2_x0
xsubckt_1542_nand3_x0 83 82 1879 626 35 248 nand3_x0
xsubckt_1562_nexor2_x0 83 82 1866 851 1859 nexor2_x0
xsubckt_1801_and2_x1 83 82 1625 1626 2285 and2_x1
xsubckt_2143_nand3_x0 83 82 1292 626 847 248 nand3_x0
xsubckt_2252_or21nand_x0 83 82 1185 1222 1230 1231 or21nand_x0
xsubckt_2385_nand3_x0 83 82 1055 1724 1725 2275 nand3_x0
xsubckt_2392_or2_x1 83 82 1048 1049 251 or2_x1
xfeed_715 83 82 tie
xspare_feed_16 83 82 tie
xsubckt_1466_nexor2_x0 83 82 2004 43 1953 nexor2_x0
xsubckt_1839_nexor2_x0 83 82 1590 1610 1588 nexor2_x0
xfeed_1009 83 82 decap_w0
xfeed_899 83 82 decap_w0
xfeed_716 83 82 tie
xspare_feed_15 83 82 tie
xsubckt_238_or21nand_x0 83 82 709 711 2697 2696 or21nand_x0
xsubckt_115_inv_x0 83 82 8 800 inv_x0
xsubckt_1776_or21nand_x0 83 82 1650 248 249 32 or21nand_x0
xfeed_1008 83 82 decap_w0
xfeed_898 83 82 decap_w0
xfeed_717 83 82 tie
xspare_feed_14 83 82 tie
xsubckt_770_and21nor_x0 83 82 2623 2640 2638 2639 and21nor_x0
xsubckt_1363_nexor2_x0 83 82 2056 2057 2054 nexor2_x0
xsubckt_2340_nexor2_x0 83 82 1105 816 1099 nexor2_x0
xfeed_1007 83 82 decap_w0
xfeed_897 83 82 decap_w0
xfeed_718 83 82 tie
xfeed_220 83 82 decap_w0
xsubckt_1042_nor2_x0 83 82 124 2366 2380 nor2_x0
xsubckt_169_and2_x1 83 82 759 58 2725 and2_x1
xsubckt_1293_and21nor_x0 83 82 2123 2129 2128 2124 and21nor_x0
xsubckt_1739_nand3_x0 83 82 1686 646 33 249 nand3_x0
xfeed_1006 83 82 decap_w0
xfeed_896 83 82 decap_w0
xfeed_719 83 82 decap_w0
xfeed_221 83 82 decap_w0
xsubckt_1098_or21nand_x0 83 82 2313 2332 2330 2331 or21nand_x0
xsubckt_757_and2_x1 83 82 2635 2636 442 and2_x1
xsubckt_464_nand2_x0 83 82 495 497 2706 nand2_x0
xsubckt_1512_nexor2_x0 83 82 1910 1912 1908 nexor2_x0
xsubckt_1709_and4_x1 83 82 1715 1716 1717 1883 437 and4_x1
xfeed_1005 83 82 decap_w0
xfeed_895 83 82 decap_w0
xfeed_222 83 82 tie
xspare_feed_19 83 82 tie
xsubckt_106_inv_x0 83 82 1 809 inv_x0
xsubckt_501_nexor2_x0 83 82 696 2702 462 nexor2_x0
xsubckt_1410_nexor2_x0 83 82 2015 857 2008 nexor2_x0
xsubckt_2137_nand4_x0 83 82 1298 76 250 864 248 nand4_x0
xsubckt_2139_nand2_x0 83 82 1296 2266 841 nand2_x0
xfeed_1004 83 82 decap_w0
xfeed_894 83 82 decap_w0
xfeed_223 83 82 decap_w0
xspare_feed_18 83 82 tie
xsubckt_723_or21nand_x0 83 82 2667 2675 2674 2668 or21nand_x0
xsubckt_707_xor2_x0 83 82 72 73 2683 xor2_x0
xsubckt_254_nexor2_x0 83 82 695 883 693 nexor2_x0
xsubckt_561_and21nor_x0 83 82 409 428 427 426 and21nor_x0
xsubckt_1355_and21nor_x0 83 82 2062 2064 2086 859 and21nor_x0
xsubckt_1702_or21nand_x0 83 82 1722 868 1723 2290 or21nand_x0
xsubckt_2354_and21nor_x0 83 82 1085 1139 1146 1149 and21nor_x0
xsubckt_2421_nexor2_x0 83 82 1022 1036 1020 nexor2_x0
xsubckt_2528_and2_x1 83 82 217 931 2727 and2_x1
xfeed_1003 83 82 decap_w0
xfeed_893 83 82 decap_w0
xfeed_224 83 82 tie
xsubckt_2629_dff_x1 83 82 189 2747 2702 dff_x1
xsubckt_1107_nand2_x0 83 82 2304 2305 442 nand2_x0
xsubckt_1067_and2_x1 83 82 2342 11 32 and2_x1
xsubckt_980_nor2_x0 83 82 2425 1 24 nor2_x0
xsubckt_756_nexor2_x0 83 82 2637 2640 2636 nexor2_x0
xsubckt_2038_nand4_x0 83 82 1394 93 46 867 91 nand4_x0
xfeed_1002 83 82 decap_w0
xfeed_892 83 82 decap_w0
xfeed_225 83 82 decap_w0
xsubckt_1083_and21nor_x0 83 82 2327 802 435 442 and21nor_x0
xsubckt_718_nor2_x0 83 82 2672 40 74 nor2_x0
xsubckt_284_nand2_x0 83 82 666 670 2707 nand2_x0
xsubckt_82_inv_x0 83 82 50 833 inv_x0
xsubckt_1342_nand2_x0 83 82 2075 2077 683 nand2_x0
xsubckt_1804_nexor2_x0 83 82 1666 10 1622 nexor2_x0
xsubckt_2165_or21nand_x0 83 82 1270 1313 1319 1320 or21nand_x0
xsubckt_2390_or3_x1 83 82 1050 1051 1052 271 or3_x1
xsubckt_2405_nexor2_x0 83 82 1041 35 1036 nexor2_x0
xsubckt_2491_or21nand_x0 83 82 953 955 1585 659 or21nand_x0
xfeed_1001 83 82 decap_w0
xfeed_891 83 82 decap_w0
xfeed_226 83 82 decap_w0
xsubckt_1197_nand3_x0 83 82 2217 2225 2246 860 nand3_x0
xsubckt_208_nand3_x0 83 82 731 109 885 85 nand3_x0
xsubckt_2515_mux2_x1 83 82 100 25 943 937 mux2_x1
xfeed_1000 83 82 decap_w0
xfeed_890 83 82 decap_w0
xfeed_227 83 82 decap_w0
xsubckt_2651_dff_x1 83 82 132 2741 29 dff_x1
xsubckt_316_and21nor_x0 83 82 635 662 664 667 and21nor_x0
xsubckt_639_or21nand_x0 83 82 335 371 353 336 or21nand_x0
xsubckt_1313_nand2_x0 83 82 2103 2282 819 nand2_x0
xsubckt_1940_and21nor_x0 83 82 1491 1510 1515 1518 and21nor_x0
xsubckt_2314_and21nor_x0 83 82 1124 659 1133 1125 and21nor_x0
xfeed_927 83 82 decap_w0
xfeed_574 83 82 decap_w0
xfeed_48 83 82 tie
xsubckt_896_or21nand_x0 83 82 2505 2510 2509 2506 or21nand_x0
xsubckt_538_nand3_x0 83 82 430 431 432 446 nand3_x0
xsubckt_1697_or21nand_x0 83 82 1727 2274 1731 1728 or21nand_x0
xfeed_926 83 82 tie
xfeed_575 83 82 decap_w0
xfeed_49 83 82 tie
xsubckt_1206_and2_x1 83 82 2208 2209 658 and2_x1
xsubckt_1205_nand4_x0 83 82 2209 93 856 867 868 nand4_x0
xsubckt_958_nand2_x0 83 82 2445 2446 442 nand2_x0
xsubckt_833_nand2_x0 83 82 2565 2566 447 nand2_x0
xsubckt_59_inv_x0 83 82 54 856 inv_x0
xsubckt_474_and4_x1 83 82 487 2695 2694 2693 2705 and4_x1
xsubckt_1431_nexor2_x0 83 82 1989 2008 1987 nexor2_x0
xsubckt_1533_and3_x1 83 82 1888 646 37 249 and3_x1
xsubckt_1829_and3_x1 83 82 1598 1666 801 802 and3_x1
xsubckt_2307_mux2_x1 83 82 867 24 798 1131 mux2_x1
xfeed_925 83 82 tie
xfeed_576 83 82 decap_w0
xsubckt_488_nor3_x0 83 82 190 475 476 251 nor3_x0
xsubckt_1508_or2_x1 83 82 1912 1914 1916 or2_x1
xfeed_924 83 82 decap_w0
xfeed_577 83 82 decap_w0
xsubckt_992_nand2_x0 83 82 2413 2414 442 nand2_x0
xsubckt_855_and21nor_x0 83 82 2544 2564 2563 2562 and21nor_x0
xsubckt_424_or21nand_x0 83 82 531 692 536 532 or21nand_x0
xsubckt_1675_or2_x1 83 82 1748 1749 1750 or2_x1
xsubckt_1841_or21nand_x0 83 82 168 1587 1591 1614 or21nand_x0
xfeed_923 83 82 decap_w0
xfeed_619 83 82 tie
xfeed_570 83 82 tie
xsubckt_1194_and21nor_x0 83 82 2220 2225 2246 860 and21nor_x0
xsubckt_953_or21nand_x0 83 82 2450 2477 2476 2475 or21nand_x0
xsubckt_52_inv_x0 83 82 250 863 inv_x0
xsubckt_337_or21nand_x0 83 82 615 638 639 643 or21nand_x0
xsubckt_478_and21nor_x0 83 82 483 488 484 485 and21nor_x0
xsubckt_2174_and2_x1 83 82 1261 1262 866 and2_x1
xsubckt_2364_mux2_x1 83 82 74 1078 437 1076 mux2_x1
xfeed_922 83 82 decap_w0
xfeed_618 83 82 tie
xfeed_571 83 82 decap_w0
xsubckt_1096_xor2_x0 83 82 9 32 2315 xor2_x0
xsubckt_339_or2_x1 83 82 613 615 616 or2_x1
xsubckt_1445_nand2_x0 83 82 1974 1975 437 nand2_x0
xsubckt_1577_nand4_x0 83 82 1844 93 840 867 868 nand4_x0
xsubckt_2451_and21nor_x0 83 82 991 1021 1036 1040 and21nor_x0
xfeed_921 83 82 decap_w0
xfeed_572 83 82 tie
xsubckt_1055_xor2_x0 83 82 12 32 2353 xor2_x0
xsubckt_163_and2_x1 83 82 763 60 2725 and2_x1
xsubckt_1493_and21nor_x0 83 82 1927 1932 1930 1928 and21nor_x0
xsubckt_2553_or21nand_x0 83 82 237 269 790 917 or21nand_x0
xsubckt_2556_nand3_x0 83 82 915 884 2725 84 nand3_x0
xfeed_920 83 82 decap_w0
xfeed_573 83 82 decap_w0
xsubckt_828_nand4_x0 83 82 2569 646 38 247 249 nand4_x0
xsubckt_1430_or21nand_x0 83 82 1988 2056 2057 2061 or21nand_x0
xsubckt_1626_nexor2_x0 83 82 1849 0 1796 nexor2_x0
xsubckt_2275_mux2_x1 83 82 841 1165 624 1163 mux2_x1
xfeed_615 83 82 decap_w0
xfeed_40 83 82 tie
xsubckt_921_nexor2_x0 83 82 4 27 2481 nexor2_x0
xsubckt_45_inv_x0 83 82 2702 870 inv_x0
xsubckt_1315_and2_x1 83 82 2101 2102 2103 and2_x1
xsubckt_1385_and21nor_x0 83 82 2032 659 2048 2033 and21nor_x0
xsubckt_1584_nexor2_x0 83 82 1839 1860 1837 nexor2_x0
xsubckt_2183_nand3_x0 83 82 1253 2269 74 863 nand3_x0
xsubckt_2263_or21nand_x0 83 82 1174 658 1183 1175 or21nand_x0
xsubckt_2453_nexor2_x0 83 82 991 997 989 nexor2_x0
xsubckt_2458_nand2_x0 83 82 985 987 33 nand2_x0
xfeed_614 83 82 decap_w0
xfeed_41 83 82 tie
xsubckt_205_and2_x1 83 82 734 86 85 and2_x1
xsubckt_444_and21nor_x0 83 82 514 710 2695 2694 and21nor_x0
xsubckt_2232_nand3_x0 83 82 1205 1206 1208 1209 nand3_x0
xsubckt_2420_and21nor_x0 83 82 1021 1062 1069 1072 and21nor_x0
xfeed_617 83 82 decap_w0
xsubckt_2681_dff_x1 83 82 118 2732 7 dff_x1
xsubckt_1134_nand2_x0 83 82 2279 2280 830 nand2_x0
xsubckt_417_and2_x1 83 82 538 866 2696 and2_x1
xsubckt_1660_and21nor_x0 83 82 1763 1770 1766 1768 and21nor_x0
xsubckt_1736_or21nand_x0 83 82 1688 675 1693 1689 or21nand_x0
xsubckt_2173_nand4_x0 83 82 1262 93 3 867 868 nand4_x0
xfeed_616 83 82 decap_w0
xfeed_43 83 82 tie
xsubckt_1183_and2_x1 83 82 2231 2232 437 and2_x1
xsubckt_570_xor2_x0 83 82 47 67 400 xor2_x0
xsubckt_598_nor2_x0 83 82 374 375 376 nor2_x0
xsubckt_2093_and3_x1 83 82 1341 673 67 250 and3_x1
xsubckt_2502_and2_x1 83 82 234 946 2714 and2_x1
xfeed_611 83 82 decap_w0
xfeed_578 83 82 tie
xsubckt_1172_and3_x1 83 82 2242 2243 2245 647 and3_x1
xsubckt_1153_and2_x1 83 82 2260 2261 624 and2_x1
xsubckt_1086_nand2_x0 83 82 2324 10 32 nand2_x0
xsubckt_1068_nand2_x0 83 82 2341 11 32 nand2_x0
xsubckt_1455_nand2_x0 83 82 1964 1968 67 nand2_x0
xsubckt_1521_and3_x1 83 82 1899 1900 1901 2285 and3_x1
xsubckt_1787_nand4_x0 83 82 1639 1649 1650 1651 841 nand4_x0
xsubckt_1844_xor2_x0 83 82 32 72 1584 xor2_x0
xsubckt_2043_and3_x1 83 82 1390 673 857 250 and3_x1
xsubckt_2331_nand2_x0 83 82 1108 1112 671 nand2_x0
xfeed_610 83 82 decap_w0
xfeed_579 83 82 decap_w0
xsubckt_1270_or21nand_x0 83 82 2145 2198 2218 2219 or21nand_x0
xsubckt_273_and21nor_x0 83 82 676 678 2708 251 and21nor_x0
xsubckt_2446_and21nor_x0 83 82 996 1033 1035 1038 and21nor_x0
xfeed_929 83 82 tie
xfeed_613 83 82 tie
xsubckt_924_or21nand_x0 83 82 2478 815 436 441 or21nand_x0
xsubckt_83_inv_x0 83 82 49 832 inv_x0
xsubckt_475_and2_x1 83 82 486 487 2706 and2_x1
xsubckt_1581_or21nand_x0 83 82 1840 658 1856 1841 or21nand_x0
xsubckt_1651_nand2_x0 83 82 1772 1774 437 nand2_x0
xsubckt_1912_and21nor_x0 83 82 1518 1519 1540 829 and21nor_x0
xfeed_928 83 82 tie
xfeed_612 83 82 tie
xfeed_47 83 82 tie
xsubckt_1135_or21nand_x0 83 82 2278 91 90 93 or21nand_x0
xsubckt_1118_nand3_x0 83 82 2294 2299 2306 2316 nand3_x0
xsubckt_983_or21nand_x0 83 82 2422 2439 2437 2438 or21nand_x0
xsubckt_360_nand3_x0 83 82 593 594 595 659 nand3_x0
xsubckt_2084_or21nand_x0 83 82 1349 2046 2281 2285 or21nand_x0
xsubckt_2132_nand2_x0 83 82 1302 1303 866 nand2_x0
xsubckt_2334_nand2_x0 83 82 1105 1106 1110 nand2_x0
xfeed_277 83 82 tie
xspare_feed_62 83 82 tie
xsubckt_220_nand3_x0 83 82 723 105 885 85 nand3_x0
xfeed_276 83 82 tie
xspare_feed_63 83 82 tie
xsubckt_797_nexor2_x0 83 82 49 72 2598 nexor2_x0
xsubckt_390_and3_x1 83 82 564 565 567 571 and3_x1
xsubckt_604_nand2_x0 83 82 368 45 68 nand2_x0
xfeed_419 83 82 tie
xspare_feed_60 83 82 tie
xsubckt_1218_nand3_x0 83 82 2196 2197 2217 2219 nand3_x0
xsubckt_1189_or21nand_x0 83 82 2225 2234 2230 2228 or21nand_x0
xsubckt_14_inv_x0 83 82 2688 901 inv_x0
xsubckt_1663_and2_x1 83 82 1760 1764 77 and2_x1
xsubckt_1904_nand3_x0 83 82 1526 686 69 865 nand3_x0
xsubckt_2319_or21nand_x0 83 82 1120 686 77 865 or21nand_x0
xsubckt_2337_and21nor_x0 83 82 1102 1106 1110 816 and21nor_x0
xsubckt_2557_nand2_x0 83 82 212 915 750 nand2_x0
xspare_feed_61 83 82 tie
xsubckt_1092_and21nor_x0 83 82 2318 2319 2326 447 and21nor_x0
xsubckt_258_nand3_x0 83 82 689 694 91 110 nand3_x0
xfeed_273 83 82 tie
xspare_feed_66 83 82 tie
xsubckt_78_inv_x0 83 82 72 837 inv_x0
xsubckt_543_and2_x1 83 82 426 71 54 and2_x1
xsubckt_1377_and2_x1 83 82 2040 2097 817 and2_x1
xfeed_272 83 82 tie
xspare_feed_67 83 82 tie
xsubckt_2688_dff_x1 83 82 111 2756 0 dff_x1
xsubckt_788_nexor2_x0 83 82 50 72 2606 nexor2_x0
xsubckt_349_mux2_x1 83 82 604 605 691 603 mux2_x1
xsubckt_509_or21nand_x0 83 82 455 674 469 456 or21nand_x0
xsubckt_1822_nand3_x0 83 82 1605 1671 832 833 nand3_x0
xsubckt_1902_and21nor_x0 83 82 1528 1535 1533 1529 and21nor_x0
xsubckt_2544_and2_x1 83 82 225 923 2727 and2_x1
xfeed_868 83 82 decap_w0
xfeed_271 83 82 tie
xspare_buffer_79 83 82 2713 2710 buf_x4
xspare_feed_64 83 82 tie
xsubckt_1381_nand4_x0 83 82 2036 93 45 867 868 nand4_x0
xsubckt_1744_and2_x1 83 82 1681 1682 75 and2_x1
xsubckt_1748_nexor2_x0 83 82 1682 843 1677 nexor2_x0
xsubckt_2346_or21nand_x0 83 82 1093 2274 1737 1094 or21nand_x0
xsubckt_2399_and3_x1 83 82 1042 1043 1044 1045 and3_x1
xfeed_869 83 82 decap_w0
xfeed_270 83 82 tie
xspare_buffer_78 83 82 2742 2733 buf_x4
xsubckt_198_and21nor_x0 83 82 198 739 740 914 and21nor_x0
xsubckt_1921_nand3_x0 83 82 1509 1552 1566 39 nand3_x0
xsubckt_2057_or21nand_x0 83 82 1376 1385 1381 1379 or21nand_x0
xfeed_866 83 82 decap_w0
xspare_buffer_77 83 82 2742 2734 buf_x4
xsubckt_1271_or21nand_x0 83 82 2144 2172 2170 2146 or21nand_x0
xsubckt_768_nand2_x0 83 82 2625 51 72 nand2_x0
xsubckt_30_inv_x0 83 82 86 885 inv_x0
xsubckt_521_and2_x1 83 82 447 558 247 and2_x1
xsubckt_2281_or21nand_x0 83 82 1157 684 1162 1160 or21nand_x0
xfeed_867 83 82 decap_w0
xspare_buffer_76 83 82 2742 2735 buf_x4
xsubckt_942_nand3_x0 83 82 2461 2462 2467 2468 nand3_x0
xsubckt_1578_and2_x1 83 82 1843 1844 658 and2_x1
xsubckt_1606_or2_x1 83 82 1816 1820 849 or2_x1
xsubckt_2162_nexor2_x0 83 82 1275 1277 1273 nexor2_x0
xfeed_864 83 82 decap_w0
xfeed_411 83 82 tie
xspare_buffer_75 83 82 2713 2711 buf_x4
xspare_feed_68 83 82 tie
xsubckt_2692_dff_x1 83 82 121 2763 10 dff_x1
xsubckt_1006_xor2_x0 83 82 32 33 2400 xor2_x0
xsubckt_452_mux2_x1 83 82 2685 507 884 180 mux2_x1
xsubckt_1585_nand2_x0 83 82 1836 1837 675 nand2_x0
xsubckt_2104_nand2_x0 83 82 1330 1331 437 nand2_x0
xfeed_865 83 82 decap_w0
xfeed_410 83 82 tie
xspare_buffer_74 83 82 2742 2736 buf_x4
xspare_feed_69 83 82 tie
xsubckt_1162_and3_x1 83 82 2251 2252 2270 79 and3_x1
xsubckt_947_nor2_x0 83 82 2456 3 26 nor2_x0
xsubckt_764_nexor2_x0 83 82 2630 2631 2629 nexor2_x0
xsubckt_703_nand2_x0 83 82 273 274 442 nand2_x0
xsubckt_175_and2_x1 83 82 755 56 2727 and2_x1
xsubckt_358_nand2_x0 83 82 595 596 598 nand2_x0
xsubckt_1485_nand4_x0 83 82 1935 33 250 249 248 nand4_x0
xsubckt_1579_or21nand_x0 83 82 1842 1850 1845 1843 or21nand_x0
xsubckt_1906_nand2_x0 83 82 1524 1526 437 nand2_x0
xsubckt_2259_nand4_x0 83 82 1178 93 809 867 868 nand4_x0
xsubckt_2529_mux2_x1 83 82 109 66 943 930 mux2_x1
xfeed_862 83 82 tie
xfeed_417 83 82 tie
xspare_buffer_73 83 82 2742 2737 buf_x4
xsubckt_1213_nand2_x0 83 82 2201 2202 2287 nand2_x0
xsubckt_1161_or21nand_x0 83 82 2252 2257 2255 2253 or21nand_x0
xsubckt_982_xor2_x0 83 82 1 24 2423 xor2_x0
xsubckt_826_nand3_x0 83 82 2571 673 29 250 nand3_x0
xsubckt_760_nor2_x0 83 82 2633 51 74 nor2_x0
xsubckt_351_nand2_x0 83 82 602 251 2690 nand2_x0
xsubckt_1332_nand4_x0 83 82 2085 36 250 249 248 nand4_x0
xsubckt_1437_nand2_x0 83 82 1982 2268 27 nand2_x0
xsubckt_1802_or21nand_x0 83 82 1624 2274 1628 1625 or21nand_x0
xsubckt_2034_mux2_x1 83 82 91 821 2283 1398 mux2_x1
xfeed_863 83 82 tie
xfeed_416 83 82 tie
xspare_buffer_72 83 82 2742 2738 buf_x4
xsubckt_2598_dff_x1 83 82 222 2763 99 dff_x1
xsubckt_2572_dff_x1 83 82 209 2772 61 dff_x1
xsubckt_689_nexor2_x0 83 82 290 293 287 nexor2_x0
xsubckt_673_or21nand_x0 83 82 302 42 436 441 or21nand_x0
xsubckt_246_and21nor_x0 83 82 701 2695 710 705 and21nor_x0
xsubckt_68_inv_x0 83 82 77 847 inv_x0
xsubckt_149_and3_x1 83 82 239 774 775 792 and3_x1
xsubckt_494_and2_x1 83 82 469 520 698 and2_x1
xsubckt_502_or2_x1 83 82 461 462 251 or2_x1
xsubckt_1505_nand3_x0 83 82 1915 1922 1936 66 nand3_x0
xfeed_860 83 82 tie
xfeed_415 83 82 tie
xfeed_279 83 82 tie
xspare_buffer_71 83 82 2713 2712 buf_x4
xsubckt_1075_nand2_x0 83 82 2334 2335 2338 nand2_x0
xsubckt_407_and3_x1 83 82 548 550 552 577 and3_x1
xsubckt_609_or21nand_x0 83 82 363 435 365 364 or21nand_x0
xsubckt_1790_and21nor_x0 83 82 1636 1655 1677 1681 and21nor_x0
xsubckt_2423_or21nand_x0 83 82 138 1019 1023 1046 or21nand_x0
xfeed_861 83 82 tie
xfeed_414 83 82 tie
xfeed_278 83 82 tie
xspare_buffer_70 83 82 2742 2739 buf_x4
xsubckt_963_xor2_x0 83 82 34 35 2441 xor2_x0
xsubckt_171_and2_x1 83 82 758 261 912 and2_x1
xsubckt_1337_nand4_x0 83 82 2080 818 250 864 248 nand4_x0
xsubckt_1487_nand2_x0 83 82 1933 2268 26 nand2_x0
xsubckt_1565_nexor2_x0 83 82 1858 1860 1856 nexor2_x0
xsubckt_1571_and21nor_x0 83 82 1850 2275 1854 1851 and21nor_x0
.ends cordic_top_cts_r
