* Coriolis Structural SPICE Driver
* Generated on Feb 04, 2026, 11:32
* Cell/Subckt "cordic_top_cts_r".
*
* INTERF wr_top
* INTERF wok_top
* INTERF vss
* INTERF vdd
* INTERF rok_top
* INTERF reset
* INTERF rd_top
* INTERF data_out[7]
* INTERF data_out[6]
* INTERF data_out[5]
* INTERF data_out[4]
* INTERF data_out[3]
* INTERF data_out[2]
* INTERF data_out[1]
* INTERF data_out[0]
* INTERF data_in[7]
* INTERF data_in[6]
* INTERF data_in[5]
* INTERF data_in[4]
* INTERF data_in[3]
* INTERF data_in[2]
* INTERF data_in[1]
* INTERF data_in[0]
* INTERF clk

* Terminal models (aka standard cells) used througout all the hierarchy.
.include tie.spi
.include and2_x1.spi
.include nand2_x0.spi
.include nand3_x0.spi
.include or21nand_x0.spi
.include or2_x1.spi
.include and21nor_x0.spi
.include decap_w0.spi
.include nexor2_x0.spi
.include nand4_x0.spi
.include and3_x1.spi
.include buf_x4.spi
.include inv_x0.spi
.include dff_x1.spi
.include nor2_x0.spi
.include nor3_x0.spi
.include mux2_x1.spi
.include and4_x1.spi
.include or3_x1.spi
.include diode_w1.spi
.include xor2_x0.spi
.include nor4_x0.spi
.include or4_x1.spi
.include buf_x1.spi

* Non-terminal models (part of the user's design hierarchy).

.subckt cordic_top_cts_r 80 81 82 83 87 88 89 143 144 145 146 147 148 149 150 151 152 153 154 155 156 157 158 161
* NET     0 = ykc[9]
* NET     1 = ykc[8]
* NET     2 = ykc[7]
* NET     3 = ykc[6]
* NET     4 = ykc[5]
* NET     5 = ykc[4]
* NET     6 = ykc[3]
* NET     7 = ykc[2]
* NET     8 = ykc[15]
* NET     9 = ykc[14]
* NET    10 = ykc[13]
* NET    11 = ykc[12]
* NET    12 = ykc[11]
* NET    13 = ykc[10]
* NET    14 = ykc[1]
* NET    15 = ykc[0]
* NET    16 = y_reg[7]
* NET    17 = y_reg[6]
* NET    18 = y_reg[5]
* NET    19 = y_reg[4]
* NET    20 = y_reg[3]
* NET    21 = y_reg[2]
* NET    22 = y_reg[1]
* NET    23 = y_reg[0]
* NET    24 = y[9]
* NET    25 = y[8]
* NET    26 = y[7]
* NET    27 = y[6]
* NET    28 = y[5]
* NET    29 = y[4]
* NET    30 = y[3]
* NET    31 = y[2]
* NET    32 = y[15]
* NET    33 = y[14]
* NET    34 = y[13]
* NET    35 = y[12]
* NET    36 = y[11]
* NET    37 = y[10]
* NET    38 = y[1]
* NET    39 = y[0]
* NET    40 = xkc[9]
* NET    41 = xkc[8]
* NET    42 = xkc[7]
* NET    43 = xkc[6]
* NET    44 = xkc[5]
* NET    45 = xkc[4]
* NET    46 = xkc[3]
* NET    47 = xkc[2]
* NET    48 = xkc[15]
* NET    49 = xkc[14]
* NET    50 = xkc[13]
* NET    51 = xkc[12]
* NET    52 = xkc[11]
* NET    53 = xkc[10]
* NET    54 = xkc[1]
* NET    55 = xkc[0]
* NET    56 = x_reg[7]
* NET    57 = x_reg[6]
* NET    58 = x_reg[5]
* NET    59 = x_reg[4]
* NET    60 = x_reg[3]
* NET    61 = x_reg[2]
* NET    62 = x_reg[1]
* NET    63 = x_reg[0]
* NET    64 = x[9]
* NET    65 = x[8]
* NET    66 = x[7]
* NET    67 = x[6]
* NET    68 = x[5]
* NET    69 = x[4]
* NET    70 = x[3]
* NET    71 = x[2]
* NET    72 = x[15]
* NET    73 = x[14]
* NET    74 = x[13]
* NET    75 = x[12]
* NET    76 = x[11]
* NET    77 = x[10]
* NET    78 = x[1]
* NET    79 = x[0]
* NET    80 = wr_top
* NET    81 = wok_top
* NET    82 = vss
* NET    83 = vdd
* NET    84 = stateoito
* NET    85 = state[1]
* NET    86 = state[0]
* NET    87 = rok_top
* NET    88 = reset
* NET    89 = rd_top
* NET    90 = quadrant[1]
* NET    91 = quadrant[0]
* NET    92 = put
* NET    93 = place
* NET    94 = ny_reg[7]
* NET    95 = ny_reg[6]
* NET    96 = ny_reg[5]
* NET    97 = ny_reg[4]
* NET    98 = ny_reg[3]
* NET    99 = ny_reg[2]
* NET   100 = ny_reg[1]
* NET   101 = ny_reg[0]
* NET   102 = nx_reg[7]
* NET   103 = nx_reg[6]
* NET   104 = nx_reg[5]
* NET   105 = nx_reg[4]
* NET   106 = nx_reg[3]
* NET   107 = nx_reg[2]
* NET   108 = nx_reg[1]
* NET   109 = nx_reg[0]
* NET   110 = norm
* NET   111 = n0_stateoito_0_0
* NET   112 = n0_state_1_0_1
* NET   113 = n0_state_1_0_0
* NET   114 = n0_put_0_0
* NET   115 = n0_place_0_0
* NET   116 = n0_ny_reg_7_0_7
* NET   117 = n0_ny_reg_7_0_6
* NET   118 = n0_ny_reg_7_0_5
* NET   119 = n0_ny_reg_7_0_4
* NET   120 = n0_ny_reg_7_0_3
* NET   121 = n0_ny_reg_7_0_2
* NET   122 = n0_ny_reg_7_0_1
* NET   123 = n0_ny_reg_7_0_0
* NET   124 = n0_nx_reg_7_0_7
* NET   125 = n0_nx_reg_7_0_6
* NET   126 = n0_nx_reg_7_0_5
* NET   127 = n0_nx_reg_7_0_4
* NET   128 = n0_nx_reg_7_0_3
* NET   129 = n0_nx_reg_7_0_2
* NET   130 = n0_nx_reg_7_0_1
* NET   131 = n0_nx_reg_7_0_0
* NET   132 = n0_norm_0_0
* NET   133 = n0_mkc_0_0
* NET   134 = n0_get_0_0
* NET   135 = n0_counter_1_0_1
* NET   136 = n0_counter_1_0_0
* NET   137 = n0_calc_0_0
* NET   138 = mkc
* NET   139 = i[2]
* NET   140 = i[1]
* NET   141 = i[0]
* NET   142 = get
* NET   143 = data_out[7]
* NET   144 = data_out[6]
* NET   145 = data_out[5]
* NET   146 = data_out[4]
* NET   147 = data_out[3]
* NET   148 = data_out[2]
* NET   149 = data_out[1]
* NET   150 = data_out[0]
* NET   151 = data_in[7]
* NET   152 = data_in[6]
* NET   153 = data_in[5]
* NET   154 = data_in[4]
* NET   155 = data_in[3]
* NET   156 = data_in[2]
* NET   157 = data_in[1]
* NET   158 = data_in[0]
* NET   159 = counter[1]
* NET   160 = counter[0]
* NET   161 = clk
* NET   162 = calc
* NET   163 = abc_7357_new_n998
* NET   164 = abc_7357_new_n997
* NET   165 = abc_7357_new_n996
* NET   166 = abc_7357_new_n995
* NET   167 = abc_7357_new_n994
* NET   168 = abc_7357_new_n993
* NET   169 = abc_7357_new_n992
* NET   170 = abc_7357_new_n991
* NET   171 = abc_7357_new_n990
* NET   172 = abc_7357_new_n989
* NET   173 = abc_7357_new_n988
* NET   174 = abc_7357_new_n987
* NET   175 = abc_7357_new_n986
* NET   176 = abc_7357_new_n985
* NET   177 = abc_7357_new_n984
* NET   178 = abc_7357_new_n983
* NET   179 = abc_7357_new_n982
* NET   180 = abc_7357_new_n981
* NET   181 = abc_7357_new_n980
* NET   182 = abc_7357_new_n979
* NET   183 = abc_7357_new_n978
* NET   184 = abc_7357_new_n977
* NET   185 = abc_7357_new_n976
* NET   186 = abc_7357_new_n975
* NET   187 = abc_7357_new_n974
* NET   188 = abc_7357_new_n973
* NET   189 = abc_7357_new_n972
* NET   190 = abc_7357_new_n971
* NET   191 = abc_7357_new_n970
* NET   192 = abc_7357_new_n969
* NET   193 = abc_7357_new_n968
* NET   194 = abc_7357_new_n967
* NET   195 = abc_7357_new_n966
* NET   196 = abc_7357_new_n965
* NET   197 = abc_7357_new_n964
* NET   198 = abc_7357_new_n963
* NET   199 = abc_7357_new_n962
* NET   200 = abc_7357_new_n961
* NET   201 = abc_7357_new_n960
* NET   202 = abc_7357_new_n959
* NET   203 = abc_7357_new_n958
* NET   204 = abc_7357_new_n957
* NET   205 = abc_7357_new_n956
* NET   206 = abc_7357_new_n955
* NET   207 = abc_7357_new_n954
* NET   208 = abc_7357_new_n953
* NET   209 = abc_7357_new_n952
* NET   210 = abc_7357_new_n951
* NET   211 = abc_7357_new_n950
* NET   212 = abc_7357_new_n949
* NET   213 = abc_7357_new_n948
* NET   214 = abc_7357_new_n947
* NET   215 = abc_7357_new_n945
* NET   216 = abc_7357_new_n944
* NET   217 = abc_7357_new_n943
* NET   218 = abc_7357_new_n942
* NET   219 = abc_7357_new_n941
* NET   220 = abc_7357_new_n940
* NET   221 = abc_7357_new_n939
* NET   222 = abc_7357_new_n938
* NET   223 = abc_7357_new_n937
* NET   224 = abc_7357_new_n936
* NET   225 = abc_7357_new_n935
* NET   226 = abc_7357_new_n934
* NET   227 = abc_7357_new_n933
* NET   228 = abc_7357_new_n932
* NET   229 = abc_7357_new_n931
* NET   230 = abc_7357_new_n930
* NET   231 = abc_7357_new_n929
* NET   232 = abc_7357_new_n928
* NET   233 = abc_7357_new_n927
* NET   234 = abc_7357_new_n926
* NET   235 = abc_7357_new_n925
* NET   236 = abc_7357_new_n924
* NET   237 = abc_7357_new_n923
* NET   238 = abc_7357_new_n922
* NET   239 = abc_7357_new_n921
* NET   240 = abc_7357_new_n920
* NET   241 = abc_7357_new_n919
* NET   242 = abc_7357_new_n918
* NET   243 = abc_7357_new_n917
* NET   244 = abc_7357_new_n916
* NET   245 = abc_7357_new_n915
* NET   246 = abc_7357_new_n914
* NET   247 = abc_7357_new_n913
* NET   248 = abc_7357_new_n912
* NET   249 = abc_7357_new_n911
* NET   250 = abc_7357_new_n910
* NET   251 = abc_7357_new_n909
* NET   252 = abc_7357_new_n908
* NET   253 = abc_7357_new_n907
* NET   254 = abc_7357_new_n906
* NET   255 = abc_7357_new_n905
* NET   256 = abc_7357_new_n904
* NET   257 = abc_7357_new_n903
* NET   258 = abc_7357_new_n902
* NET   259 = abc_7357_new_n901
* NET   260 = abc_7357_new_n900
* NET   261 = abc_7357_new_n899
* NET   262 = abc_7357_new_n898
* NET   263 = abc_7357_new_n896
* NET   264 = abc_7357_new_n895
* NET   265 = abc_7357_new_n894
* NET   266 = abc_7357_new_n893
* NET   267 = abc_7357_new_n892
* NET   268 = abc_7357_new_n891
* NET   269 = abc_7357_new_n890
* NET   270 = abc_7357_new_n889
* NET   271 = abc_7357_new_n888
* NET   272 = abc_7357_new_n887
* NET   273 = abc_7357_new_n886
* NET   274 = abc_7357_new_n885
* NET   275 = abc_7357_new_n884
* NET   276 = abc_7357_new_n883
* NET   277 = abc_7357_new_n882
* NET   278 = abc_7357_new_n881
* NET   279 = abc_7357_new_n880
* NET   280 = abc_7357_new_n879
* NET   281 = abc_7357_new_n878
* NET   282 = abc_7357_new_n877
* NET   283 = abc_7357_new_n876
* NET   284 = abc_7357_new_n875
* NET   285 = abc_7357_new_n874
* NET   286 = abc_7357_new_n873
* NET   287 = abc_7357_new_n872
* NET   288 = abc_7357_new_n871
* NET   289 = abc_7357_new_n870
* NET   290 = abc_7357_new_n869
* NET   291 = abc_7357_new_n868
* NET   292 = abc_7357_new_n867
* NET   293 = abc_7357_new_n866
* NET   294 = abc_7357_new_n865
* NET   295 = abc_7357_new_n864
* NET   296 = abc_7357_new_n863
* NET   297 = abc_7357_new_n862
* NET   298 = abc_7357_new_n861
* NET   299 = abc_7357_new_n860
* NET   300 = abc_7357_new_n859
* NET   301 = abc_7357_new_n858
* NET   302 = abc_7357_new_n857
* NET   303 = abc_7357_new_n856
* NET   304 = abc_7357_new_n855
* NET   305 = abc_7357_new_n854
* NET   306 = abc_7357_new_n853
* NET   307 = abc_7357_new_n852
* NET   308 = abc_7357_new_n851
* NET   309 = abc_7357_new_n850
* NET   310 = abc_7357_new_n849
* NET   311 = abc_7357_new_n848
* NET   312 = abc_7357_new_n847
* NET   313 = abc_7357_new_n846
* NET   314 = abc_7357_new_n845
* NET   315 = abc_7357_new_n844
* NET   316 = abc_7357_new_n843
* NET   317 = abc_7357_new_n842
* NET   318 = abc_7357_new_n841
* NET   319 = abc_7357_new_n840
* NET   320 = abc_7357_new_n839
* NET   321 = abc_7357_new_n838
* NET   322 = abc_7357_new_n837
* NET   323 = abc_7357_new_n836
* NET   324 = abc_7357_new_n835
* NET   325 = abc_7357_new_n834
* NET   326 = abc_7357_new_n833
* NET   327 = abc_7357_new_n832
* NET   328 = abc_7357_new_n830
* NET   329 = abc_7357_new_n829
* NET   330 = abc_7357_new_n828
* NET   331 = abc_7357_new_n827
* NET   332 = abc_7357_new_n826
* NET   333 = abc_7357_new_n825
* NET   334 = abc_7357_new_n824
* NET   335 = abc_7357_new_n823
* NET   336 = abc_7357_new_n822
* NET   337 = abc_7357_new_n821
* NET   338 = abc_7357_new_n820
* NET   339 = abc_7357_new_n819
* NET   340 = abc_7357_new_n818
* NET   341 = abc_7357_new_n817
* NET   342 = abc_7357_new_n816
* NET   343 = abc_7357_new_n815
* NET   344 = abc_7357_new_n814
* NET   345 = abc_7357_new_n813
* NET   346 = abc_7357_new_n812
* NET   347 = abc_7357_new_n811
* NET   348 = abc_7357_new_n810
* NET   349 = abc_7357_new_n809
* NET   350 = abc_7357_new_n808
* NET   351 = abc_7357_new_n807
* NET   352 = abc_7357_new_n806
* NET   353 = abc_7357_new_n805
* NET   354 = abc_7357_new_n804
* NET   355 = abc_7357_new_n803
* NET   356 = abc_7357_new_n802
* NET   357 = abc_7357_new_n801
* NET   358 = abc_7357_new_n800
* NET   359 = abc_7357_new_n799
* NET   360 = abc_7357_new_n798
* NET   361 = abc_7357_new_n797
* NET   362 = abc_7357_new_n796
* NET   363 = abc_7357_new_n795
* NET   364 = abc_7357_new_n794
* NET   365 = abc_7357_new_n793
* NET   366 = abc_7357_new_n792
* NET   367 = abc_7357_new_n791
* NET   368 = abc_7357_new_n790
* NET   369 = abc_7357_new_n789
* NET   370 = abc_7357_new_n788
* NET   371 = abc_7357_new_n787
* NET   372 = abc_7357_new_n786
* NET   373 = abc_7357_new_n785
* NET   374 = abc_7357_new_n784
* NET   375 = abc_7357_new_n783
* NET   376 = abc_7357_new_n782
* NET   377 = abc_7357_new_n780
* NET   378 = abc_7357_new_n779
* NET   379 = abc_7357_new_n778
* NET   380 = abc_7357_new_n777
* NET   381 = abc_7357_new_n776
* NET   382 = abc_7357_new_n774
* NET   383 = abc_7357_new_n773
* NET   384 = abc_7357_new_n772
* NET   385 = abc_7357_new_n771
* NET   386 = abc_7357_new_n770
* NET   387 = abc_7357_new_n769
* NET   388 = abc_7357_new_n768
* NET   389 = abc_7357_new_n766
* NET   390 = abc_7357_new_n765
* NET   391 = abc_7357_new_n764
* NET   392 = abc_7357_new_n763
* NET   393 = abc_7357_new_n762
* NET   394 = abc_7357_new_n761
* NET   395 = abc_7357_new_n760
* NET   396 = abc_7357_new_n759
* NET   397 = abc_7357_new_n758
* NET   398 = abc_7357_new_n756
* NET   399 = abc_7357_new_n755
* NET   400 = abc_7357_new_n754
* NET   401 = abc_7357_new_n753
* NET   402 = abc_7357_new_n752
* NET   403 = abc_7357_new_n751
* NET   404 = abc_7357_new_n750
* NET   405 = abc_7357_new_n749
* NET   406 = abc_7357_new_n748
* NET   407 = abc_7357_new_n746
* NET   408 = abc_7357_new_n745
* NET   409 = abc_7357_new_n744
* NET   410 = abc_7357_new_n743
* NET   411 = abc_7357_new_n742
* NET   412 = abc_7357_new_n741
* NET   413 = abc_7357_new_n740
* NET   414 = abc_7357_new_n739
* NET   415 = abc_7357_new_n738
* NET   416 = abc_7357_new_n737
* NET   417 = abc_7357_new_n736
* NET   418 = abc_7357_new_n735
* NET   419 = abc_7357_new_n733
* NET   420 = abc_7357_new_n732
* NET   421 = abc_7357_new_n731
* NET   422 = abc_7357_new_n730
* NET   423 = abc_7357_new_n729
* NET   424 = abc_7357_new_n728
* NET   425 = abc_7357_new_n727
* NET   426 = abc_7357_new_n726
* NET   427 = abc_7357_new_n725
* NET   428 = abc_7357_new_n724
* NET   429 = abc_7357_new_n723
* NET   430 = abc_7357_new_n722
* NET   431 = abc_7357_new_n721
* NET   432 = abc_7357_new_n720
* NET   433 = abc_7357_new_n718
* NET   434 = abc_7357_new_n717
* NET   435 = abc_7357_new_n716
* NET   436 = abc_7357_new_n715
* NET   437 = abc_7357_new_n714
* NET   438 = abc_7357_new_n713
* NET   439 = abc_7357_new_n712
* NET   440 = abc_7357_new_n711
* NET   441 = abc_7357_new_n710
* NET   442 = abc_7357_new_n709
* NET   443 = abc_7357_new_n708
* NET   444 = abc_7357_new_n707
* NET   445 = abc_7357_new_n706
* NET   446 = abc_7357_new_n705
* NET   447 = abc_7357_new_n704
* NET   448 = abc_7357_new_n703
* NET   449 = abc_7357_new_n702
* NET   450 = abc_7357_new_n700
* NET   451 = abc_7357_new_n699
* NET   452 = abc_7357_new_n698
* NET   453 = abc_7357_new_n697
* NET   454 = abc_7357_new_n696
* NET   455 = abc_7357_new_n695
* NET   456 = abc_7357_new_n694
* NET   457 = abc_7357_new_n693
* NET   458 = abc_7357_new_n692
* NET   459 = abc_7357_new_n691
* NET   460 = abc_7357_new_n690
* NET   461 = abc_7357_new_n689
* NET   462 = abc_7357_new_n688
* NET   463 = abc_7357_new_n687
* NET   464 = abc_7357_new_n686
* NET   465 = abc_7357_new_n685
* NET   466 = abc_7357_new_n684
* NET   467 = abc_7357_new_n682
* NET   468 = abc_7357_new_n681
* NET   469 = abc_7357_new_n680
* NET   470 = abc_7357_new_n679
* NET   471 = abc_7357_new_n678
* NET   472 = abc_7357_new_n677
* NET   473 = abc_7357_new_n676
* NET   474 = abc_7357_new_n675
* NET   475 = abc_7357_new_n674
* NET   476 = abc_7357_new_n673
* NET   477 = abc_7357_new_n672
* NET   478 = abc_7357_new_n671
* NET   479 = abc_7357_new_n670
* NET   480 = abc_7357_new_n669
* NET   481 = abc_7357_new_n668
* NET   482 = abc_7357_new_n667
* NET   483 = abc_7357_new_n665
* NET   484 = abc_7357_new_n664
* NET   485 = abc_7357_new_n663
* NET   486 = abc_7357_new_n662
* NET   487 = abc_7357_new_n661
* NET   488 = abc_7357_new_n660
* NET   489 = abc_7357_new_n659
* NET   490 = abc_7357_new_n658
* NET   491 = abc_7357_new_n657
* NET   492 = abc_7357_new_n656
* NET   493 = abc_7357_new_n655
* NET   494 = abc_7357_new_n654
* NET   495 = abc_7357_new_n653
* NET   496 = abc_7357_new_n652
* NET   497 = abc_7357_new_n651
* NET   498 = abc_7357_new_n650
* NET   499 = abc_7357_new_n649
* NET   500 = abc_7357_new_n647
* NET   501 = abc_7357_new_n646
* NET   502 = abc_7357_new_n645
* NET   503 = abc_7357_new_n644
* NET   504 = abc_7357_new_n643
* NET   505 = abc_7357_new_n642
* NET   506 = abc_7357_new_n641
* NET   507 = abc_7357_new_n640
* NET   508 = abc_7357_new_n639
* NET   509 = abc_7357_new_n638
* NET   510 = abc_7357_new_n637
* NET   511 = abc_7357_new_n636
* NET   512 = abc_7357_new_n635
* NET   513 = abc_7357_new_n634
* NET   514 = abc_7357_new_n633
* NET   515 = abc_7357_new_n632
* NET   516 = abc_7357_new_n631
* NET   517 = abc_7357_new_n630
* NET   518 = abc_7357_new_n629
* NET   519 = abc_7357_new_n627
* NET   520 = abc_7357_new_n626
* NET   521 = abc_7357_new_n625
* NET   522 = abc_7357_new_n624
* NET   523 = abc_7357_new_n623
* NET   524 = abc_7357_new_n622
* NET   525 = abc_7357_new_n621
* NET   526 = abc_7357_new_n620
* NET   527 = abc_7357_new_n619
* NET   528 = abc_7357_new_n618
* NET   529 = abc_7357_new_n617
* NET   530 = abc_7357_new_n616
* NET   531 = abc_7357_new_n615
* NET   532 = abc_7357_new_n614
* NET   533 = abc_7357_new_n613
* NET   534 = abc_7357_new_n612
* NET   535 = abc_7357_new_n611
* NET   536 = abc_7357_new_n610
* NET   537 = abc_7357_new_n609
* NET   538 = abc_7357_new_n608
* NET   539 = abc_7357_new_n607
* NET   540 = abc_7357_new_n606
* NET   541 = abc_7357_new_n605
* NET   542 = abc_7357_new_n603
* NET   543 = abc_7357_new_n602
* NET   544 = abc_7357_new_n601
* NET   545 = abc_7357_new_n600
* NET   546 = abc_7357_new_n599
* NET   547 = abc_7357_new_n598
* NET   548 = abc_7357_new_n597
* NET   549 = abc_7357_new_n596
* NET   550 = abc_7357_new_n595
* NET   551 = abc_7357_new_n594
* NET   552 = abc_7357_new_n593
* NET   553 = abc_7357_new_n592
* NET   554 = abc_7357_new_n591
* NET   555 = abc_7357_new_n590
* NET   556 = abc_7357_new_n589
* NET   557 = abc_7357_new_n588
* NET   558 = abc_7357_new_n586
* NET   559 = abc_7357_new_n585
* NET   560 = abc_7357_new_n584
* NET   561 = abc_7357_new_n583
* NET   562 = abc_7357_new_n582
* NET   563 = abc_7357_new_n581
* NET   564 = abc_7357_new_n580
* NET   565 = abc_7357_new_n579
* NET   566 = abc_7357_new_n578
* NET   567 = abc_7357_new_n577
* NET   568 = abc_7357_new_n576
* NET   569 = abc_7357_new_n575
* NET   570 = abc_7357_new_n574
* NET   571 = abc_7357_new_n573
* NET   572 = abc_7357_new_n572
* NET   573 = abc_7357_new_n571
* NET   574 = abc_7357_new_n570
* NET   575 = abc_7357_new_n569
* NET   576 = abc_7357_new_n568
* NET   577 = abc_7357_new_n567
* NET   578 = abc_7357_new_n566
* NET   579 = abc_7357_new_n564
* NET   580 = abc_7357_new_n563
* NET   581 = abc_7357_new_n562
* NET   582 = abc_7357_new_n561
* NET   583 = abc_7357_new_n560
* NET   584 = abc_7357_new_n559
* NET   585 = abc_7357_new_n558
* NET   586 = abc_7357_new_n557
* NET   587 = abc_7357_new_n556
* NET   588 = abc_7357_new_n555
* NET   589 = abc_7357_new_n554
* NET   590 = abc_7357_new_n553
* NET   591 = abc_7357_new_n551
* NET   592 = abc_7357_new_n550
* NET   593 = abc_7357_new_n549
* NET   594 = abc_7357_new_n548
* NET   595 = abc_7357_new_n547
* NET   596 = abc_7357_new_n546
* NET   597 = abc_7357_new_n545
* NET   598 = abc_7357_new_n544
* NET   599 = abc_7357_new_n543
* NET   600 = abc_7357_new_n542
* NET   601 = abc_7357_new_n541
* NET   602 = abc_7357_new_n540
* NET   603 = abc_7357_new_n539
* NET   604 = abc_7357_new_n538
* NET   605 = abc_7357_new_n537
* NET   606 = abc_7357_new_n536
* NET   607 = abc_7357_new_n535
* NET   608 = abc_7357_new_n534
* NET   609 = abc_7357_new_n533
* NET   610 = abc_7357_new_n532
* NET   611 = abc_7357_new_n531
* NET   612 = abc_7357_new_n530
* NET   613 = abc_7357_new_n529
* NET   614 = abc_7357_new_n528
* NET   615 = abc_7357_new_n527
* NET   616 = abc_7357_new_n526
* NET   617 = abc_7357_new_n525
* NET   618 = abc_7357_new_n524
* NET   619 = abc_7357_new_n522
* NET   620 = abc_7357_new_n521
* NET   621 = abc_7357_new_n519
* NET   622 = abc_7357_new_n518
* NET   623 = abc_7357_new_n516
* NET   624 = abc_7357_new_n515
* NET   625 = abc_7357_new_n513
* NET   626 = abc_7357_new_n512
* NET   627 = abc_7357_new_n510
* NET   628 = abc_7357_new_n509
* NET   629 = abc_7357_new_n507
* NET   630 = abc_7357_new_n506
* NET   631 = abc_7357_new_n504
* NET   632 = abc_7357_new_n503
* NET   633 = abc_7357_new_n501
* NET   634 = abc_7357_new_n500
* NET   635 = abc_7357_new_n498
* NET   636 = abc_7357_new_n497
* NET   637 = abc_7357_new_n495
* NET   638 = abc_7357_new_n494
* NET   639 = abc_7357_new_n493
* NET   640 = abc_7357_new_n492
* NET   641 = abc_7357_new_n490
* NET   642 = abc_7357_new_n489
* NET   643 = abc_7357_new_n488
* NET   644 = abc_7357_new_n487
* NET   645 = abc_7357_new_n485
* NET   646 = abc_7357_new_n483
* NET   647 = abc_7357_new_n482
* NET   648 = abc_7357_new_n481
* NET   649 = abc_7357_new_n480
* NET   650 = abc_7357_new_n479
* NET   651 = abc_7357_new_n477
* NET   652 = abc_7357_new_n475
* NET   653 = abc_7357_new_n473
* NET   654 = abc_7357_new_n471
* NET   655 = abc_7357_new_n469
* NET   656 = abc_7357_new_n467
* NET   657 = abc_7357_new_n465
* NET   658 = abc_7357_new_n463
* NET   659 = abc_7357_new_n461
* NET   660 = abc_7357_new_n459
* NET   661 = abc_7357_new_n457
* NET   662 = abc_7357_new_n455
* NET   663 = abc_7357_new_n453
* NET   664 = abc_7357_new_n451
* NET   665 = abc_7357_new_n449
* NET   666 = abc_7357_new_n447
* NET   667 = abc_7357_new_n445
* NET   668 = abc_7357_new_n444
* NET   669 = abc_7357_new_n443
* NET   670 = abc_7357_new_n441
* NET   671 = abc_7357_new_n440
* NET   672 = abc_7357_new_n439
* NET   673 = abc_7357_new_n437
* NET   674 = abc_7357_new_n436
* NET   675 = abc_7357_new_n435
* NET   676 = abc_7357_new_n434
* NET   677 = abc_7357_new_n433
* NET   678 = abc_7357_new_n432
* NET   679 = abc_7357_new_n431
* NET   680 = abc_7357_new_n430
* NET   681 = abc_7357_new_n429
* NET   682 = abc_7357_new_n428
* NET   683 = abc_7357_new_n427
* NET   684 = abc_7357_new_n426
* NET   685 = abc_7357_new_n425
* NET   686 = abc_7357_new_n424
* NET   687 = abc_7357_new_n423
* NET   688 = abc_7357_new_n422
* NET   689 = abc_7357_new_n421
* NET   690 = abc_7357_new_n420
* NET   691 = abc_7357_new_n419
* NET   692 = abc_7357_new_n418
* NET   693 = abc_7357_new_n417
* NET   694 = abc_7357_new_n416
* NET   695 = abc_7357_new_n415
* NET   696 = abc_7357_new_n413
* NET   697 = abc_7357_new_n412
* NET   698 = abc_7357_new_n411
* NET   699 = abc_7357_new_n410
* NET   700 = abc_7357_new_n409
* NET   701 = abc_7357_new_n408
* NET   702 = abc_7357_new_n406
* NET   703 = abc_7357_new_n405
* NET   704 = abc_7357_new_n404
* NET   705 = abc_7357_new_n403
* NET   706 = abc_7357_new_n402
* NET   707 = abc_7357_new_n400
* NET   708 = abc_7357_new_n399
* NET   709 = abc_7357_new_n398
* NET   710 = abc_7357_new_n397
* NET   711 = abc_7357_new_n396
* NET   712 = abc_7357_new_n395
* NET   713 = abc_7357_new_n394
* NET   714 = abc_7357_new_n393
* NET   715 = abc_7357_new_n392
* NET   716 = abc_7357_new_n391
* NET   717 = abc_7357_new_n390
* NET   718 = abc_7357_new_n389
* NET   719 = abc_7357_new_n388
* NET   720 = abc_7357_new_n387
* NET   721 = abc_7357_new_n386
* NET   722 = abc_7357_new_n385
* NET   723 = abc_7357_new_n384
* NET   724 = abc_7357_new_n383
* NET   725 = abc_7357_new_n382
* NET   726 = abc_7357_new_n381
* NET   727 = abc_7357_new_n380
* NET   728 = abc_7357_new_n379
* NET   729 = abc_7357_new_n378
* NET   730 = abc_7357_new_n377
* NET   731 = abc_7357_new_n376
* NET   732 = abc_7357_new_n375
* NET   733 = abc_7357_new_n374
* NET   734 = abc_7357_new_n373
* NET   735 = abc_7357_new_n372
* NET   736 = abc_7357_new_n371
* NET   737 = abc_7357_new_n370
* NET   738 = abc_7357_new_n369
* NET   739 = abc_7357_new_n368
* NET   740 = abc_7357_new_n367
* NET   741 = abc_7357_new_n366
* NET   742 = abc_7357_new_n365
* NET   743 = abc_7357_new_n364
* NET   744 = abc_7357_new_n363
* NET   745 = abc_7357_new_n362
* NET   746 = abc_7357_new_n361
* NET   747 = abc_7357_new_n360
* NET   748 = abc_7357_new_n359
* NET   749 = abc_7357_new_n358
* NET   750 = abc_7357_new_n357
* NET   751 = abc_7357_new_n356
* NET   752 = abc_7357_new_n355
* NET   753 = abc_7357_new_n354
* NET   754 = abc_7357_new_n353
* NET   755 = abc_7357_new_n352
* NET   756 = abc_7357_new_n351
* NET   757 = abc_7357_new_n350
* NET   758 = abc_7357_new_n349
* NET   759 = abc_7357_new_n348
* NET   760 = abc_7357_new_n347
* NET   761 = abc_7357_new_n346
* NET   762 = abc_7357_new_n345
* NET   763 = abc_7357_new_n343
* NET   764 = abc_7357_new_n342
* NET   765 = abc_7357_new_n341
* NET   766 = abc_7357_new_n340
* NET   767 = abc_7357_new_n339
* NET   768 = abc_7357_new_n338
* NET   769 = abc_7357_new_n337
* NET   770 = abc_7357_new_n336
* NET   771 = abc_7357_new_n335
* NET   772 = abc_7357_new_n334
* NET   773 = abc_7357_new_n333
* NET   774 = abc_7357_new_n332
* NET   775 = abc_7357_new_n331
* NET   776 = abc_7357_new_n330
* NET   777 = abc_7357_new_n329
* NET   778 = abc_7357_new_n328
* NET   779 = abc_7357_new_n327
* NET   780 = abc_7357_new_n326
* NET   781 = abc_7357_new_n325
* NET   782 = abc_7357_new_n324
* NET   783 = abc_7357_new_n323
* NET   784 = abc_7357_new_n322
* NET   785 = abc_7357_new_n321
* NET   786 = abc_7357_new_n320
* NET   787 = abc_7357_new_n319
* NET   788 = abc_7357_new_n318
* NET   789 = abc_7357_new_n317
* NET   790 = abc_7357_new_n316
* NET   791 = abc_7357_new_n315
* NET   792 = abc_7357_new_n314
* NET   793 = abc_7357_new_n313
* NET   794 = abc_7357_new_n312
* NET   795 = abc_7357_new_n311
* NET   796 = abc_7357_new_n310
* NET   797 = abc_7357_new_n309
* NET   798 = abc_7357_new_n308
* NET   799 = abc_7357_new_n307
* NET   800 = abc_7357_new_n306
* NET   801 = abc_7357_new_n305
* NET   802 = abc_7357_new_n304
* NET   803 = abc_7357_new_n303
* NET   804 = abc_7357_new_n302
* NET   805 = abc_7357_new_n301
* NET   806 = abc_7357_new_n300
* NET   807 = abc_7357_new_n299
* NET   808 = abc_7357_new_n298
* NET   809 = abc_7357_new_n297
* NET   810 = abc_7357_new_n296
* NET   811 = abc_7357_new_n295
* NET   812 = abc_7357_new_n294
* NET   813 = abc_7357_new_n2666
* NET   814 = abc_7357_new_n2665
* NET   815 = abc_7357_new_n2664
* NET   816 = abc_7357_new_n2663
* NET   817 = abc_7357_new_n2661
* NET   818 = abc_7357_new_n2660
* NET   819 = abc_7357_new_n2659
* NET   820 = abc_7357_new_n2658
* NET   821 = abc_7357_new_n2657
* NET   822 = abc_7357_new_n2656
* NET   823 = abc_7357_new_n2655
* NET   824 = abc_7357_new_n2654
* NET   825 = abc_7357_new_n2653
* NET   826 = abc_7357_new_n2652
* NET   827 = abc_7357_new_n2651
* NET   828 = abc_7357_new_n2649
* NET   829 = abc_7357_new_n2648
* NET   830 = abc_7357_new_n2647
* NET   831 = abc_7357_new_n2646
* NET   832 = abc_7357_new_n2645
* NET   833 = abc_7357_new_n2644
* NET   834 = abc_7357_new_n2643
* NET   835 = abc_7357_new_n2642
* NET   836 = abc_7357_new_n2641
* NET   837 = abc_7357_new_n2640
* NET   838 = abc_7357_new_n2638
* NET   839 = abc_7357_new_n2637
* NET   840 = abc_7357_new_n2636
* NET   841 = abc_7357_new_n2635
* NET   842 = abc_7357_new_n2634
* NET   843 = abc_7357_new_n2633
* NET   844 = abc_7357_new_n2632
* NET   845 = abc_7357_new_n2631
* NET   846 = abc_7357_new_n2630
* NET   847 = abc_7357_new_n2628
* NET   848 = abc_7357_new_n2627
* NET   849 = abc_7357_new_n2626
* NET   850 = abc_7357_new_n2625
* NET   851 = abc_7357_new_n2624
* NET   852 = abc_7357_new_n2623
* NET   853 = abc_7357_new_n2622
* NET   854 = abc_7357_new_n2621
* NET   855 = abc_7357_new_n2620
* NET   856 = abc_7357_new_n2619
* NET   857 = abc_7357_new_n2618
* NET   858 = abc_7357_new_n2616
* NET   859 = abc_7357_new_n2615
* NET   860 = abc_7357_new_n2614
* NET   861 = abc_7357_new_n2613
* NET   862 = abc_7357_new_n2612
* NET   863 = abc_7357_new_n2611
* NET   864 = abc_7357_new_n2610
* NET   865 = abc_7357_new_n2609
* NET   866 = abc_7357_new_n2608
* NET   867 = abc_7357_new_n2607
* NET   868 = abc_7357_new_n2606
* NET   869 = abc_7357_new_n2605
* NET   870 = abc_7357_new_n2604
* NET   871 = abc_7357_new_n2602
* NET   872 = abc_7357_new_n2601
* NET   873 = abc_7357_new_n2600
* NET   874 = abc_7357_new_n2599
* NET   875 = abc_7357_new_n2598
* NET   876 = abc_7357_new_n2597
* NET   877 = abc_7357_new_n2596
* NET   878 = abc_7357_new_n2595
* NET   879 = abc_7357_new_n2594
* NET   880 = abc_7357_new_n2593
* NET   881 = abc_7357_new_n2592
* NET   882 = abc_7357_new_n2591
* NET   883 = abc_7357_new_n2590
* NET   884 = abc_7357_new_n2589
* NET   885 = abc_7357_new_n2588
* NET   886 = abc_7357_new_n2587
* NET   887 = abc_7357_new_n2585
* NET   888 = abc_7357_new_n2584
* NET   889 = abc_7357_new_n2583
* NET   890 = abc_7357_new_n2582
* NET   891 = abc_7357_new_n2581
* NET   892 = abc_7357_new_n2580
* NET   893 = abc_7357_new_n2579
* NET   894 = abc_7357_new_n2578
* NET   895 = abc_7357_new_n2577
* NET   896 = abc_7357_new_n2576
* NET   897 = abc_7357_new_n2575
* NET   898 = abc_7357_new_n2574
* NET   899 = abc_7357_new_n2573
* NET   900 = abc_7357_new_n2572
* NET   901 = abc_7357_new_n2571
* NET   902 = abc_7357_new_n2570
* NET   903 = abc_7357_new_n2568
* NET   904 = abc_7357_new_n2567
* NET   905 = abc_7357_new_n2566
* NET   906 = abc_7357_new_n2565
* NET   907 = abc_7357_new_n2564
* NET   908 = abc_7357_new_n2563
* NET   909 = abc_7357_new_n2562
* NET   910 = abc_7357_new_n2561
* NET   911 = abc_7357_new_n2560
* NET   912 = abc_7357_new_n2559
* NET   913 = abc_7357_new_n2558
* NET   914 = abc_7357_new_n2557
* NET   915 = abc_7357_new_n2556
* NET   916 = abc_7357_new_n2555
* NET   917 = abc_7357_new_n2554
* NET   918 = abc_7357_new_n2552
* NET   919 = abc_7357_new_n2551
* NET   920 = abc_7357_new_n2550
* NET   921 = abc_7357_new_n2549
* NET   922 = abc_7357_new_n2548
* NET   923 = abc_7357_new_n2547
* NET   924 = abc_7357_new_n2546
* NET   925 = abc_7357_new_n2545
* NET   926 = abc_7357_new_n2544
* NET   927 = abc_7357_new_n2543
* NET   928 = abc_7357_new_n2542
* NET   929 = abc_7357_new_n2541
* NET   930 = abc_7357_new_n2540
* NET   931 = abc_7357_new_n2539
* NET   932 = abc_7357_new_n2538
* NET   933 = abc_7357_new_n2537
* NET   934 = abc_7357_new_n2536
* NET   935 = abc_7357_new_n2535
* NET   936 = abc_7357_new_n2534
* NET   937 = abc_7357_new_n2533
* NET   938 = abc_7357_new_n2532
* NET   939 = abc_7357_new_n2530
* NET   940 = abc_7357_new_n2529
* NET   941 = abc_7357_new_n2528
* NET   942 = abc_7357_new_n2527
* NET   943 = abc_7357_new_n2526
* NET   944 = abc_7357_new_n2525
* NET   945 = abc_7357_new_n2524
* NET   946 = abc_7357_new_n2523
* NET   947 = abc_7357_new_n2522
* NET   948 = abc_7357_new_n2521
* NET   949 = abc_7357_new_n2520
* NET   950 = abc_7357_new_n2519
* NET   951 = abc_7357_new_n2518
* NET   952 = abc_7357_new_n2517
* NET   953 = abc_7357_new_n2516
* NET   954 = abc_7357_new_n2514
* NET   955 = abc_7357_new_n2513
* NET   956 = abc_7357_new_n2512
* NET   957 = abc_7357_new_n2511
* NET   958 = abc_7357_new_n2510
* NET   959 = abc_7357_new_n2509
* NET   960 = abc_7357_new_n2508
* NET   961 = abc_7357_new_n2507
* NET   962 = abc_7357_new_n2506
* NET   963 = abc_7357_new_n2505
* NET   964 = abc_7357_new_n2504
* NET   965 = abc_7357_new_n2503
* NET   966 = abc_7357_new_n2502
* NET   967 = abc_7357_new_n2501
* NET   968 = abc_7357_new_n2500
* NET   969 = abc_7357_new_n2499
* NET   970 = abc_7357_new_n2498
* NET   971 = abc_7357_new_n2497
* NET   972 = abc_7357_new_n2496
* NET   973 = abc_7357_new_n2495
* NET   974 = abc_7357_new_n2493
* NET   975 = abc_7357_new_n2492
* NET   976 = abc_7357_new_n2491
* NET   977 = abc_7357_new_n2490
* NET   978 = abc_7357_new_n2489
* NET   979 = abc_7357_new_n2488
* NET   980 = abc_7357_new_n2487
* NET   981 = abc_7357_new_n2486
* NET   982 = abc_7357_new_n2485
* NET   983 = abc_7357_new_n2484
* NET   984 = abc_7357_new_n2483
* NET   985 = abc_7357_new_n2482
* NET   986 = abc_7357_new_n2481
* NET   987 = abc_7357_new_n2480
* NET   988 = abc_7357_new_n2479
* NET   989 = abc_7357_new_n2478
* NET   990 = abc_7357_new_n2476
* NET   991 = abc_7357_new_n2475
* NET   992 = abc_7357_new_n2474
* NET   993 = abc_7357_new_n2473
* NET   994 = abc_7357_new_n2472
* NET   995 = abc_7357_new_n2471
* NET   996 = abc_7357_new_n2470
* NET   997 = abc_7357_new_n2469
* NET   998 = abc_7357_new_n2468
* NET   999 = abc_7357_new_n2467
* NET  1000 = abc_7357_new_n2466
* NET  1001 = abc_7357_new_n2465
* NET  1002 = abc_7357_new_n2464
* NET  1003 = abc_7357_new_n2463
* NET  1004 = abc_7357_new_n2462
* NET  1005 = abc_7357_new_n2461
* NET  1006 = abc_7357_new_n2459
* NET  1007 = abc_7357_new_n2458
* NET  1008 = abc_7357_new_n2457
* NET  1009 = abc_7357_new_n2456
* NET  1010 = abc_7357_new_n2455
* NET  1011 = abc_7357_new_n2454
* NET  1012 = abc_7357_new_n2453
* NET  1013 = abc_7357_new_n2452
* NET  1014 = abc_7357_new_n2451
* NET  1015 = abc_7357_new_n2450
* NET  1016 = abc_7357_new_n2449
* NET  1017 = abc_7357_new_n2448
* NET  1018 = abc_7357_new_n2446
* NET  1019 = abc_7357_new_n2445
* NET  1020 = abc_7357_new_n2444
* NET  1021 = abc_7357_new_n2443
* NET  1022 = abc_7357_new_n2442
* NET  1023 = abc_7357_new_n2441
* NET  1024 = abc_7357_new_n2440
* NET  1025 = abc_7357_new_n2439
* NET  1026 = abc_7357_new_n2438
* NET  1027 = abc_7357_new_n2437
* NET  1028 = abc_7357_new_n2436
* NET  1029 = abc_7357_new_n2435
* NET  1030 = abc_7357_new_n2433
* NET  1031 = abc_7357_new_n2431
* NET  1032 = abc_7357_new_n2430
* NET  1033 = abc_7357_new_n2429
* NET  1034 = abc_7357_new_n2427
* NET  1035 = abc_7357_new_n2426
* NET  1036 = abc_7357_new_n2424
* NET  1037 = abc_7357_new_n2423
* NET  1038 = abc_7357_new_n2421
* NET  1039 = abc_7357_new_n2420
* NET  1040 = abc_7357_new_n2419
* NET  1041 = abc_7357_new_n2417
* NET  1042 = abc_7357_new_n2416
* NET  1043 = abc_7357_new_n2414
* NET  1044 = abc_7357_new_n2413
* NET  1045 = abc_7357_new_n2411
* NET  1046 = abc_7357_new_n2410
* NET  1047 = abc_7357_new_n2408
* NET  1048 = abc_7357_new_n2407
* NET  1049 = abc_7357_new_n2405
* NET  1050 = abc_7357_new_n2404
* NET  1051 = abc_7357_new_n2402
* NET  1052 = abc_7357_new_n2401
* NET  1053 = abc_7357_new_n2399
* NET  1054 = abc_7357_new_n2398
* NET  1055 = abc_7357_new_n2396
* NET  1056 = abc_7357_new_n2395
* NET  1057 = abc_7357_new_n2393
* NET  1058 = abc_7357_new_n2392
* NET  1059 = abc_7357_new_n2390
* NET  1060 = abc_7357_new_n2389
* NET  1061 = abc_7357_new_n2387
* NET  1062 = abc_7357_new_n2386
* NET  1063 = abc_7357_new_n2384
* NET  1064 = abc_7357_new_n2383
* NET  1065 = abc_7357_new_n2381
* NET  1066 = abc_7357_new_n2380
* NET  1067 = abc_7357_new_n2378
* NET  1068 = abc_7357_new_n2377
* NET  1069 = abc_7357_new_n2375
* NET  1070 = abc_7357_new_n2374
* NET  1071 = abc_7357_new_n2372
* NET  1072 = abc_7357_new_n2371
* NET  1073 = abc_7357_new_n2370
* NET  1074 = abc_7357_new_n2368
* NET  1075 = abc_7357_new_n2367
* NET  1076 = abc_7357_new_n2365
* NET  1077 = abc_7357_new_n2364
* NET  1078 = abc_7357_new_n2362
* NET  1079 = abc_7357_new_n2361
* NET  1080 = abc_7357_new_n2359
* NET  1081 = abc_7357_new_n2358
* NET  1082 = abc_7357_new_n2356
* NET  1083 = abc_7357_new_n2355
* NET  1084 = abc_7357_new_n2353
* NET  1085 = abc_7357_new_n2352
* NET  1086 = abc_7357_new_n2350
* NET  1087 = abc_7357_new_n2349
* NET  1088 = abc_7357_new_n2347
* NET  1089 = abc_7357_new_n2346
* NET  1090 = abc_7357_new_n2345
* NET  1091 = abc_7357_new_n2344
* NET  1092 = abc_7357_new_n2342
* NET  1093 = abc_7357_new_n2341
* NET  1094 = abc_7357_new_n2340
* NET  1095 = abc_7357_new_n2339
* NET  1096 = abc_7357_new_n2338
* NET  1097 = abc_7357_new_n2337
* NET  1098 = abc_7357_new_n2336
* NET  1099 = abc_7357_new_n2335
* NET  1100 = abc_7357_new_n2333
* NET  1101 = abc_7357_new_n2332
* NET  1102 = abc_7357_new_n2331
* NET  1103 = abc_7357_new_n2330
* NET  1104 = abc_7357_new_n2329
* NET  1105 = abc_7357_new_n2328
* NET  1106 = abc_7357_new_n2327
* NET  1107 = abc_7357_new_n2326
* NET  1108 = abc_7357_new_n2324
* NET  1109 = abc_7357_new_n2323
* NET  1110 = abc_7357_new_n2322
* NET  1111 = abc_7357_new_n2321
* NET  1112 = abc_7357_new_n2320
* NET  1113 = abc_7357_new_n2319
* NET  1114 = abc_7357_new_n2318
* NET  1115 = abc_7357_new_n2317
* NET  1116 = abc_7357_new_n2316
* NET  1117 = abc_7357_new_n2314
* NET  1118 = abc_7357_new_n2313
* NET  1119 = abc_7357_new_n2312
* NET  1120 = abc_7357_new_n2311
* NET  1121 = abc_7357_new_n2310
* NET  1122 = abc_7357_new_n2309
* NET  1123 = abc_7357_new_n2308
* NET  1124 = abc_7357_new_n2307
* NET  1125 = abc_7357_new_n2305
* NET  1126 = abc_7357_new_n2304
* NET  1127 = abc_7357_new_n2303
* NET  1128 = abc_7357_new_n2302
* NET  1129 = abc_7357_new_n2301
* NET  1130 = abc_7357_new_n2300
* NET  1131 = abc_7357_new_n2299
* NET  1132 = abc_7357_new_n2297
* NET  1133 = abc_7357_new_n2296
* NET  1134 = abc_7357_new_n2295
* NET  1135 = abc_7357_new_n2294
* NET  1136 = abc_7357_new_n2293
* NET  1137 = abc_7357_new_n2292
* NET  1138 = abc_7357_new_n2290
* NET  1139 = abc_7357_new_n2289
* NET  1140 = abc_7357_new_n2288
* NET  1141 = abc_7357_new_n2287
* NET  1142 = abc_7357_new_n2286
* NET  1143 = abc_7357_new_n2285
* NET  1144 = abc_7357_new_n2284
* NET  1145 = abc_7357_new_n2283
* NET  1146 = abc_7357_new_n2281
* NET  1147 = abc_7357_new_n2280
* NET  1148 = abc_7357_new_n2279
* NET  1149 = abc_7357_new_n2278
* NET  1150 = abc_7357_new_n2277
* NET  1151 = abc_7357_new_n2276
* NET  1152 = abc_7357_new_n2274
* NET  1153 = abc_7357_new_n2273
* NET  1154 = abc_7357_new_n2272
* NET  1155 = abc_7357_new_n2271
* NET  1156 = abc_7357_new_n2270
* NET  1157 = abc_7357_new_n2268
* NET  1158 = abc_7357_new_n2267
* NET  1159 = abc_7357_new_n2266
* NET  1160 = abc_7357_new_n2265
* NET  1161 = abc_7357_new_n2264
* NET  1162 = abc_7357_new_n2263
* NET  1163 = abc_7357_new_n2262
* NET  1164 = abc_7357_new_n2261
* NET  1165 = abc_7357_new_n2260
* NET  1166 = abc_7357_new_n2259
* NET  1167 = abc_7357_new_n2258
* NET  1168 = abc_7357_new_n2256
* NET  1169 = abc_7357_new_n2255
* NET  1170 = abc_7357_new_n2254
* NET  1171 = abc_7357_new_n2253
* NET  1172 = abc_7357_new_n2252
* NET  1173 = abc_7357_new_n2251
* NET  1174 = abc_7357_new_n2250
* NET  1175 = abc_7357_new_n2249
* NET  1176 = abc_7357_new_n2248
* NET  1177 = abc_7357_new_n2247
* NET  1178 = abc_7357_new_n2246
* NET  1179 = abc_7357_new_n2244
* NET  1180 = abc_7357_new_n2243
* NET  1181 = abc_7357_new_n2242
* NET  1182 = abc_7357_new_n2241
* NET  1183 = abc_7357_new_n2240
* NET  1184 = abc_7357_new_n2239
* NET  1185 = abc_7357_new_n2238
* NET  1186 = abc_7357_new_n2237
* NET  1187 = abc_7357_new_n2236
* NET  1188 = abc_7357_new_n2235
* NET  1189 = abc_7357_new_n2234
* NET  1190 = abc_7357_new_n2233
* NET  1191 = abc_7357_new_n2232
* NET  1192 = abc_7357_new_n2231
* NET  1193 = abc_7357_new_n2230
* NET  1194 = abc_7357_new_n2229
* NET  1195 = abc_7357_new_n2227
* NET  1196 = abc_7357_new_n2226
* NET  1197 = abc_7357_new_n2225
* NET  1198 = abc_7357_new_n2224
* NET  1199 = abc_7357_new_n2223
* NET  1200 = abc_7357_new_n2222
* NET  1201 = abc_7357_new_n2221
* NET  1202 = abc_7357_new_n2220
* NET  1203 = abc_7357_new_n2219
* NET  1204 = abc_7357_new_n2218
* NET  1205 = abc_7357_new_n2216
* NET  1206 = abc_7357_new_n2215
* NET  1207 = abc_7357_new_n2214
* NET  1208 = abc_7357_new_n2213
* NET  1209 = abc_7357_new_n2212
* NET  1210 = abc_7357_new_n2211
* NET  1211 = abc_7357_new_n2210
* NET  1212 = abc_7357_new_n2209
* NET  1213 = abc_7357_new_n2208
* NET  1214 = abc_7357_new_n2207
* NET  1215 = abc_7357_new_n2206
* NET  1216 = abc_7357_new_n2205
* NET  1217 = abc_7357_new_n2204
* NET  1218 = abc_7357_new_n2203
* NET  1219 = abc_7357_new_n2202
* NET  1220 = abc_7357_new_n2201
* NET  1221 = abc_7357_new_n2200
* NET  1222 = abc_7357_new_n2199
* NET  1223 = abc_7357_new_n2198
* NET  1224 = abc_7357_new_n2197
* NET  1225 = abc_7357_new_n2196
* NET  1226 = abc_7357_new_n2195
* NET  1227 = abc_7357_new_n2194
* NET  1228 = abc_7357_new_n2193
* NET  1229 = abc_7357_new_n2192
* NET  1230 = abc_7357_new_n2191
* NET  1231 = abc_7357_new_n2190
* NET  1232 = abc_7357_new_n2189
* NET  1233 = abc_7357_new_n2188
* NET  1234 = abc_7357_new_n2187
* NET  1235 = abc_7357_new_n2186
* NET  1236 = abc_7357_new_n2185
* NET  1237 = abc_7357_new_n2184
* NET  1238 = abc_7357_new_n2183
* NET  1239 = abc_7357_new_n2182
* NET  1240 = abc_7357_new_n2181
* NET  1241 = abc_7357_new_n2180
* NET  1242 = abc_7357_new_n2179
* NET  1243 = abc_7357_new_n2178
* NET  1244 = abc_7357_new_n2177
* NET  1245 = abc_7357_new_n2176
* NET  1246 = abc_7357_new_n2175
* NET  1247 = abc_7357_new_n2174
* NET  1248 = abc_7357_new_n2173
* NET  1249 = abc_7357_new_n2172
* NET  1250 = abc_7357_new_n2171
* NET  1251 = abc_7357_new_n2170
* NET  1252 = abc_7357_new_n2169
* NET  1253 = abc_7357_new_n2168
* NET  1254 = abc_7357_new_n2167
* NET  1255 = abc_7357_new_n2166
* NET  1256 = abc_7357_new_n2165
* NET  1257 = abc_7357_new_n2164
* NET  1258 = abc_7357_new_n2163
* NET  1259 = abc_7357_new_n2162
* NET  1260 = abc_7357_new_n2161
* NET  1261 = abc_7357_new_n2160
* NET  1262 = abc_7357_new_n2158
* NET  1263 = abc_7357_new_n2157
* NET  1264 = abc_7357_new_n2156
* NET  1265 = abc_7357_new_n2155
* NET  1266 = abc_7357_new_n2154
* NET  1267 = abc_7357_new_n2153
* NET  1268 = abc_7357_new_n2152
* NET  1269 = abc_7357_new_n2151
* NET  1270 = abc_7357_new_n2150
* NET  1271 = abc_7357_new_n2149
* NET  1272 = abc_7357_new_n2148
* NET  1273 = abc_7357_new_n2147
* NET  1274 = abc_7357_new_n2146
* NET  1275 = abc_7357_new_n2145
* NET  1276 = abc_7357_new_n2144
* NET  1277 = abc_7357_new_n2143
* NET  1278 = abc_7357_new_n2142
* NET  1279 = abc_7357_new_n2141
* NET  1280 = abc_7357_new_n2139
* NET  1281 = abc_7357_new_n2138
* NET  1282 = abc_7357_new_n2137
* NET  1283 = abc_7357_new_n2136
* NET  1284 = abc_7357_new_n2134
* NET  1285 = abc_7357_new_n2133
* NET  1286 = abc_7357_new_n2132
* NET  1287 = abc_7357_new_n2131
* NET  1288 = abc_7357_new_n2130
* NET  1289 = abc_7357_new_n2129
* NET  1290 = abc_7357_new_n2128
* NET  1291 = abc_7357_new_n2127
* NET  1292 = abc_7357_new_n2126
* NET  1293 = abc_7357_new_n2125
* NET  1294 = abc_7357_new_n2124
* NET  1295 = abc_7357_new_n2123
* NET  1296 = abc_7357_new_n2122
* NET  1297 = abc_7357_new_n2121
* NET  1298 = abc_7357_new_n2120
* NET  1299 = abc_7357_new_n2119
* NET  1300 = abc_7357_new_n2117
* NET  1301 = abc_7357_new_n2116
* NET  1302 = abc_7357_new_n2115
* NET  1303 = abc_7357_new_n2114
* NET  1304 = abc_7357_new_n2113
* NET  1305 = abc_7357_new_n2112
* NET  1306 = abc_7357_new_n2111
* NET  1307 = abc_7357_new_n2110
* NET  1308 = abc_7357_new_n2109
* NET  1309 = abc_7357_new_n2108
* NET  1310 = abc_7357_new_n2107
* NET  1311 = abc_7357_new_n2106
* NET  1312 = abc_7357_new_n2105
* NET  1313 = abc_7357_new_n2104
* NET  1314 = abc_7357_new_n2103
* NET  1315 = abc_7357_new_n2102
* NET  1316 = abc_7357_new_n2101
* NET  1317 = abc_7357_new_n2100
* NET  1318 = abc_7357_new_n2099
* NET  1319 = abc_7357_new_n2098
* NET  1320 = abc_7357_new_n2097
* NET  1321 = abc_7357_new_n2096
* NET  1322 = abc_7357_new_n2095
* NET  1323 = abc_7357_new_n2094
* NET  1324 = abc_7357_new_n2093
* NET  1325 = abc_7357_new_n2091
* NET  1326 = abc_7357_new_n2090
* NET  1327 = abc_7357_new_n2089
* NET  1328 = abc_7357_new_n2088
* NET  1329 = abc_7357_new_n2087
* NET  1330 = abc_7357_new_n2086
* NET  1331 = abc_7357_new_n2085
* NET  1332 = abc_7357_new_n2084
* NET  1333 = abc_7357_new_n2083
* NET  1334 = abc_7357_new_n2082
* NET  1335 = abc_7357_new_n2081
* NET  1336 = abc_7357_new_n2080
* NET  1337 = abc_7357_new_n2079
* NET  1338 = abc_7357_new_n2078
* NET  1339 = abc_7357_new_n2077
* NET  1340 = abc_7357_new_n2076
* NET  1341 = abc_7357_new_n2075
* NET  1342 = abc_7357_new_n2074
* NET  1343 = abc_7357_new_n2073
* NET  1344 = abc_7357_new_n2072
* NET  1345 = abc_7357_new_n2071
* NET  1346 = abc_7357_new_n2070
* NET  1347 = abc_7357_new_n2069
* NET  1348 = abc_7357_new_n2068
* NET  1349 = abc_7357_new_n2067
* NET  1350 = abc_7357_new_n2066
* NET  1351 = abc_7357_new_n2065
* NET  1352 = abc_7357_new_n2064
* NET  1353 = abc_7357_new_n2063
* NET  1354 = abc_7357_new_n2062
* NET  1355 = abc_7357_new_n2061
* NET  1356 = abc_7357_new_n2060
* NET  1357 = abc_7357_new_n2059
* NET  1358 = abc_7357_new_n2058
* NET  1359 = abc_7357_new_n2056
* NET  1360 = abc_7357_new_n2055
* NET  1361 = abc_7357_new_n2054
* NET  1362 = abc_7357_new_n2053
* NET  1363 = abc_7357_new_n2052
* NET  1364 = abc_7357_new_n2051
* NET  1365 = abc_7357_new_n2050
* NET  1366 = abc_7357_new_n2049
* NET  1367 = abc_7357_new_n2048
* NET  1368 = abc_7357_new_n2047
* NET  1369 = abc_7357_new_n2046
* NET  1370 = abc_7357_new_n2045
* NET  1371 = abc_7357_new_n2044
* NET  1372 = abc_7357_new_n2043
* NET  1373 = abc_7357_new_n2042
* NET  1374 = abc_7357_new_n2041
* NET  1375 = abc_7357_new_n2040
* NET  1376 = abc_7357_new_n2039
* NET  1377 = abc_7357_new_n2038
* NET  1378 = abc_7357_new_n2037
* NET  1379 = abc_7357_new_n2036
* NET  1380 = abc_7357_new_n2035
* NET  1381 = abc_7357_new_n2034
* NET  1382 = abc_7357_new_n2033
* NET  1383 = abc_7357_new_n2032
* NET  1384 = abc_7357_new_n2031
* NET  1385 = abc_7357_new_n2030
* NET  1386 = abc_7357_new_n2029
* NET  1387 = abc_7357_new_n2028
* NET  1388 = abc_7357_new_n2027
* NET  1389 = abc_7357_new_n2026
* NET  1390 = abc_7357_new_n2025
* NET  1391 = abc_7357_new_n2024
* NET  1392 = abc_7357_new_n2022
* NET  1393 = abc_7357_new_n2021
* NET  1394 = abc_7357_new_n2020
* NET  1395 = abc_7357_new_n2019
* NET  1396 = abc_7357_new_n2018
* NET  1397 = abc_7357_new_n2017
* NET  1398 = abc_7357_new_n2016
* NET  1399 = abc_7357_new_n2015
* NET  1400 = abc_7357_new_n2014
* NET  1401 = abc_7357_new_n2013
* NET  1402 = abc_7357_new_n2012
* NET  1403 = abc_7357_new_n2011
* NET  1404 = abc_7357_new_n2010
* NET  1405 = abc_7357_new_n2009
* NET  1406 = abc_7357_new_n2008
* NET  1407 = abc_7357_new_n2007
* NET  1408 = abc_7357_new_n2006
* NET  1409 = abc_7357_new_n2005
* NET  1410 = abc_7357_new_n2004
* NET  1411 = abc_7357_new_n2003
* NET  1412 = abc_7357_new_n2002
* NET  1413 = abc_7357_new_n2001
* NET  1414 = abc_7357_new_n2000
* NET  1415 = abc_7357_new_n1999
* NET  1416 = abc_7357_new_n1998
* NET  1417 = abc_7357_new_n1997
* NET  1418 = abc_7357_new_n1996
* NET  1419 = abc_7357_new_n1995
* NET  1420 = abc_7357_new_n1994
* NET  1421 = abc_7357_new_n1993
* NET  1422 = abc_7357_new_n1992
* NET  1423 = abc_7357_new_n1991
* NET  1424 = abc_7357_new_n1990
* NET  1425 = abc_7357_new_n1989
* NET  1426 = abc_7357_new_n1987
* NET  1427 = abc_7357_new_n1986
* NET  1428 = abc_7357_new_n1985
* NET  1429 = abc_7357_new_n1984
* NET  1430 = abc_7357_new_n1983
* NET  1431 = abc_7357_new_n1982
* NET  1432 = abc_7357_new_n1981
* NET  1433 = abc_7357_new_n1980
* NET  1434 = abc_7357_new_n1979
* NET  1435 = abc_7357_new_n1978
* NET  1436 = abc_7357_new_n1977
* NET  1437 = abc_7357_new_n1976
* NET  1438 = abc_7357_new_n1975
* NET  1439 = abc_7357_new_n1974
* NET  1440 = abc_7357_new_n1973
* NET  1441 = abc_7357_new_n1972
* NET  1442 = abc_7357_new_n1971
* NET  1443 = abc_7357_new_n1970
* NET  1444 = abc_7357_new_n1969
* NET  1445 = abc_7357_new_n1968
* NET  1446 = abc_7357_new_n1967
* NET  1447 = abc_7357_new_n1966
* NET  1448 = abc_7357_new_n1965
* NET  1449 = abc_7357_new_n1964
* NET  1450 = abc_7357_new_n1963
* NET  1451 = abc_7357_new_n1962
* NET  1452 = abc_7357_new_n1961
* NET  1453 = abc_7357_new_n1960
* NET  1454 = abc_7357_new_n1959
* NET  1455 = abc_7357_new_n1958
* NET  1456 = abc_7357_new_n1957
* NET  1457 = abc_7357_new_n1955
* NET  1458 = abc_7357_new_n1954
* NET  1459 = abc_7357_new_n1953
* NET  1460 = abc_7357_new_n1952
* NET  1461 = abc_7357_new_n1951
* NET  1462 = abc_7357_new_n1950
* NET  1463 = abc_7357_new_n1949
* NET  1464 = abc_7357_new_n1948
* NET  1465 = abc_7357_new_n1947
* NET  1466 = abc_7357_new_n1946
* NET  1467 = abc_7357_new_n1945
* NET  1468 = abc_7357_new_n1944
* NET  1469 = abc_7357_new_n1943
* NET  1470 = abc_7357_new_n1942
* NET  1471 = abc_7357_new_n1941
* NET  1472 = abc_7357_new_n1940
* NET  1473 = abc_7357_new_n1939
* NET  1474 = abc_7357_new_n1938
* NET  1475 = abc_7357_new_n1937
* NET  1476 = abc_7357_new_n1936
* NET  1477 = abc_7357_new_n1935
* NET  1478 = abc_7357_new_n1934
* NET  1479 = abc_7357_new_n1933
* NET  1480 = abc_7357_new_n1932
* NET  1481 = abc_7357_new_n1931
* NET  1482 = abc_7357_new_n1930
* NET  1483 = abc_7357_new_n1929
* NET  1484 = abc_7357_new_n1928
* NET  1485 = abc_7357_new_n1927
* NET  1486 = abc_7357_new_n1926
* NET  1487 = abc_7357_new_n1925
* NET  1488 = abc_7357_new_n1924
* NET  1489 = abc_7357_new_n1923
* NET  1490 = abc_7357_new_n1922
* NET  1491 = abc_7357_new_n1921
* NET  1492 = abc_7357_new_n1920
* NET  1493 = abc_7357_new_n1919
* NET  1494 = abc_7357_new_n1918
* NET  1495 = abc_7357_new_n1917
* NET  1496 = abc_7357_new_n1916
* NET  1497 = abc_7357_new_n1914
* NET  1498 = abc_7357_new_n1913
* NET  1499 = abc_7357_new_n1912
* NET  1500 = abc_7357_new_n1911
* NET  1501 = abc_7357_new_n1910
* NET  1502 = abc_7357_new_n1909
* NET  1503 = abc_7357_new_n1908
* NET  1504 = abc_7357_new_n1907
* NET  1505 = abc_7357_new_n1906
* NET  1506 = abc_7357_new_n1905
* NET  1507 = abc_7357_new_n1904
* NET  1508 = abc_7357_new_n1903
* NET  1509 = abc_7357_new_n1902
* NET  1510 = abc_7357_new_n1901
* NET  1511 = abc_7357_new_n1900
* NET  1512 = abc_7357_new_n1899
* NET  1513 = abc_7357_new_n1898
* NET  1514 = abc_7357_new_n1897
* NET  1515 = abc_7357_new_n1896
* NET  1516 = abc_7357_new_n1895
* NET  1517 = abc_7357_new_n1894
* NET  1518 = abc_7357_new_n1893
* NET  1519 = abc_7357_new_n1892
* NET  1520 = abc_7357_new_n1891
* NET  1521 = abc_7357_new_n1890
* NET  1522 = abc_7357_new_n1889
* NET  1523 = abc_7357_new_n1888
* NET  1524 = abc_7357_new_n1887
* NET  1525 = abc_7357_new_n1886
* NET  1526 = abc_7357_new_n1885
* NET  1527 = abc_7357_new_n1884
* NET  1528 = abc_7357_new_n1883
* NET  1529 = abc_7357_new_n1882
* NET  1530 = abc_7357_new_n1881
* NET  1531 = abc_7357_new_n1880
* NET  1532 = abc_7357_new_n1879
* NET  1533 = abc_7357_new_n1878
* NET  1534 = abc_7357_new_n1877
* NET  1535 = abc_7357_new_n1876
* NET  1536 = abc_7357_new_n1874
* NET  1537 = abc_7357_new_n1873
* NET  1538 = abc_7357_new_n1872
* NET  1539 = abc_7357_new_n1871
* NET  1540 = abc_7357_new_n1870
* NET  1541 = abc_7357_new_n1869
* NET  1542 = abc_7357_new_n1868
* NET  1543 = abc_7357_new_n1867
* NET  1544 = abc_7357_new_n1866
* NET  1545 = abc_7357_new_n1865
* NET  1546 = abc_7357_new_n1864
* NET  1547 = abc_7357_new_n1863
* NET  1548 = abc_7357_new_n1862
* NET  1549 = abc_7357_new_n1861
* NET  1550 = abc_7357_new_n1860
* NET  1551 = abc_7357_new_n1859
* NET  1552 = abc_7357_new_n1858
* NET  1553 = abc_7357_new_n1857
* NET  1554 = abc_7357_new_n1856
* NET  1555 = abc_7357_new_n1855
* NET  1556 = abc_7357_new_n1854
* NET  1557 = abc_7357_new_n1853
* NET  1558 = abc_7357_new_n1852
* NET  1559 = abc_7357_new_n1851
* NET  1560 = abc_7357_new_n1850
* NET  1561 = abc_7357_new_n1849
* NET  1562 = abc_7357_new_n1848
* NET  1563 = abc_7357_new_n1847
* NET  1564 = abc_7357_new_n1846
* NET  1565 = abc_7357_new_n1845
* NET  1566 = abc_7357_new_n1844
* NET  1567 = abc_7357_new_n1843
* NET  1568 = abc_7357_new_n1842
* NET  1569 = abc_7357_new_n1841
* NET  1570 = abc_7357_new_n1840
* NET  1571 = abc_7357_new_n1839
* NET  1572 = abc_7357_new_n1838
* NET  1573 = abc_7357_new_n1837
* NET  1574 = abc_7357_new_n1836
* NET  1575 = abc_7357_new_n1835
* NET  1576 = abc_7357_new_n1833
* NET  1577 = abc_7357_new_n1832
* NET  1578 = abc_7357_new_n1831
* NET  1579 = abc_7357_new_n1830
* NET  1580 = abc_7357_new_n1829
* NET  1581 = abc_7357_new_n1828
* NET  1582 = abc_7357_new_n1827
* NET  1583 = abc_7357_new_n1826
* NET  1584 = abc_7357_new_n1825
* NET  1585 = abc_7357_new_n1824
* NET  1586 = abc_7357_new_n1823
* NET  1587 = abc_7357_new_n1822
* NET  1588 = abc_7357_new_n1821
* NET  1589 = abc_7357_new_n1820
* NET  1590 = abc_7357_new_n1819
* NET  1591 = abc_7357_new_n1818
* NET  1592 = abc_7357_new_n1817
* NET  1593 = abc_7357_new_n1816
* NET  1594 = abc_7357_new_n1815
* NET  1595 = abc_7357_new_n1814
* NET  1596 = abc_7357_new_n1813
* NET  1597 = abc_7357_new_n1812
* NET  1598 = abc_7357_new_n1811
* NET  1599 = abc_7357_new_n1810
* NET  1600 = abc_7357_new_n1809
* NET  1601 = abc_7357_new_n1808
* NET  1602 = abc_7357_new_n1807
* NET  1603 = abc_7357_new_n1806
* NET  1604 = abc_7357_new_n1805
* NET  1605 = abc_7357_new_n1804
* NET  1606 = abc_7357_new_n1803
* NET  1607 = abc_7357_new_n1802
* NET  1608 = abc_7357_new_n1801
* NET  1609 = abc_7357_new_n1800
* NET  1610 = abc_7357_new_n1799
* NET  1611 = abc_7357_new_n1798
* NET  1612 = abc_7357_new_n1797
* NET  1613 = abc_7357_new_n1796
* NET  1614 = abc_7357_new_n1795
* NET  1615 = abc_7357_new_n1794
* NET  1616 = abc_7357_new_n1793
* NET  1617 = abc_7357_new_n1792
* NET  1618 = abc_7357_new_n1791
* NET  1619 = abc_7357_new_n1789
* NET  1620 = abc_7357_new_n1788
* NET  1621 = abc_7357_new_n1787
* NET  1622 = abc_7357_new_n1786
* NET  1623 = abc_7357_new_n1785
* NET  1624 = abc_7357_new_n1784
* NET  1625 = abc_7357_new_n1783
* NET  1626 = abc_7357_new_n1782
* NET  1627 = abc_7357_new_n1781
* NET  1628 = abc_7357_new_n1780
* NET  1629 = abc_7357_new_n1779
* NET  1630 = abc_7357_new_n1778
* NET  1631 = abc_7357_new_n1777
* NET  1632 = abc_7357_new_n1776
* NET  1633 = abc_7357_new_n1775
* NET  1634 = abc_7357_new_n1774
* NET  1635 = abc_7357_new_n1773
* NET  1636 = abc_7357_new_n1772
* NET  1637 = abc_7357_new_n1771
* NET  1638 = abc_7357_new_n1770
* NET  1639 = abc_7357_new_n1769
* NET  1640 = abc_7357_new_n1768
* NET  1641 = abc_7357_new_n1767
* NET  1642 = abc_7357_new_n1766
* NET  1643 = abc_7357_new_n1765
* NET  1644 = abc_7357_new_n1764
* NET  1645 = abc_7357_new_n1763
* NET  1646 = abc_7357_new_n1762
* NET  1647 = abc_7357_new_n1761
* NET  1648 = abc_7357_new_n1760
* NET  1649 = abc_7357_new_n1759
* NET  1650 = abc_7357_new_n1758
* NET  1651 = abc_7357_new_n1757
* NET  1652 = abc_7357_new_n1756
* NET  1653 = abc_7357_new_n1755
* NET  1654 = abc_7357_new_n1754
* NET  1655 = abc_7357_new_n1753
* NET  1656 = abc_7357_new_n1752
* NET  1657 = abc_7357_new_n1751
* NET  1658 = abc_7357_new_n1750
* NET  1659 = abc_7357_new_n1749
* NET  1660 = abc_7357_new_n1748
* NET  1661 = abc_7357_new_n1747
* NET  1662 = abc_7357_new_n1746
* NET  1663 = abc_7357_new_n1745
* NET  1664 = abc_7357_new_n1744
* NET  1665 = abc_7357_new_n1742
* NET  1666 = abc_7357_new_n1741
* NET  1667 = abc_7357_new_n1740
* NET  1668 = abc_7357_new_n1739
* NET  1669 = abc_7357_new_n1738
* NET  1670 = abc_7357_new_n1737
* NET  1671 = abc_7357_new_n1736
* NET  1672 = abc_7357_new_n1735
* NET  1673 = abc_7357_new_n1734
* NET  1674 = abc_7357_new_n1733
* NET  1675 = abc_7357_new_n1732
* NET  1676 = abc_7357_new_n1731
* NET  1677 = abc_7357_new_n1730
* NET  1678 = abc_7357_new_n1729
* NET  1679 = abc_7357_new_n1728
* NET  1680 = abc_7357_new_n1727
* NET  1681 = abc_7357_new_n1726
* NET  1682 = abc_7357_new_n1725
* NET  1683 = abc_7357_new_n1724
* NET  1684 = abc_7357_new_n1723
* NET  1685 = abc_7357_new_n1722
* NET  1686 = abc_7357_new_n1721
* NET  1687 = abc_7357_new_n1720
* NET  1688 = abc_7357_new_n1719
* NET  1689 = abc_7357_new_n1718
* NET  1690 = abc_7357_new_n1717
* NET  1691 = abc_7357_new_n1716
* NET  1692 = abc_7357_new_n1715
* NET  1693 = abc_7357_new_n1714
* NET  1694 = abc_7357_new_n1713
* NET  1695 = abc_7357_new_n1712
* NET  1696 = abc_7357_new_n1711
* NET  1697 = abc_7357_new_n1710
* NET  1698 = abc_7357_new_n1709
* NET  1699 = abc_7357_new_n1708
* NET  1700 = abc_7357_new_n1707
* NET  1701 = abc_7357_new_n1706
* NET  1702 = abc_7357_new_n1705
* NET  1703 = abc_7357_new_n1704
* NET  1704 = abc_7357_new_n1703
* NET  1705 = abc_7357_new_n1702
* NET  1706 = abc_7357_new_n1701
* NET  1707 = abc_7357_new_n1700
* NET  1708 = abc_7357_new_n1699
* NET  1709 = abc_7357_new_n1697
* NET  1710 = abc_7357_new_n1696
* NET  1711 = abc_7357_new_n1695
* NET  1712 = abc_7357_new_n1694
* NET  1713 = abc_7357_new_n1693
* NET  1714 = abc_7357_new_n1692
* NET  1715 = abc_7357_new_n1691
* NET  1716 = abc_7357_new_n1690
* NET  1717 = abc_7357_new_n1689
* NET  1718 = abc_7357_new_n1688
* NET  1719 = abc_7357_new_n1687
* NET  1720 = abc_7357_new_n1686
* NET  1721 = abc_7357_new_n1685
* NET  1722 = abc_7357_new_n1684
* NET  1723 = abc_7357_new_n1683
* NET  1724 = abc_7357_new_n1682
* NET  1725 = abc_7357_new_n1681
* NET  1726 = abc_7357_new_n1680
* NET  1727 = abc_7357_new_n1679
* NET  1728 = abc_7357_new_n1678
* NET  1729 = abc_7357_new_n1677
* NET  1730 = abc_7357_new_n1676
* NET  1731 = abc_7357_new_n1675
* NET  1732 = abc_7357_new_n1674
* NET  1733 = abc_7357_new_n1673
* NET  1734 = abc_7357_new_n1672
* NET  1735 = abc_7357_new_n1671
* NET  1736 = abc_7357_new_n1670
* NET  1737 = abc_7357_new_n1669
* NET  1738 = abc_7357_new_n1668
* NET  1739 = abc_7357_new_n1667
* NET  1740 = abc_7357_new_n1666
* NET  1741 = abc_7357_new_n1665
* NET  1742 = abc_7357_new_n1664
* NET  1743 = abc_7357_new_n1663
* NET  1744 = abc_7357_new_n1662
* NET  1745 = abc_7357_new_n1661
* NET  1746 = abc_7357_new_n1660
* NET  1747 = abc_7357_new_n1659
* NET  1748 = abc_7357_new_n1658
* NET  1749 = abc_7357_new_n1657
* NET  1750 = abc_7357_new_n1656
* NET  1751 = abc_7357_new_n1655
* NET  1752 = abc_7357_new_n1654
* NET  1753 = abc_7357_new_n1653
* NET  1754 = abc_7357_new_n1652
* NET  1755 = abc_7357_new_n1651
* NET  1756 = abc_7357_new_n1650
* NET  1757 = abc_7357_new_n1648
* NET  1758 = abc_7357_new_n1647
* NET  1759 = abc_7357_new_n1646
* NET  1760 = abc_7357_new_n1645
* NET  1761 = abc_7357_new_n1644
* NET  1762 = abc_7357_new_n1643
* NET  1763 = abc_7357_new_n1642
* NET  1764 = abc_7357_new_n1641
* NET  1765 = abc_7357_new_n1640
* NET  1766 = abc_7357_new_n1639
* NET  1767 = abc_7357_new_n1638
* NET  1768 = abc_7357_new_n1637
* NET  1769 = abc_7357_new_n1636
* NET  1770 = abc_7357_new_n1635
* NET  1771 = abc_7357_new_n1634
* NET  1772 = abc_7357_new_n1633
* NET  1773 = abc_7357_new_n1632
* NET  1774 = abc_7357_new_n1631
* NET  1775 = abc_7357_new_n1630
* NET  1776 = abc_7357_new_n1629
* NET  1777 = abc_7357_new_n1628
* NET  1778 = abc_7357_new_n1627
* NET  1779 = abc_7357_new_n1626
* NET  1780 = abc_7357_new_n1625
* NET  1781 = abc_7357_new_n1624
* NET  1782 = abc_7357_new_n1623
* NET  1783 = abc_7357_new_n1622
* NET  1784 = abc_7357_new_n1621
* NET  1785 = abc_7357_new_n1620
* NET  1786 = abc_7357_new_n1619
* NET  1787 = abc_7357_new_n1618
* NET  1788 = abc_7357_new_n1617
* NET  1789 = abc_7357_new_n1616
* NET  1790 = abc_7357_new_n1615
* NET  1791 = abc_7357_new_n1614
* NET  1792 = abc_7357_new_n1613
* NET  1793 = abc_7357_new_n1612
* NET  1794 = abc_7357_new_n1611
* NET  1795 = abc_7357_new_n1610
* NET  1796 = abc_7357_new_n1609
* NET  1797 = abc_7357_new_n1608
* NET  1798 = abc_7357_new_n1607
* NET  1799 = abc_7357_new_n1606
* NET  1800 = abc_7357_new_n1605
* NET  1801 = abc_7357_new_n1603
* NET  1802 = abc_7357_new_n1602
* NET  1803 = abc_7357_new_n1601
* NET  1804 = abc_7357_new_n1600
* NET  1805 = abc_7357_new_n1599
* NET  1806 = abc_7357_new_n1598
* NET  1807 = abc_7357_new_n1597
* NET  1808 = abc_7357_new_n1596
* NET  1809 = abc_7357_new_n1595
* NET  1810 = abc_7357_new_n1594
* NET  1811 = abc_7357_new_n1593
* NET  1812 = abc_7357_new_n1592
* NET  1813 = abc_7357_new_n1591
* NET  1814 = abc_7357_new_n1590
* NET  1815 = abc_7357_new_n1589
* NET  1816 = abc_7357_new_n1588
* NET  1817 = abc_7357_new_n1587
* NET  1818 = abc_7357_new_n1586
* NET  1819 = abc_7357_new_n1585
* NET  1820 = abc_7357_new_n1584
* NET  1821 = abc_7357_new_n1583
* NET  1822 = abc_7357_new_n1582
* NET  1823 = abc_7357_new_n1581
* NET  1824 = abc_7357_new_n1580
* NET  1825 = abc_7357_new_n1579
* NET  1826 = abc_7357_new_n1578
* NET  1827 = abc_7357_new_n1577
* NET  1828 = abc_7357_new_n1576
* NET  1829 = abc_7357_new_n1575
* NET  1830 = abc_7357_new_n1574
* NET  1831 = abc_7357_new_n1573
* NET  1832 = abc_7357_new_n1572
* NET  1833 = abc_7357_new_n1571
* NET  1834 = abc_7357_new_n1570
* NET  1835 = abc_7357_new_n1569
* NET  1836 = abc_7357_new_n1568
* NET  1837 = abc_7357_new_n1567
* NET  1838 = abc_7357_new_n1566
* NET  1839 = abc_7357_new_n1565
* NET  1840 = abc_7357_new_n1564
* NET  1841 = abc_7357_new_n1563
* NET  1842 = abc_7357_new_n1562
* NET  1843 = abc_7357_new_n1561
* NET  1844 = abc_7357_new_n1560
* NET  1845 = abc_7357_new_n1559
* NET  1846 = abc_7357_new_n1558
* NET  1847 = abc_7357_new_n1557
* NET  1848 = abc_7357_new_n1556
* NET  1849 = abc_7357_new_n1555
* NET  1850 = abc_7357_new_n1554
* NET  1851 = abc_7357_new_n1553
* NET  1852 = abc_7357_new_n1552
* NET  1853 = abc_7357_new_n1551
* NET  1854 = abc_7357_new_n1549
* NET  1855 = abc_7357_new_n1548
* NET  1856 = abc_7357_new_n1547
* NET  1857 = abc_7357_new_n1546
* NET  1858 = abc_7357_new_n1545
* NET  1859 = abc_7357_new_n1544
* NET  1860 = abc_7357_new_n1543
* NET  1861 = abc_7357_new_n1542
* NET  1862 = abc_7357_new_n1541
* NET  1863 = abc_7357_new_n1540
* NET  1864 = abc_7357_new_n1539
* NET  1865 = abc_7357_new_n1538
* NET  1866 = abc_7357_new_n1537
* NET  1867 = abc_7357_new_n1536
* NET  1868 = abc_7357_new_n1535
* NET  1869 = abc_7357_new_n1534
* NET  1870 = abc_7357_new_n1533
* NET  1871 = abc_7357_new_n1532
* NET  1872 = abc_7357_new_n1531
* NET  1873 = abc_7357_new_n1530
* NET  1874 = abc_7357_new_n1529
* NET  1875 = abc_7357_new_n1528
* NET  1876 = abc_7357_new_n1527
* NET  1877 = abc_7357_new_n1526
* NET  1878 = abc_7357_new_n1525
* NET  1879 = abc_7357_new_n1524
* NET  1880 = abc_7357_new_n1523
* NET  1881 = abc_7357_new_n1522
* NET  1882 = abc_7357_new_n1521
* NET  1883 = abc_7357_new_n1520
* NET  1884 = abc_7357_new_n1519
* NET  1885 = abc_7357_new_n1518
* NET  1886 = abc_7357_new_n1517
* NET  1887 = abc_7357_new_n1516
* NET  1888 = abc_7357_new_n1515
* NET  1889 = abc_7357_new_n1513
* NET  1890 = abc_7357_new_n1512
* NET  1891 = abc_7357_new_n1511
* NET  1892 = abc_7357_new_n1510
* NET  1893 = abc_7357_new_n1509
* NET  1894 = abc_7357_new_n1508
* NET  1895 = abc_7357_new_n1507
* NET  1896 = abc_7357_new_n1506
* NET  1897 = abc_7357_new_n1505
* NET  1898 = abc_7357_new_n1504
* NET  1899 = abc_7357_new_n1503
* NET  1900 = abc_7357_new_n1502
* NET  1901 = abc_7357_new_n1501
* NET  1902 = abc_7357_new_n1500
* NET  1903 = abc_7357_new_n1499
* NET  1904 = abc_7357_new_n1498
* NET  1905 = abc_7357_new_n1497
* NET  1906 = abc_7357_new_n1496
* NET  1907 = abc_7357_new_n1495
* NET  1908 = abc_7357_new_n1494
* NET  1909 = abc_7357_new_n1493
* NET  1910 = abc_7357_new_n1492
* NET  1911 = abc_7357_new_n1491
* NET  1912 = abc_7357_new_n1490
* NET  1913 = abc_7357_new_n1488
* NET  1914 = abc_7357_new_n1487
* NET  1915 = abc_7357_new_n1486
* NET  1916 = abc_7357_new_n1485
* NET  1917 = abc_7357_new_n1484
* NET  1918 = abc_7357_new_n1483
* NET  1919 = abc_7357_new_n1482
* NET  1920 = abc_7357_new_n1481
* NET  1921 = abc_7357_new_n1480
* NET  1922 = abc_7357_new_n1479
* NET  1923 = abc_7357_new_n1478
* NET  1924 = abc_7357_new_n1477
* NET  1925 = abc_7357_new_n1476
* NET  1926 = abc_7357_new_n1475
* NET  1927 = abc_7357_new_n1474
* NET  1928 = abc_7357_new_n1473
* NET  1929 = abc_7357_new_n1472
* NET  1930 = abc_7357_new_n1471
* NET  1931 = abc_7357_new_n1470
* NET  1932 = abc_7357_new_n1469
* NET  1933 = abc_7357_new_n1468
* NET  1934 = abc_7357_new_n1467
* NET  1935 = abc_7357_new_n1466
* NET  1936 = abc_7357_new_n1465
* NET  1937 = abc_7357_new_n1464
* NET  1938 = abc_7357_new_n1463
* NET  1939 = abc_7357_new_n1462
* NET  1940 = abc_7357_new_n1461
* NET  1941 = abc_7357_new_n1460
* NET  1942 = abc_7357_new_n1459
* NET  1943 = abc_7357_new_n1458
* NET  1944 = abc_7357_new_n1457
* NET  1945 = abc_7357_new_n1456
* NET  1946 = abc_7357_new_n1454
* NET  1947 = abc_7357_new_n1453
* NET  1948 = abc_7357_new_n1452
* NET  1949 = abc_7357_new_n1451
* NET  1950 = abc_7357_new_n1450
* NET  1951 = abc_7357_new_n1449
* NET  1952 = abc_7357_new_n1448
* NET  1953 = abc_7357_new_n1447
* NET  1954 = abc_7357_new_n1446
* NET  1955 = abc_7357_new_n1445
* NET  1956 = abc_7357_new_n1444
* NET  1957 = abc_7357_new_n1443
* NET  1958 = abc_7357_new_n1442
* NET  1959 = abc_7357_new_n1441
* NET  1960 = abc_7357_new_n1440
* NET  1961 = abc_7357_new_n1439
* NET  1962 = abc_7357_new_n1438
* NET  1963 = abc_7357_new_n1437
* NET  1964 = abc_7357_new_n1436
* NET  1965 = abc_7357_new_n1435
* NET  1966 = abc_7357_new_n1434
* NET  1967 = abc_7357_new_n1433
* NET  1968 = abc_7357_new_n1432
* NET  1969 = abc_7357_new_n1431
* NET  1970 = abc_7357_new_n1430
* NET  1971 = abc_7357_new_n1429
* NET  1972 = abc_7357_new_n1428
* NET  1973 = abc_7357_new_n1427
* NET  1974 = abc_7357_new_n1426
* NET  1975 = abc_7357_new_n1425
* NET  1976 = abc_7357_new_n1424
* NET  1977 = abc_7357_new_n1423
* NET  1978 = abc_7357_new_n1422
* NET  1979 = abc_7357_new_n1421
* NET  1980 = abc_7357_new_n1420
* NET  1981 = abc_7357_new_n1419
* NET  1982 = abc_7357_new_n1418
* NET  1983 = abc_7357_new_n1417
* NET  1984 = abc_7357_new_n1416
* NET  1985 = abc_7357_new_n1415
* NET  1986 = abc_7357_new_n1413
* NET  1987 = abc_7357_new_n1412
* NET  1988 = abc_7357_new_n1411
* NET  1989 = abc_7357_new_n1410
* NET  1990 = abc_7357_new_n1409
* NET  1991 = abc_7357_new_n1408
* NET  1992 = abc_7357_new_n1407
* NET  1993 = abc_7357_new_n1406
* NET  1994 = abc_7357_new_n1405
* NET  1995 = abc_7357_new_n1404
* NET  1996 = abc_7357_new_n1403
* NET  1997 = abc_7357_new_n1402
* NET  1998 = abc_7357_new_n1401
* NET  1999 = abc_7357_new_n1400
* NET  2000 = abc_7357_new_n1399
* NET  2001 = abc_7357_new_n1398
* NET  2002 = abc_7357_new_n1397
* NET  2003 = abc_7357_new_n1396
* NET  2004 = abc_7357_new_n1395
* NET  2005 = abc_7357_new_n1394
* NET  2006 = abc_7357_new_n1393
* NET  2007 = abc_7357_new_n1392
* NET  2008 = abc_7357_new_n1391
* NET  2009 = abc_7357_new_n1390
* NET  2010 = abc_7357_new_n1389
* NET  2011 = abc_7357_new_n1388
* NET  2012 = abc_7357_new_n1387
* NET  2013 = abc_7357_new_n1386
* NET  2014 = abc_7357_new_n1385
* NET  2015 = abc_7357_new_n1384
* NET  2016 = abc_7357_new_n1383
* NET  2017 = abc_7357_new_n1382
* NET  2018 = abc_7357_new_n1381
* NET  2019 = abc_7357_new_n1380
* NET  2020 = abc_7357_new_n1379
* NET  2021 = abc_7357_new_n1378
* NET  2022 = abc_7357_new_n1377
* NET  2023 = abc_7357_new_n1376
* NET  2024 = abc_7357_new_n1375
* NET  2025 = abc_7357_new_n1374
* NET  2026 = abc_7357_new_n1373
* NET  2027 = abc_7357_new_n1372
* NET  2028 = abc_7357_new_n1371
* NET  2029 = abc_7357_new_n1370
* NET  2030 = abc_7357_new_n1368
* NET  2031 = abc_7357_new_n1367
* NET  2032 = abc_7357_new_n1366
* NET  2033 = abc_7357_new_n1365
* NET  2034 = abc_7357_new_n1364
* NET  2035 = abc_7357_new_n1363
* NET  2036 = abc_7357_new_n1362
* NET  2037 = abc_7357_new_n1361
* NET  2038 = abc_7357_new_n1360
* NET  2039 = abc_7357_new_n1359
* NET  2040 = abc_7357_new_n1358
* NET  2041 = abc_7357_new_n1357
* NET  2042 = abc_7357_new_n1356
* NET  2043 = abc_7357_new_n1355
* NET  2044 = abc_7357_new_n1354
* NET  2045 = abc_7357_new_n1353
* NET  2046 = abc_7357_new_n1352
* NET  2047 = abc_7357_new_n1351
* NET  2048 = abc_7357_new_n1350
* NET  2049 = abc_7357_new_n1349
* NET  2050 = abc_7357_new_n1348
* NET  2051 = abc_7357_new_n1347
* NET  2052 = abc_7357_new_n1346
* NET  2053 = abc_7357_new_n1345
* NET  2054 = abc_7357_new_n1344
* NET  2055 = abc_7357_new_n1343
* NET  2056 = abc_7357_new_n1342
* NET  2057 = abc_7357_new_n1341
* NET  2058 = abc_7357_new_n1340
* NET  2059 = abc_7357_new_n1339
* NET  2060 = abc_7357_new_n1338
* NET  2061 = abc_7357_new_n1337
* NET  2062 = abc_7357_new_n1336
* NET  2063 = abc_7357_new_n1335
* NET  2064 = abc_7357_new_n1334
* NET  2065 = abc_7357_new_n1333
* NET  2066 = abc_7357_new_n1332
* NET  2067 = abc_7357_new_n1331
* NET  2068 = abc_7357_new_n1330
* NET  2069 = abc_7357_new_n1329
* NET  2070 = abc_7357_new_n1328
* NET  2071 = abc_7357_new_n1327
* NET  2072 = abc_7357_new_n1326
* NET  2073 = abc_7357_new_n1325
* NET  2074 = abc_7357_new_n1324
* NET  2075 = abc_7357_new_n1322
* NET  2076 = abc_7357_new_n1321
* NET  2077 = abc_7357_new_n1320
* NET  2078 = abc_7357_new_n1319
* NET  2079 = abc_7357_new_n1318
* NET  2080 = abc_7357_new_n1317
* NET  2081 = abc_7357_new_n1316
* NET  2082 = abc_7357_new_n1315
* NET  2083 = abc_7357_new_n1314
* NET  2084 = abc_7357_new_n1313
* NET  2085 = abc_7357_new_n1312
* NET  2086 = abc_7357_new_n1311
* NET  2087 = abc_7357_new_n1310
* NET  2088 = abc_7357_new_n1309
* NET  2089 = abc_7357_new_n1308
* NET  2090 = abc_7357_new_n1307
* NET  2091 = abc_7357_new_n1306
* NET  2092 = abc_7357_new_n1305
* NET  2093 = abc_7357_new_n1304
* NET  2094 = abc_7357_new_n1303
* NET  2095 = abc_7357_new_n1302
* NET  2096 = abc_7357_new_n1301
* NET  2097 = abc_7357_new_n1300
* NET  2098 = abc_7357_new_n1299
* NET  2099 = abc_7357_new_n1298
* NET  2100 = abc_7357_new_n1297
* NET  2101 = abc_7357_new_n1296
* NET  2102 = abc_7357_new_n1295
* NET  2103 = abc_7357_new_n1294
* NET  2104 = abc_7357_new_n1293
* NET  2105 = abc_7357_new_n1292
* NET  2106 = abc_7357_new_n1291
* NET  2107 = abc_7357_new_n1290
* NET  2108 = abc_7357_new_n1289
* NET  2109 = abc_7357_new_n1288
* NET  2110 = abc_7357_new_n1287
* NET  2111 = abc_7357_new_n1286
* NET  2112 = abc_7357_new_n1285
* NET  2113 = abc_7357_new_n1284
* NET  2114 = abc_7357_new_n1283
* NET  2115 = abc_7357_new_n1282
* NET  2116 = abc_7357_new_n1281
* NET  2117 = abc_7357_new_n1280
* NET  2118 = abc_7357_new_n1279
* NET  2119 = abc_7357_new_n1278
* NET  2120 = abc_7357_new_n1277
* NET  2121 = abc_7357_new_n1276
* NET  2122 = abc_7357_new_n1275
* NET  2123 = abc_7357_new_n1273
* NET  2124 = abc_7357_new_n1272
* NET  2125 = abc_7357_new_n1271
* NET  2126 = abc_7357_new_n1270
* NET  2127 = abc_7357_new_n1269
* NET  2128 = abc_7357_new_n1268
* NET  2129 = abc_7357_new_n1267
* NET  2130 = abc_7357_new_n1266
* NET  2131 = abc_7357_new_n1265
* NET  2132 = abc_7357_new_n1264
* NET  2133 = abc_7357_new_n1263
* NET  2134 = abc_7357_new_n1262
* NET  2135 = abc_7357_new_n1261
* NET  2136 = abc_7357_new_n1260
* NET  2137 = abc_7357_new_n1259
* NET  2138 = abc_7357_new_n1258
* NET  2139 = abc_7357_new_n1257
* NET  2140 = abc_7357_new_n1256
* NET  2141 = abc_7357_new_n1255
* NET  2142 = abc_7357_new_n1254
* NET  2143 = abc_7357_new_n1253
* NET  2144 = abc_7357_new_n1252
* NET  2145 = abc_7357_new_n1251
* NET  2146 = abc_7357_new_n1250
* NET  2147 = abc_7357_new_n1249
* NET  2148 = abc_7357_new_n1248
* NET  2149 = abc_7357_new_n1247
* NET  2150 = abc_7357_new_n1246
* NET  2151 = abc_7357_new_n1245
* NET  2152 = abc_7357_new_n1244
* NET  2153 = abc_7357_new_n1243
* NET  2154 = abc_7357_new_n1242
* NET  2155 = abc_7357_new_n1241
* NET  2156 = abc_7357_new_n1240
* NET  2157 = abc_7357_new_n1239
* NET  2158 = abc_7357_new_n1238
* NET  2159 = abc_7357_new_n1237
* NET  2160 = abc_7357_new_n1236
* NET  2161 = abc_7357_new_n1235
* NET  2162 = abc_7357_new_n1234
* NET  2163 = abc_7357_new_n1233
* NET  2164 = abc_7357_new_n1232
* NET  2165 = abc_7357_new_n1231
* NET  2166 = abc_7357_new_n1230
* NET  2167 = abc_7357_new_n1229
* NET  2168 = abc_7357_new_n1228
* NET  2169 = abc_7357_new_n1227
* NET  2170 = abc_7357_new_n1225
* NET  2171 = abc_7357_new_n1224
* NET  2172 = abc_7357_new_n1223
* NET  2173 = abc_7357_new_n1222
* NET  2174 = abc_7357_new_n1221
* NET  2175 = abc_7357_new_n1220
* NET  2176 = abc_7357_new_n1219
* NET  2177 = abc_7357_new_n1218
* NET  2178 = abc_7357_new_n1217
* NET  2179 = abc_7357_new_n1216
* NET  2180 = abc_7357_new_n1215
* NET  2181 = abc_7357_new_n1214
* NET  2182 = abc_7357_new_n1213
* NET  2183 = abc_7357_new_n1212
* NET  2184 = abc_7357_new_n1211
* NET  2185 = abc_7357_new_n1210
* NET  2186 = abc_7357_new_n1209
* NET  2187 = abc_7357_new_n1208
* NET  2188 = abc_7357_new_n1207
* NET  2189 = abc_7357_new_n1206
* NET  2190 = abc_7357_new_n1205
* NET  2191 = abc_7357_new_n1204
* NET  2192 = abc_7357_new_n1203
* NET  2193 = abc_7357_new_n1202
* NET  2194 = abc_7357_new_n1201
* NET  2195 = abc_7357_new_n1200
* NET  2196 = abc_7357_new_n1199
* NET  2197 = abc_7357_new_n1198
* NET  2198 = abc_7357_new_n1197
* NET  2199 = abc_7357_new_n1196
* NET  2200 = abc_7357_new_n1195
* NET  2201 = abc_7357_new_n1194
* NET  2202 = abc_7357_new_n1193
* NET  2203 = abc_7357_new_n1192
* NET  2204 = abc_7357_new_n1191
* NET  2205 = abc_7357_new_n1190
* NET  2206 = abc_7357_new_n1189
* NET  2207 = abc_7357_new_n1188
* NET  2208 = abc_7357_new_n1187
* NET  2209 = abc_7357_new_n1186
* NET  2210 = abc_7357_new_n1185
* NET  2211 = abc_7357_new_n1184
* NET  2212 = abc_7357_new_n1183
* NET  2213 = abc_7357_new_n1182
* NET  2214 = abc_7357_new_n1181
* NET  2215 = abc_7357_new_n1180
* NET  2216 = abc_7357_new_n1179
* NET  2217 = abc_7357_new_n1177
* NET  2218 = abc_7357_new_n1176
* NET  2219 = abc_7357_new_n1175
* NET  2220 = abc_7357_new_n1174
* NET  2221 = abc_7357_new_n1173
* NET  2222 = abc_7357_new_n1172
* NET  2223 = abc_7357_new_n1171
* NET  2224 = abc_7357_new_n1170
* NET  2225 = abc_7357_new_n1169
* NET  2226 = abc_7357_new_n1168
* NET  2227 = abc_7357_new_n1167
* NET  2228 = abc_7357_new_n1166
* NET  2229 = abc_7357_new_n1165
* NET  2230 = abc_7357_new_n1164
* NET  2231 = abc_7357_new_n1163
* NET  2232 = abc_7357_new_n1162
* NET  2233 = abc_7357_new_n1161
* NET  2234 = abc_7357_new_n1160
* NET  2235 = abc_7357_new_n1159
* NET  2236 = abc_7357_new_n1158
* NET  2237 = abc_7357_new_n1157
* NET  2238 = abc_7357_new_n1156
* NET  2239 = abc_7357_new_n1155
* NET  2240 = abc_7357_new_n1154
* NET  2241 = abc_7357_new_n1153
* NET  2242 = abc_7357_new_n1152
* NET  2243 = abc_7357_new_n1151
* NET  2244 = abc_7357_new_n1150
* NET  2245 = abc_7357_new_n1149
* NET  2246 = abc_7357_new_n1148
* NET  2247 = abc_7357_new_n1147
* NET  2248 = abc_7357_new_n1146
* NET  2249 = abc_7357_new_n1145
* NET  2250 = abc_7357_new_n1144
* NET  2251 = abc_7357_new_n1143
* NET  2252 = abc_7357_new_n1142
* NET  2253 = abc_7357_new_n1141
* NET  2254 = abc_7357_new_n1140
* NET  2255 = abc_7357_new_n1139
* NET  2256 = abc_7357_new_n1138
* NET  2257 = abc_7357_new_n1137
* NET  2258 = abc_7357_new_n1136
* NET  2259 = abc_7357_new_n1135
* NET  2260 = abc_7357_new_n1134
* NET  2261 = abc_7357_new_n1133
* NET  2262 = abc_7357_new_n1132
* NET  2263 = abc_7357_new_n1131
* NET  2264 = abc_7357_new_n1130
* NET  2265 = abc_7357_new_n1128
* NET  2266 = abc_7357_new_n1127
* NET  2267 = abc_7357_new_n1126
* NET  2268 = abc_7357_new_n1125
* NET  2269 = abc_7357_new_n1124
* NET  2270 = abc_7357_new_n1123
* NET  2271 = abc_7357_new_n1122
* NET  2272 = abc_7357_new_n1121
* NET  2273 = abc_7357_new_n1120
* NET  2274 = abc_7357_new_n1119
* NET  2275 = abc_7357_new_n1118
* NET  2276 = abc_7357_new_n1117
* NET  2277 = abc_7357_new_n1116
* NET  2278 = abc_7357_new_n1115
* NET  2279 = abc_7357_new_n1114
* NET  2280 = abc_7357_new_n1113
* NET  2281 = abc_7357_new_n1112
* NET  2282 = abc_7357_new_n1111
* NET  2283 = abc_7357_new_n1110
* NET  2284 = abc_7357_new_n1109
* NET  2285 = abc_7357_new_n1108
* NET  2286 = abc_7357_new_n1107
* NET  2287 = abc_7357_new_n1106
* NET  2288 = abc_7357_new_n1105
* NET  2289 = abc_7357_new_n1104
* NET  2290 = abc_7357_new_n1103
* NET  2291 = abc_7357_new_n1102
* NET  2292 = abc_7357_new_n1101
* NET  2293 = abc_7357_new_n1100
* NET  2294 = abc_7357_new_n1099
* NET  2295 = abc_7357_new_n1098
* NET  2296 = abc_7357_new_n1097
* NET  2297 = abc_7357_new_n1096
* NET  2298 = abc_7357_new_n1095
* NET  2299 = abc_7357_new_n1094
* NET  2300 = abc_7357_new_n1093
* NET  2301 = abc_7357_new_n1092
* NET  2302 = abc_7357_new_n1090
* NET  2303 = abc_7357_new_n1089
* NET  2304 = abc_7357_new_n1088
* NET  2305 = abc_7357_new_n1087
* NET  2306 = abc_7357_new_n1086
* NET  2307 = abc_7357_new_n1085
* NET  2308 = abc_7357_new_n1084
* NET  2309 = abc_7357_new_n1083
* NET  2310 = abc_7357_new_n1082
* NET  2311 = abc_7357_new_n1081
* NET  2312 = abc_7357_new_n1080
* NET  2313 = abc_7357_new_n1079
* NET  2314 = abc_7357_new_n1078
* NET  2315 = abc_7357_new_n1077
* NET  2316 = abc_7357_new_n1076
* NET  2317 = abc_7357_new_n1075
* NET  2318 = abc_7357_new_n1074
* NET  2319 = abc_7357_new_n1073
* NET  2320 = abc_7357_new_n1072
* NET  2321 = abc_7357_new_n1071
* NET  2322 = abc_7357_new_n1070
* NET  2323 = abc_7357_new_n1069
* NET  2324 = abc_7357_new_n1068
* NET  2325 = abc_7357_new_n1067
* NET  2326 = abc_7357_new_n1066
* NET  2327 = abc_7357_new_n1065
* NET  2328 = abc_7357_new_n1064
* NET  2329 = abc_7357_new_n1063
* NET  2330 = abc_7357_new_n1062
* NET  2331 = abc_7357_new_n1061
* NET  2332 = abc_7357_new_n1060
* NET  2333 = abc_7357_new_n1059
* NET  2334 = abc_7357_new_n1058
* NET  2335 = abc_7357_new_n1057
* NET  2336 = abc_7357_new_n1056
* NET  2337 = abc_7357_new_n1055
* NET  2338 = abc_7357_new_n1054
* NET  2339 = abc_7357_new_n1053
* NET  2340 = abc_7357_new_n1052
* NET  2341 = abc_7357_new_n1051
* NET  2342 = abc_7357_new_n1050
* NET  2343 = abc_7357_new_n1049
* NET  2344 = abc_7357_new_n1048
* NET  2345 = abc_7357_new_n1046
* NET  2346 = abc_7357_new_n1045
* NET  2347 = abc_7357_new_n1044
* NET  2348 = abc_7357_new_n1043
* NET  2349 = abc_7357_new_n1042
* NET  2350 = abc_7357_new_n1041
* NET  2351 = abc_7357_new_n1040
* NET  2352 = abc_7357_new_n1039
* NET  2353 = abc_7357_new_n1038
* NET  2354 = abc_7357_new_n1037
* NET  2355 = abc_7357_new_n1036
* NET  2356 = abc_7357_new_n1035
* NET  2357 = abc_7357_new_n1034
* NET  2358 = abc_7357_new_n1033
* NET  2359 = abc_7357_new_n1032
* NET  2360 = abc_7357_new_n1031
* NET  2361 = abc_7357_new_n1030
* NET  2362 = abc_7357_new_n1029
* NET  2363 = abc_7357_new_n1028
* NET  2364 = abc_7357_new_n1027
* NET  2365 = abc_7357_new_n1026
* NET  2366 = abc_7357_new_n1025
* NET  2367 = abc_7357_new_n1024
* NET  2368 = abc_7357_new_n1023
* NET  2369 = abc_7357_new_n1022
* NET  2370 = abc_7357_new_n1021
* NET  2371 = abc_7357_new_n1020
* NET  2372 = abc_7357_new_n1019
* NET  2373 = abc_7357_new_n1018
* NET  2374 = abc_7357_new_n1017
* NET  2375 = abc_7357_new_n1016
* NET  2376 = abc_7357_new_n1015
* NET  2377 = abc_7357_new_n1014
* NET  2378 = abc_7357_new_n1013
* NET  2379 = abc_7357_new_n1012
* NET  2380 = abc_7357_new_n1011
* NET  2381 = abc_7357_new_n1010
* NET  2382 = abc_7357_new_n1009
* NET  2383 = abc_7357_new_n1008
* NET  2384 = abc_7357_new_n1007
* NET  2385 = abc_7357_new_n1006
* NET  2386 = abc_7357_new_n1005
* NET  2387 = abc_7357_new_n1004
* NET  2388 = abc_7357_new_n1003
* NET  2389 = abc_7357_new_n1002
* NET  2390 = abc_7357_new_n1001
* NET  2391 = abc_7357_new_n1000
* NET  2392 = abc_7357_auto_rtlil_cc_3381_MuxGate_7356
* NET  2393 = abc_7357_auto_rtlil_cc_3381_MuxGate_7354
* NET  2394 = abc_7357_auto_rtlil_cc_3381_MuxGate_7352
* NET  2395 = abc_7357_auto_rtlil_cc_3381_MuxGate_7350
* NET  2396 = abc_7357_auto_rtlil_cc_3381_MuxGate_7348
* NET  2397 = abc_7357_auto_rtlil_cc_3381_MuxGate_7346
* NET  2398 = abc_7357_auto_rtlil_cc_3381_MuxGate_7344
* NET  2399 = abc_7357_auto_rtlil_cc_3381_MuxGate_7342
* NET  2400 = abc_7357_auto_rtlil_cc_3381_MuxGate_7340
* NET  2401 = abc_7357_auto_rtlil_cc_3381_MuxGate_7338
* NET  2402 = abc_7357_auto_rtlil_cc_3381_MuxGate_7336
* NET  2403 = abc_7357_auto_rtlil_cc_3381_MuxGate_7334
* NET  2404 = abc_7357_auto_rtlil_cc_3381_MuxGate_7332
* NET  2405 = abc_7357_auto_rtlil_cc_3381_MuxGate_7330
* NET  2406 = abc_7357_auto_rtlil_cc_3381_MuxGate_7328
* NET  2407 = abc_7357_auto_rtlil_cc_3381_MuxGate_7326
* NET  2408 = abc_7357_auto_rtlil_cc_3381_MuxGate_7324
* NET  2409 = abc_7357_auto_rtlil_cc_3381_MuxGate_7320
* NET  2410 = abc_7357_auto_rtlil_cc_3381_MuxGate_7316
* NET  2411 = abc_7357_auto_rtlil_cc_3381_MuxGate_7312
* NET  2412 = abc_7357_auto_rtlil_cc_3381_MuxGate_7308
* NET  2413 = abc_7357_auto_rtlil_cc_3381_MuxGate_7304
* NET  2414 = abc_7357_auto_rtlil_cc_3381_MuxGate_7300
* NET  2415 = abc_7357_auto_rtlil_cc_3381_MuxGate_7296
* NET  2416 = abc_7357_auto_rtlil_cc_3381_MuxGate_7292
* NET  2417 = abc_7357_auto_rtlil_cc_3381_MuxGate_7288
* NET  2418 = abc_7357_auto_rtlil_cc_3381_MuxGate_7284
* NET  2419 = abc_7357_auto_rtlil_cc_3381_MuxGate_7280
* NET  2420 = abc_7357_auto_rtlil_cc_3381_MuxGate_7276
* NET  2421 = abc_7357_auto_rtlil_cc_3381_MuxGate_7272
* NET  2422 = abc_7357_auto_rtlil_cc_3381_MuxGate_7268
* NET  2423 = abc_7357_auto_rtlil_cc_3381_MuxGate_7264
* NET  2424 = abc_7357_auto_rtlil_cc_3381_MuxGate_7260
* NET  2425 = abc_7357_auto_rtlil_cc_3381_MuxGate_7256
* NET  2426 = abc_7357_auto_rtlil_cc_3381_MuxGate_7252
* NET  2427 = abc_7357_auto_rtlil_cc_3381_MuxGate_7248
* NET  2428 = abc_7357_auto_rtlil_cc_3381_MuxGate_7244
* NET  2429 = abc_7357_auto_rtlil_cc_3381_MuxGate_7240
* NET  2430 = abc_7357_auto_rtlil_cc_3381_MuxGate_7236
* NET  2431 = abc_7357_auto_rtlil_cc_3381_MuxGate_7232
* NET  2432 = abc_7357_auto_rtlil_cc_3381_MuxGate_7228
* NET  2433 = abc_7357_auto_rtlil_cc_3381_MuxGate_7224
* NET  2434 = abc_7357_auto_rtlil_cc_3381_MuxGate_7220
* NET  2435 = abc_7357_auto_rtlil_cc_3381_MuxGate_7216
* NET  2436 = abc_7357_auto_rtlil_cc_3381_MuxGate_7212
* NET  2437 = abc_7357_auto_rtlil_cc_3381_MuxGate_7208
* NET  2438 = abc_7357_auto_rtlil_cc_3381_MuxGate_7206
* NET  2439 = abc_7357_auto_rtlil_cc_3381_MuxGate_7204
* NET  2440 = abc_7357_auto_rtlil_cc_3381_MuxGate_7202
* NET  2441 = abc_7357_auto_rtlil_cc_3381_MuxGate_7200
* NET  2442 = abc_7357_auto_rtlil_cc_3381_MuxGate_7198
* NET  2443 = abc_7357_auto_rtlil_cc_3381_MuxGate_7196
* NET  2444 = abc_7357_auto_rtlil_cc_3381_MuxGate_7194
* NET  2445 = abc_7357_auto_rtlil_cc_3381_MuxGate_7192
* NET  2446 = abc_7357_auto_rtlil_cc_3381_MuxGate_7188
* NET  2447 = abc_7357_auto_rtlil_cc_3381_MuxGate_7184
* NET  2448 = abc_7357_auto_rtlil_cc_3381_MuxGate_7180
* NET  2449 = abc_7357_auto_rtlil_cc_3381_MuxGate_7176
* NET  2450 = abc_7357_auto_rtlil_cc_3381_MuxGate_7172
* NET  2451 = abc_7357_auto_rtlil_cc_3381_MuxGate_7168
* NET  2452 = abc_7357_auto_rtlil_cc_3381_MuxGate_7164
* NET  2453 = abc_7357_auto_rtlil_cc_3381_MuxGate_7160
* NET  2454 = abc_7357_auto_rtlil_cc_3381_MuxGate_7158
* NET  2455 = abc_7357_auto_rtlil_cc_3381_MuxGate_7156
* NET  2456 = abc_7357_auto_rtlil_cc_3381_MuxGate_7154
* NET  2457 = abc_7357_auto_rtlil_cc_3381_MuxGate_7152
* NET  2458 = abc_7357_auto_rtlil_cc_3381_MuxGate_7150
* NET  2459 = abc_7357_auto_rtlil_cc_3381_MuxGate_7148
* NET  2460 = abc_7357_auto_rtlil_cc_3381_MuxGate_7146
* NET  2461 = abc_7357_auto_rtlil_cc_3381_MuxGate_7144
* NET  2462 = abc_7357_auto_rtlil_cc_3381_MuxGate_7142
* NET  2463 = abc_7357_auto_rtlil_cc_3381_MuxGate_7138
* NET  2464 = abc_7357_auto_rtlil_cc_3381_MuxGate_7134
* NET  2465 = abc_7357_auto_rtlil_cc_3381_MuxGate_7130
* NET  2466 = abc_7357_auto_rtlil_cc_3381_MuxGate_7126
* NET  2467 = abc_7357_auto_rtlil_cc_3381_MuxGate_7122
* NET  2468 = abc_7357_auto_rtlil_cc_3381_MuxGate_7118
* NET  2469 = abc_7357_auto_rtlil_cc_3381_MuxGate_7114
* NET  2470 = abc_7357_auto_rtlil_cc_3381_MuxGate_7112
* NET  2471 = abc_7357_auto_rtlil_cc_3381_MuxGate_7110
* NET  2472 = abc_7357_auto_rtlil_cc_3381_MuxGate_7108
* NET  2473 = abc_7357_auto_rtlil_cc_3381_MuxGate_7106
* NET  2474 = abc_7357_auto_rtlil_cc_3381_MuxGate_7104
* NET  2475 = abc_7357_auto_rtlil_cc_3381_MuxGate_7102
* NET  2476 = abc_7357_auto_rtlil_cc_3381_MuxGate_7100
* NET  2477 = abc_7357_auto_rtlil_cc_3381_MuxGate_7098
* NET  2478 = abc_7357_auto_rtlil_cc_3381_MuxGate_7096
* NET  2479 = abc_7357_auto_rtlil_cc_3381_MuxGate_7092
* NET  2480 = abc_7357_auto_rtlil_cc_3381_MuxGate_7088
* NET  2481 = abc_7357_auto_rtlil_cc_3381_MuxGate_7084
* NET  2482 = abc_7357_auto_rtlil_cc_3381_MuxGate_7080
* NET  2483 = abc_7357_auto_rtlil_cc_3381_MuxGate_7076
* NET  2484 = abc_7357_auto_rtlil_cc_3381_MuxGate_7072
* NET  2485 = abc_7357_auto_rtlil_cc_3381_MuxGate_7068
* NET  2486 = abc_7357_auto_rtlil_cc_3381_MuxGate_7066
* NET  2487 = abc_7357_auto_rtlil_cc_3381_MuxGate_7064
* NET  2488 = abc_7357_auto_rtlil_cc_3381_MuxGate_7062
* NET  2489 = abc_7357_auto_rtlil_cc_3381_MuxGate_7060
* NET  2490 = abc_7357_auto_rtlil_cc_3381_MuxGate_7058
* NET  2491 = abc_7357_auto_rtlil_cc_3381_MuxGate_7056
* NET  2492 = abc_7357_auto_rtlil_cc_3381_MuxGate_7054
* NET  2493 = abc_7357_auto_rtlil_cc_3381_MuxGate_7052
* NET  2494 = abc_7357_auto_rtlil_cc_3381_MuxGate_7050
* NET  2495 = abc_7357_auto_rtlil_cc_3381_MuxGate_7048
* NET  2496 = abc_7357_auto_rtlil_cc_3381_MuxGate_7046
* NET  2497 = abc_7357_auto_rtlil_cc_3381_MuxGate_7044
* NET  2498 = abc_7357_auto_rtlil_cc_3381_MuxGate_7042
* NET  2499 = abc_7357_auto_rtlil_cc_3381_MuxGate_7040
* NET  2500 = abc_7357_auto_rtlil_cc_3381_MuxGate_7038
* NET  2501 = a_reg[7]
* NET  2502 = a_reg[6]
* NET  2503 = a_reg[5]
* NET  2504 = a_reg[4]
* NET  2505 = a_reg[3]
* NET  2506 = a_reg[2]
* NET  2507 = a_reg[1]
* NET  2508 = a_reg[0]
* NET  2509 = a[9]
* NET  2510 = a[8]
* NET  2511 = a[7]
* NET  2512 = a[6]
* NET  2513 = a[5]
* NET  2514 = a[4]
* NET  2515 = a[3]
* NET  2516 = a[2]
* NET  2517 = a[15]
* NET  2518 = a[14]
* NET  2519 = a[13]
* NET  2520 = a[12]
* NET  2521 = a[11]
* NET  2522 = a[10]
* NET  2523 = a[1]
* NET  2524 = a[0]
* NET  2525 = reset_root_tr_tr_0
* NET  2526 = reset_root_tr_tl_0
* NET  2527 = reset_root_tr_br_0
* NET  2528 = reset_root_tr_bl_0
* NET  2529 = reset_root_tr_0
* NET  2530 = reset_root_tl_tr_0
* NET  2531 = reset_root_tl_tl_0
* NET  2532 = reset_root_tl_br_0
* NET  2533 = reset_root_tl_bl_0
* NET  2534 = reset_root_tl_0
* NET  2535 = reset_root_br_tr_0
* NET  2536 = reset_root_br_tl_0
* NET  2537 = reset_root_br_br_0
* NET  2538 = reset_root_br_bl_0
* NET  2539 = reset_root_br_0
* NET  2540 = reset_root_bl_tr_0
* NET  2541 = reset_root_bl_tl_0
* NET  2542 = reset_root_bl_br_0
* NET  2543 = reset_root_bl_bl_0
* NET  2544 = reset_root_bl_0
* NET  2545 = reset_root_0
* NET  2546 = clk_root_tr_tr_2
* NET  2547 = clk_root_tr_tr_1
* NET  2548 = clk_root_tr_tr_0
* NET  2549 = clk_root_tr_tl_2
* NET  2550 = clk_root_tr_tl_1
* NET  2551 = clk_root_tr_tl_0
* NET  2552 = clk_root_tr_br_2
* NET  2553 = clk_root_tr_br_1
* NET  2554 = clk_root_tr_br_0
* NET  2555 = clk_root_tr_bl_2
* NET  2556 = clk_root_tr_bl_1
* NET  2557 = clk_root_tr_bl_0
* NET  2558 = clk_root_tr_0
* NET  2559 = clk_root_tl_tr_2
* NET  2560 = clk_root_tl_tr_1
* NET  2561 = clk_root_tl_tr_0
* NET  2562 = clk_root_tl_tl_2
* NET  2563 = clk_root_tl_tl_1
* NET  2564 = clk_root_tl_tl_0
* NET  2565 = clk_root_tl_br_2
* NET  2566 = clk_root_tl_br_1
* NET  2567 = clk_root_tl_br_0
* NET  2568 = clk_root_tl_bl_2
* NET  2569 = clk_root_tl_bl_1
* NET  2570 = clk_root_tl_bl_0
* NET  2571 = clk_root_tl_0
* NET  2572 = clk_root_br_tr_2
* NET  2573 = clk_root_br_tr_1
* NET  2574 = clk_root_br_tr_0
* NET  2575 = clk_root_br_tl_2
* NET  2576 = clk_root_br_tl_1
* NET  2577 = clk_root_br_tl_0
* NET  2578 = clk_root_br_br_2
* NET  2579 = clk_root_br_br_1
* NET  2580 = clk_root_br_br_0
* NET  2581 = clk_root_br_bl_2
* NET  2582 = clk_root_br_bl_1
* NET  2583 = clk_root_br_bl_0
* NET  2584 = clk_root_br_0
* NET  2585 = clk_root_bl_tr_2
* NET  2586 = clk_root_bl_tr_1
* NET  2587 = clk_root_bl_tr_0
* NET  2588 = clk_root_bl_tl_2
* NET  2589 = clk_root_bl_tl_1
* NET  2590 = clk_root_bl_tl_0
* NET  2591 = clk_root_bl_br_2
* NET  2592 = clk_root_bl_br_1
* NET  2593 = clk_root_bl_br_0
* NET  2594 = clk_root_bl_bl_2
* NET  2595 = clk_root_bl_bl_1
* NET  2596 = clk_root_bl_bl_0
* NET  2597 = clk_root_bl_0
* NET  2598 = clk_root_0
* NET  2599 = blockagenet

xfeed_264 83 82 tie
xsubckt_712_and2_x1 83 82 2385 77 808 and2_x1
xsubckt_706_nand2_x0 83 82 2391 327 29 nand2_x0
xsubckt_255_nand3_x0 83 82 593 594 612 138 nand3_x0
xfeed_409 83 82 tie
xfeed_265 83 82 tie
xsubckt_1048_and2_x1 83 82 2056 2061 2063 and2_x1
xsubckt_1589_nand3_x0 83 82 1528 1612 140 810 nand3_x0
xsubckt_1591_or21nand_x0 83 82 1526 1532 1530 1527 or21nand_x0
xsubckt_1952_or2_x1 83 82 1178 1186 1189 or2_x1
xsubckt_2121_and21nor_x0 83 82 2414 1043 1044 763 and21nor_x0
xsubckt_2334_or21nand_x0 83 82 847 610 848 855 or21nand_x0
xfeed_859 83 82 decap_w0
xfeed_266 83 82 tie
xsubckt_1199_nexor2_x0 83 82 1932 708 1909 nexor2_x0
xsubckt_1177_nexor2_x0 83 82 1963 709 1930 nexor2_x0
xsubckt_963_nexor2_x0 83 82 2188 0 2139 nexor2_x0
xsubckt_115_nand2_x0 83 82 700 141 140 nand2_x0
xsubckt_1686_and21nor_x0 83 82 1433 335 2095 333 and21nor_x0
xsubckt_2101_nand3_x0 83 82 1056 644 159 158 nand3_x0
xfeed_858 83 82 tie
xfeed_267 83 82 decap_w0
xsubckt_1256_nand2_x0 83 82 2468 1854 1888 nand2_x0
xsubckt_774_and21nor_x0 83 82 2324 2366 2369 2373 and21nor_x0
xsubckt_763_nand4_x0 83 82 2335 753 808 140 810 nand4_x0
xsubckt_312_and3_x1 83 82 540 614 760 141 and3_x1
xsubckt_180_and2_x1 83 82 126 653 2537 and2_x1
xsubckt_579_and2_x1 83 82 286 162 799 and2_x1
xfeed_329 83 82 tie
xfeed_260 83 82 tie
xspare_buffer_68 83 82 2558 2557 buf_x4
xsubckt_812_and21nor_x0 83 82 2287 2323 2326 2330 and21nor_x0
xsubckt_665_and21nor_x0 83 82 202 207 205 203 and21nor_x0
xsubckt_34_inv_x0 83 82 39 778 inv_x0
xsubckt_1478_nexor2_x0 83 82 1641 68 1636 nexor2_x0
xsubckt_1613_and21nor_x0 83 82 1504 335 2189 1505 and21nor_x0
xfeed_328 83 82 tie
xfeed_261 83 82 tie
xspare_buffer_69 83 82 2558 2556 buf_x4
xsubckt_952_and21nor_x0 83 82 2150 2158 2161 24 and21nor_x0
xsubckt_24_inv_x0 83 82 70 788 inv_x0
xsubckt_336_and21nor_x0 83 82 517 536 533 535 and21nor_x0
xsubckt_1414_and21nor_x0 83 82 1699 1706 1704 1700 and21nor_x0
xsubckt_1814_or21nand_x0 83 82 1309 90 764 9 or21nand_x0
xsubckt_1821_and21nor_x0 83 82 1302 1303 1315 142 and21nor_x0
xsubckt_2323_or21nand_x0 83 82 2397 858 862 870 or21nand_x0
xsubckt_2378_dff_x1 83 82 2497 2548 6 dff_x1
xsubckt_2460_dff_x1 83 82 2418 2594 21 dff_x1
xfeed_262 83 82 tie
xsubckt_318_nexor2_x0 83 82 538 720 534 nexor2_x0
xsubckt_1659_or21nand_x0 83 82 1459 285 1460 265 or21nand_x0
xsubckt_1708_and2_x1 83 82 1412 1419 749 and2_x1
xsubckt_1803_nexor2_x0 83 82 1323 73 1320 nexor2_x0
xfeed_263 83 82 tie
xsubckt_1143_and2_x1 83 82 1963 1999 710 and2_x1
xsubckt_886_and21nor_x0 83 82 2215 139 140 65 and21nor_x0
xsubckt_320_nexor2_x0 83 82 533 534 532 nexor2_x0
xsubckt_44_inv_x0 83 82 2516 768 inv_x0
xsubckt_1290_and3_x1 83 82 1820 1863 1886 79 and3_x1
xsubckt_1298_nand4_x0 83 82 1812 54 93 811 812 nand4_x0
xsubckt_1702_nor2_x0 83 82 1418 1419 76 nor2_x0
xsubckt_2234_nor3_x0 83 82 941 942 943 609 nor3_x0
xsubckt_2413_dff_x1 83 82 2462 2557 67 dff_x1
xfeed_853 83 82 decap_w0
xfeed_400 83 82 decap_w0
xfeed_325 83 82 decap_w0
xspare_buffer_64 83 82 2571 2561 buf_x4
xsubckt_148_and21nor_x0 83 82 132 670 672 763 and21nor_x0
xsubckt_600_and2_x1 83 82 265 338 762 and2_x1
xsubckt_1350_nand4_x0 83 82 1761 47 93 811 812 nand4_x0
xfeed_852 83 82 tie
xfeed_401 83 82 decap_w0
xfeed_324 83 82 decap_w0
xspare_buffer_65 83 82 2571 2560 buf_x4
xsubckt_196_or21nand_x0 83 82 641 84 743 642 or21nand_x0
xsubckt_1360_mux2_x1 83 82 759 1756 373 1752 mux2_x1
xfeed_851 83 82 decap_w0
xfeed_402 83 82 decap_w0
xfeed_327 83 82 tie
xspare_buffer_66 83 82 2571 2559 buf_x4
xsubckt_1000_and21nor_x0 83 82 2103 2107 2111 758 and21nor_x0
xsubckt_748_or21nand_x0 83 82 2349 169 175 176 or21nand_x0
xsubckt_307_nexor2_x0 83 82 545 547 544 nexor2_x0
xsubckt_490_and3_x1 83 82 374 808 140 139 and3_x1
xsubckt_2204_and2_x1 83 82 970 972 737 and2_x1
xsubckt_2436_dff_x1 83 82 2439 2568 2511 dff_x1
xfeed_850 83 82 decap_w0
xfeed_403 83 82 tie
xfeed_326 83 82 tie
xspare_buffer_67 83 82 2534 2530 buf_x4
xsubckt_1674_nand2_x0 83 82 1445 1449 77 nand2_x0
xsubckt_1961_and2_x1 83 82 1169 1170 762 and2_x1
xsubckt_2240_mux2_x1 83 82 66 77 606 936 mux2_x1
xfeed_857 83 82 tie
xfeed_321 83 82 decap_w0
xspare_buffer_60 83 82 2571 2564 buf_x4
xsubckt_881_or21nand_x0 83 82 2219 2237 2238 265 or21nand_x0
xsubckt_761_nand3_x0 83 82 2337 616 64 139 nand3_x0
xsubckt_690_and21nor_x0 83 82 177 183 198 781 and21nor_x0
xsubckt_176_and2_x1 83 82 128 655 2537 and2_x1
xsubckt_1491_nand2_x0 83 82 1623 1624 777 nand2_x0
xsubckt_1987_nand2_x0 83 82 1146 1147 1277 nand2_x0
xsubckt_2504_dff_x1 83 82 2398 2574 40 dff_x1
xfeed_856 83 82 decap_w0
xfeed_405 83 82 tie
xfeed_320 83 82 decap_w0
xspare_buffer_61 83 82 2571 2563 buf_x4
xsubckt_780_nexor2_x0 83 82 2364 719 2318 nexor2_x0
xsubckt_506_and2_x1 83 82 358 359 360 and2_x1
xsubckt_513_and4_x1 83 82 351 352 353 356 607 and4_x1
xsubckt_1682_nexor2_x0 83 82 1439 1443 1437 nexor2_x0
xsubckt_1746_nand2_x0 83 82 1375 1377 1378 nand2_x0
xsubckt_1822_and2_x1 83 82 1301 142 56 and2_x1
xsubckt_1911_and3_x1 83 82 1216 687 162 799 and3_x1
xfeed_855 83 82 tie
xfeed_406 83 82 decap_w0
xfeed_323 83 82 decap_w0
xspare_buffer_62 83 82 2571 2562 buf_x4
xsubckt_1203_nand3_x0 83 82 1905 48 93 812 nand3_x0
xsubckt_845_nand4_x0 83 82 2255 751 808 140 810 nand4_x0
xsubckt_69_inv_x0 83 82 159 744 inv_x0
xsubckt_528_nand2_x0 83 82 336 337 777 nand2_x0
xsubckt_1769_or3_x1 83 82 1353 1356 1357 608 or3_x1
xsubckt_2506_dff_x1 83 82 2396 2574 52 dff_x1
xfeed_854 83 82 decap_w0
xfeed_407 83 82 decap_w0
xfeed_322 83 82 decap_w0
xspare_buffer_63 83 82 2534 2531 buf_x4
xsubckt_1200_nexor2_x0 83 82 1932 8 1908 nexor2_x0
xsubckt_1153_or21nand_x0 83 82 1953 1954 1956 285 or21nand_x0
xsubckt_1011_nexor2_x0 83 82 2140 713 2092 nexor2_x0
xsubckt_152_nand2_x0 83 82 134 667 668 nand2_x0
xsubckt_614_and2_x1 83 82 252 253 705 and2_x1
xsubckt_1378_nand3_x0 83 82 1734 1736 603 788 nand3_x0
xsubckt_1731_mux2_x1 83 82 35 32 699 1390 mux2_x1
xdiode_70 83 82 811 diode_w1
xsubckt_1193_and2_x1 83 82 1914 1915 326 and2_x1
xsubckt_603_or21nand_x0 83 82 2483 263 266 325 or21nand_x0
xsubckt_1644_and21nor_x0 83 82 1474 1478 1489 751 and21nor_x0
xsubckt_1843_nand3_x0 83 82 1282 2212 314 162 nand3_x0
xdiode_71 83 82 811 diode_w1
xsubckt_256_and2_x1 83 82 592 593 618 and2_x1
xdiode_98 83 82 24 diode_w1
xdiode_72 83 82 811 diode_w1
xsubckt_928_and21nor_x0 83 82 2173 286 2174 264 and21nor_x0
xsubckt_263_nand2_x0 83 82 586 589 14 nand2_x0
xsubckt_343_nexor2_x0 83 82 511 517 510 nexor2_x0
xsubckt_372_and2_x1 83 82 2494 483 499 and2_x1
xsubckt_1376_or21nand_x0 83 82 1736 1746 1741 1739 or21nand_x0
xsubckt_1919_nexor2_x0 83 82 1210 1214 1208 nexor2_x0
xsubckt_2099_and2_x1 83 82 1057 2543 56 and2_x1
xdiode_99 83 82 24 diode_w1
xdiode_73 83 82 811 diode_w1
xsubckt_276_nexor2_x0 83 82 25 26 574 nexor2_x0
xsubckt_1507_nand3_x0 83 82 1608 616 758 139 nand3_x0
xsubckt_1832_nand2_x0 83 82 1292 1293 289 nand2_x0
xdiode_74 83 82 811 diode_w1
xfeed_758 83 82 decap_w0
xsubckt_1519_nand3_x0 83 82 1596 1599 554 67 nand3_x0
xsubckt_1664_mux2_x1 83 82 754 714 615 1455 mux2_x1
xdiode_75 83 82 811 diode_w1
xfeed_759 83 82 decap_w0
xsubckt_385_xor2_x0 83 82 34 35 470 xor2_x0
xsubckt_2008_mux2_x1 83 82 1129 1130 670 1128 mux2_x1
xsubckt_2147_or21nand_x0 83 82 1023 741 1029 609 or21nand_x0
xdiode_76 83 82 811 diode_w1
xspare_feed_59 83 82 tie
xsubckt_1191_and2_x1 83 82 1916 142 16 and2_x1
xsubckt_744_nand2_x0 83 82 2353 2354 777 nand2_x0
xsubckt_652_or21nand_x0 83 82 2482 215 216 262 or21nand_x0
xsubckt_147_nand3_x0 83 82 670 676 677 110 nand3_x0
xsubckt_436_and3_x1 83 82 422 423 612 138 and3_x1
xsubckt_1669_or2_x1 83 82 1450 1451 1452 or2_x1
xsubckt_2397_dff_x1 83 82 2478 2557 27 dff_x1
xdiode_77 83 82 811 diode_w1
xspare_feed_58 83 82 tie
xsubckt_792_and21nor_x0 83 82 2306 2349 2368 2371 and21nor_x0
xsubckt_236_nor3_x0 83 82 612 141 140 139 nor3_x0
xsubckt_470_nexor2_x0 83 82 395 710 391 nexor2_x0
xdiode_92 83 82 65 diode_w1
xdiode_78 83 82 811 diode_w1
xfeed_754 83 82 decap_w0
xspare_feed_57 83 82 tie
xsubckt_1423_and2_x1 83 82 1690 1694 69 and2_x1
xsubckt_1971_nexor2_x0 83 82 1162 1165 1160 nexor2_x0
xsubckt_2205_nand2_x0 83 82 969 971 45 nand2_x0
xdiode_93 83 82 65 diode_w1
xdiode_79 83 82 812 diode_w1
xfeed_755 83 82 tie
xspare_feed_56 83 82 tie
xsubckt_95_inv_x0 83 82 3 718 inv_x0
xsubckt_1884_nand3_x0 83 82 1243 2122 285 700 nand3_x0
xdiode_90 83 82 808 diode_w1
xfeed_756 83 82 tie
xspare_feed_55 83 82 tie
xsubckt_779_and3_x1 83 82 2319 214 719 720 and3_x1
xsubckt_274_nor2_x0 83 82 576 25 26 nor2_x0
xsubckt_335_nand2_x0 83 82 518 617 719 nand2_x0
xsubckt_1417_nand2_x0 83 82 1696 1697 1698 nand2_x0
xsubckt_1574_or21nand_x0 83 82 1542 1591 1593 1594 or21nand_x0
xdiode_91 83 82 65 diode_w1
xfeed_757 83 82 decap_w0
xspare_feed_54 83 82 tie
xsubckt_17_inv_x0 83 82 2521 795 inv_x0
xsubckt_1377_and3_x1 83 82 1735 1736 603 788 and3_x1
xsubckt_1796_and2_x1 83 82 1326 142 57 and2_x1
xdiode_96 83 82 162 diode_w1
xfeed_750 83 82 decap_w0
xspare_feed_53 83 82 tie
xsubckt_67_inv_x0 83 82 73 746 inv_x0
xsubckt_334_and2_x1 83 82 2496 519 541 and2_x1
xsubckt_1554_and21nor_x0 83 82 1562 1563 539 66 and21nor_x0
xsubckt_1931_nexor2_x0 83 82 684 2521 1197 nexor2_x0
xsubckt_2036_nand2_x0 83 82 1103 1104 1277 nand2_x0
xdiode_97 83 82 162 diode_w1
xfeed_751 83 82 decap_w0
xspare_feed_52 83 82 tie
xsubckt_483_or2_x1 83 82 380 381 708 or2_x1
xsubckt_1951_and21nor_x0 83 82 2448 1183 1181 1179 and21nor_x0
xdiode_94 83 82 76 diode_w1
xfeed_752 83 82 tie
xspare_feed_51 83 82 tie
xsubckt_1156_or21nand_x0 83 82 1950 2012 2014 2015 or21nand_x0
xsubckt_935_mux2_x1 83 82 64 72 371 2167 mux2_x1
xsubckt_692_and3_x1 83 82 175 183 198 781 and3_x1
xsubckt_418_or21nand_x0 83 82 439 456 454 455 or21nand_x0
xsubckt_1400_or21nand_x0 83 82 1712 1772 1774 1775 or21nand_x0
xsubckt_1672_or2_x1 83 82 1447 1449 750 or2_x1
xsubckt_2375_dff_x1 83 82 2500 2551 15 dff_x1
xsubckt_2487_dff_x1 83 82 133 2589 138 dff_x1
xdiode_95 83 82 76 diode_w1
xfeed_753 83 82 tie
xspare_feed_50 83 82 tie
xsubckt_1077_nand3_x0 83 82 2028 614 74 141 nand3_x0
xsubckt_273_nand2_x0 83 82 577 25 26 nand2_x0
xsubckt_1385_and2_x1 83 82 1727 1732 1734 and2_x1
xsubckt_1614_nand4_x0 83 82 1503 41 93 811 812 nand4_x0
xsubckt_2233_and21nor_x0 83 82 942 961 958 944 and21nor_x0
xsubckt_2256_nand3_x0 83 82 920 923 928 929 nand3_x0
xfeed_1050 83 82 tie
xfeed_596 83 82 decap_w0
xfeed_457 83 82 tie
xfeed_163 83 82 tie
xsubckt_885_and21nor_x0 83 82 2216 746 374 367 and21nor_x0
xsubckt_1349_or21nand_x0 83 82 1762 811 233 341 or21nand_x0
xsubckt_2110_nand3_x0 83 82 1050 644 159 155 nand3_x0
xfeed_1051 83 82 tie
xfeed_597 83 82 decap_w0
xfeed_456 83 82 decap_w0
xfeed_162 83 82 tie
xsubckt_1094_and21nor_x0 83 82 2011 2059 2055 2058 and21nor_x0
xsubckt_1047_or21nand_x0 83 82 2057 2065 2070 757 or21nand_x0
xsubckt_836_nand3_x0 83 82 2264 614 65 141 nand3_x0
xsubckt_285_and2_x1 83 82 565 566 722 and2_x1
xsubckt_212_nand3_x0 83 82 630 99 85 86 nand3_x0
xsubckt_380_or2_x1 83 82 475 476 481 or2_x1
xsubckt_1366_and21nor_x0 83 82 1746 1755 1753 1747 and21nor_x0
xsubckt_1483_and21nor_x0 83 82 1631 1680 1688 1692 and21nor_x0
xsubckt_1888_nexor2_x0 83 82 1242 770 1239 nexor2_x0
xsubckt_2175_nexor2_x0 83 82 998 1003 997 nexor2_x0
xsubckt_2248_or21nand_x0 83 82 928 64 76 77 or21nand_x0
xfeed_1052 83 82 tie
xfeed_828 83 82 decap_w0
xfeed_594 83 82 tie
xsubckt_1215_and21nor_x0 83 82 1893 1919 1940 1942 and21nor_x0
xsubckt_1543_mux2_x1 83 82 26 33 699 1573 mux2_x1
xsubckt_2142_mux2_x1 83 82 69 78 605 1028 mux2_x1
xsubckt_2197_and21nor_x0 83 82 976 979 981 609 and21nor_x0
xsubckt_2288_nexor2_x0 83 82 73 74 890 nexor2_x0
xsubckt_2472_dff_x1 83 82 127 2579 105 dff_x1
xfeed_1053 83 82 tie
xfeed_829 83 82 decap_w0
xfeed_454 83 82 decap_w0
xsubckt_1188_and21nor_x0 83 82 1919 1974 1951 1973 and21nor_x0
xsubckt_754_nand2_x0 83 82 2344 327 28 nand2_x0
xsubckt_751_and2_x1 83 82 2346 2347 286 and2_x1
xsubckt_711_or2_x1 83 82 2386 2387 140 or2_x1
xsubckt_35_inv_x0 83 82 162 777 inv_x0
xsubckt_473_nor2_x0 83 82 2487 389 397 nor2_x0
xsubckt_1399_and21nor_x0 83 82 1713 1771 1773 1776 and21nor_x0
xfeed_1054 83 82 tie
xfeed_592 83 82 tie
xfeed_453 83 82 decap_w0
xfeed_189 83 82 tie
xfeed_167 83 82 tie
xsubckt_882_and2_x1 83 82 2218 142 23 and2_x1
xsubckt_1782_nexor2_x0 83 82 1342 1344 1340 nexor2_x0
xsubckt_1966_nexor2_x0 83 82 286 798 1165 nexor2_x0
xsubckt_2150_nand3_x0 83 82 1020 1021 612 138 nand3_x0
xfeed_1055 83 82 tie
xfeed_593 83 82 tie
xfeed_452 83 82 decap_w0
xfeed_188 83 82 tie
xsubckt_1182_and21nor_x0 83 82 1925 1929 1928 1926 and21nor_x0
xsubckt_933_nand3_x0 83 82 2169 73 809 139 nand3_x0
xsubckt_242_and3_x1 83 82 606 614 138 141 and3_x1
xsubckt_560_nand3_x0 83 82 305 701 789 810 nand3_x0
xsubckt_602_or21nand_x0 83 82 263 287 268 265 or21nand_x0
xsubckt_1354_nand3_x0 83 82 1757 1758 1765 1769 nand3_x0
xsubckt_1722_nand4_x0 83 82 1398 729 93 811 812 nand4_x0
xfeed_1056 83 82 tie
xfeed_590 83 82 tie
xfeed_451 83 82 decap_w0
xfeed_165 83 82 tie
xsubckt_1183_nand4_x0 83 82 1924 709 93 811 812 nand4_x0
xsubckt_829_or21nand_x0 83 82 2270 289 2285 2271 or21nand_x0
xsubckt_241_nand2_x0 83 82 607 614 141 nand2_x0
xsubckt_1429_and2_x1 83 82 1684 1686 1688 and2_x1
xsubckt_2407_dff_x1 83 82 2468 2561 79 dff_x1
xfeed_1057 83 82 decap_w0
xfeed_591 83 82 tie
xfeed_450 83 82 decap_w0
xsubckt_1238_nand2_x0 83 82 1871 30 141 nand2_x0
xsubckt_718_mux2_x1 83 82 67 66 141 2379 mux2_x1
xsubckt_2222_nand2_x0 83 82 953 617 736 nand2_x0
xfeed_1058 83 82 decap_w0
xfeed_822 83 82 decap_w0
xfeed_185 83 82 tie
xsubckt_185_nand3_x0 83 82 650 765 766 86 nand3_x0
xsubckt_486_nexor2_x0 83 82 378 714 377 nexor2_x0
xsubckt_1359_and2_x1 83 82 1753 1754 366 and2_x1
xsubckt_1653_or21nand_x0 83 82 1465 1512 1516 1520 or21nand_x0
xsubckt_1705_nand2_x0 83 82 1415 1419 76 nand2_x0
xsubckt_2358_and2_x1 83 82 826 49 72 and2_x1
xsubckt_2409_dff_x1 83 82 2466 2561 71 dff_x1
xsubckt_2500_dff_x1 83 82 2402 2554 44 dff_x1
xfeed_1059 83 82 decap_w0
xfeed_823 83 82 decap_w0
xfeed_184 83 82 decap_w0
xsubckt_1012_nand2_x0 83 82 2091 2092 335 nand2_x0
xsubckt_800_or21nand_x0 83 82 2299 2385 2381 2300 or21nand_x0
xsubckt_589_and21nor_x0 83 82 276 811 343 279 and21nor_x0
xsubckt_1880_nexor2_x0 83 82 286 613 1247 nexor2_x0
xsubckt_2064_or21nand_x0 83 82 1081 643 159 2504 or21nand_x0
xsubckt_2428_dff_x1 83 82 2447 2564 2519 dff_x1
xfeed_820 83 82 decap_w0
xfeed_169 83 82 tie
xsubckt_494_nand2_x0 83 82 370 372 785 nand2_x0
xsubckt_2012_and21nor_x0 83 82 2441 1277 1128 1125 and21nor_x0
xfeed_821 83 82 decap_w0
xfeed_186 83 82 tie
xfeed_168 83 82 tie
xsubckt_1096_or21nand_x0 83 82 2009 2012 2014 286 or21nand_x0
xsubckt_167_mux2_x1 83 82 94 33 669 659 mux2_x1
xsubckt_337_nand3_x0 83 82 516 614 759 141 nand3_x0
xsubckt_1415_nand3_x0 83 82 1698 616 760 139 nand3_x0
xsubckt_1481_or21nand_x0 83 82 1633 1686 1688 1689 or21nand_x0
xsubckt_1968_or3_x1 83 82 1163 1176 1186 1189 or3_x1
xsubckt_2132_or3_x1 83 82 1035 162 138 139 or3_x1
xsubckt_2347_or21nand_x0 83 82 836 843 840 842 or21nand_x0
xsubckt_2453_dff_x1 83 82 2425 2596 60 dff_x1
xfeed_826 83 82 decap_w0
xsubckt_961_nexor2_x0 83 82 2190 732 2141 nexor2_x0
xsubckt_834_nand2_x0 83 82 2265 2270 265 nand2_x0
xsubckt_401_nand2_x0 83 82 455 33 34 nand2_x0
xsubckt_1526_nexor2_x0 83 82 1591 1593 1589 nexor2_x0
xsubckt_1749_or21nand_x0 83 82 1372 90 764 11 or21nand_x0
xsubckt_2044_nexor2_x0 83 82 686 775 1096 nexor2_x0
xfeed_827 83 82 decap_w0
xsubckt_534_and21nor_x0 83 82 330 162 344 331 and21nor_x0
xsubckt_591_nand3_x0 83 82 274 54 93 812 nand3_x0
xsubckt_599_and2_x1 83 82 266 267 286 and2_x1
xsubckt_1325_nand3_x0 83 82 1786 1878 140 810 nand3_x0
xsubckt_1744_or21nand_x0 83 82 1377 1408 1416 1417 or21nand_x0
xsubckt_1810_and21nor_x0 83 82 1313 1347 1330 1346 and21nor_x0
xsubckt_2148_and2_x1 83 82 1022 790 67 and2_x1
xfeed_824 83 82 decap_w0
xfeed_598 83 82 decap_w0
xfeed_183 83 82 tie
xsubckt_134_and2_x1 83 82 682 683 685 and2_x1
xsubckt_1783_nand2_x0 83 82 1339 1965 335 nand2_x0
xsubckt_1845_nand3_x0 83 82 1280 1282 670 792 nand3_x0
xfeed_825 83 82 decap_w0
xfeed_599 83 82 tie
xfeed_458 83 82 tie
xfeed_182 83 82 tie
xsubckt_864_and21nor_x0 83 82 2236 2286 2289 2293 and21nor_x0
xsubckt_0_inv_x0 83 82 90 812 inv_x0
xsubckt_328_nexor2_x0 83 82 37 24 524 nexor2_x0
xsubckt_433_and21nor_x0 83 82 425 448 443 444 and21nor_x0
xsubckt_553_and2_x1 83 82 312 313 314 and2_x1
xsubckt_1463_or21nand_x0 83 82 1651 367 1659 1654 or21nand_x0
xsubckt_2020_nand2_x0 83 82 1117 1118 1119 nand2_x0
xfeed_299 83 82 tie
xsubckt_868_nexor2_x0 83 82 2284 42 2232 nexor2_x0
xsubckt_1332_mux2_x1 83 82 30 1781 607 1779 mux2_x1
xsubckt_2373_mux2_x1 83 82 48 813 618 2392 mux2_x1
xsubckt_2445_dff_x1 83 82 2433 2590 2505 dff_x1
xfeed_298 83 82 tie
xsubckt_708_nand3_x0 83 82 2389 614 68 141 nand3_x0
xsubckt_2420_dff_x1 83 82 2455 2583 74 dff_x1
xfeed_789 83 82 decap_w0
xsubckt_1040_and3_x1 83 82 2064 2066 2069 757 and3_x1
xsubckt_1981_or21nand_x0 83 82 2445 1152 1154 1156 or21nand_x0
xfeed_788 83 82 tie
xsubckt_1198_nexor2_x0 83 82 1936 48 1910 nexor2_x0
xsubckt_1176_nexor2_x0 83 82 1963 9 1931 nexor2_x0
xsubckt_959_and4_x1 83 82 2143 2284 732 733 734 and4_x1
xsubckt_144_and2_x1 83 82 137 673 2531 and2_x1
xsubckt_394_nand2_x0 83 82 462 464 716 nand2_x0
xsubckt_1715_and21nor_x0 83 82 1405 1441 1443 1446 and21nor_x0
xsubckt_1719_or21nand_x0 83 82 1401 90 764 12 or21nand_x0
xdiode_102 83 82 24 diode_w1
xsubckt_262_and2_x1 83 82 587 589 14 and2_x1
xsubckt_375_mux2_x1 83 82 25 36 606 480 mux2_x1
xsubckt_452_and21nor_x0 83 82 407 609 408 415 and21nor_x0
xsubckt_2217_nand3_x0 83 82 957 959 963 964 nand3_x0
xsubckt_2230_nand2_x0 83 82 945 76 77 nand2_x0
xdiode_103 83 82 24 diode_w1
xsubckt_898_nand3_x0 83 82 2203 614 751 141 nand3_x0
xsubckt_284_mux2_x1 83 82 784 781 605 566 mux2_x1
xsubckt_2_inv_x0 83 82 139 810 inv_x0
xsubckt_341_nand2_x0 83 82 512 515 4 nand2_x0
xsubckt_1304_or21nand_x0 83 82 1806 1822 1824 1861 or21nand_x0
xdiode_100 83 82 24 diode_w1
xsubckt_946_and3_x1 83 82 2156 2158 2161 759 and3_x1
xsubckt_919_and21nor_x0 83 82 2182 2186 2185 2183 and21nor_x0
xsubckt_157_mux2_x1 83 82 99 24 669 664 mux2_x1
xsubckt_469_nand2_x0 83 82 392 395 10 nand2_x0
xsubckt_2429_dff_x1 83 82 2446 2564 2518 dff_x1
xdiode_101 83 82 24 diode_w1
xsubckt_1029_nand2_x0 83 82 2474 2075 2077 nand2_x0
xsubckt_851_and21nor_x0 83 82 2249 2252 2264 26 and21nor_x0
xsubckt_351_and2_x1 83 82 502 504 610 and2_x1
xsubckt_1389_nexor2_x0 83 82 1725 1726 1723 nexor2_x0
xsubckt_1427_or21nand_x0 83 82 1686 1712 1733 1734 or21nand_x0
xsubckt_1849_and21nor_x0 83 82 1277 777 670 142 and21nor_x0
xsubckt_2185_or21nand_x0 83 82 988 1004 1000 999 or21nand_x0
xfeed_783 83 82 decap_w0
xfeed_291 83 82 tie
xsubckt_1135_nexor2_x0 83 82 1980 34 1971 nexor2_x0
xsubckt_240_and2_x1 83 82 608 614 141 and2_x1
xsubckt_1436_nand3_x0 83 82 1677 1678 1679 290 nand3_x0
xfeed_782 83 82 tie
xfeed_290 83 82 tie
xsubckt_956_and21nor_x0 83 82 2146 2192 2195 2199 and21nor_x0
xsubckt_428_mux2_x1 83 82 36 33 606 430 mux2_x1
xsubckt_1380_or21nand_x0 83 82 1732 1737 604 70 or21nand_x0
xsubckt_1740_and3_x1 83 82 1381 1386 447 75 and3_x1
xsubckt_1825_and21nor_x0 83 82 1299 1317 1319 1321 and21nor_x0
xfeed_781 83 82 decap_w0
xfeed_293 83 82 tie
xsubckt_1202_and21nor_x0 83 82 1906 334 1911 278 and21nor_x0
xsubckt_1013_and21nor_x0 83 82 2090 334 2095 278 and21nor_x0
xsubckt_815_and4_x1 83 82 2284 211 735 736 737 and4_x1
xsubckt_36_inv_x0 83 82 110 776 inv_x0
xsubckt_118_and4_x1 83 82 697 162 141 140 139 and4_x1
xsubckt_2231_nexor2_x0 83 82 76 77 944 nexor2_x0
xfeed_780 83 82 decap_w0
xfeed_292 83 82 tie
xsubckt_1073_and2_x1 83 82 2031 142 19 and2_x1
xsubckt_1006_nexor2_x0 83 82 2099 2101 2097 nexor2_x0
xsubckt_244_and3_x1 83 82 604 614 782 141 and3_x1
xsubckt_2281_nexor2_x0 83 82 901 733 897 nexor2_x0
xsubckt_2289_or2_x1 83 82 889 890 892 or2_x1
xfeed_787 83 82 tie
xfeed_295 83 82 tie
xsubckt_329_nand3_x0 83 82 523 524 529 530 nand3_x0
xsubckt_474_nand2_x0 83 82 388 617 709 nand2_x0
xsubckt_1658_nexor2_x0 83 82 1462 1467 1460 nexor2_x0
xsubckt_1957_nexor2_x0 83 82 1174 1178 1173 nexor2_x0
xsubckt_2449_dff_x1 83 82 2429 2590 2501 dff_x1
xfeed_786 83 82 tie
xfeed_294 83 82 tie
xsubckt_1898_and21nor_x0 83 82 1229 1231 1232 768 and21nor_x0
xsubckt_2250_and2_x1 83 82 926 75 76 and2_x1
xsubckt_171_mux2_x1 83 82 108 65 669 657 mux2_x1
xsubckt_129_or2_x1 83 82 687 2510 2509 or2_x1
xsubckt_1336_nand2_x0 83 82 1775 1780 71 nand2_x0
xsubckt_2179_or21nand_x0 83 82 993 66 68 67 or21nand_x0
xsubckt_2304_xor2_x0 83 82 72 73 875 xor2_x0
xfeed_784 83 82 decap_w0
xfeed_296 83 82 tie
xsubckt_764_nand3_x0 83 82 2334 701 752 810 nand3_x0
xsubckt_684_or21nand_x0 83 82 183 193 189 186 or21nand_x0
xsubckt_1698_or21nand_x0 83 82 1422 809 1424 1423 or21nand_x0
xfeed_798 83 82 tie
xfeed_286 83 82 tie
xsubckt_1144_nexor2_x0 83 82 1999 10 1962 nexor2_x0
xsubckt_958_nexor2_x0 83 82 2146 2148 2144 nexor2_x0
xsubckt_720_or21nand_x0 83 82 2377 2378 2380 140 or21nand_x0
xsubckt_233_or2_x1 83 82 615 141 140 or2_x1
xsubckt_1701_or21nand_x0 83 82 1419 1420 1421 465 or21nand_x0
xsubckt_1738_and21nor_x0 83 82 1383 1386 447 748 and21nor_x0
xsubckt_2386_dff_x1 83 82 2489 2581 12 dff_x1
xfeed_799 83 82 tie
xsubckt_1021_or21nand_x0 83 82 2082 289 2097 2083 or21nand_x0
xsubckt_929_nand2_x0 83 82 2172 142 22 nand2_x0
xsubckt_317_and2_x1 83 82 535 538 5 and2_x1
xsubckt_1394_and2_x1 83 82 1718 93 777 and2_x1
xfeed_284 83 82 decap_w0
xspare_feed_99 83 82 decap_w0
xsubckt_141_nexor2_x0 83 82 678 2517 675 nexor2_x0
xfeed_285 83 82 decap_w0
xspare_feed_98 83 82 tie
xsubckt_773_nexor2_x0 83 82 2331 28 2325 nexor2_x0
xsubckt_84_inv_x0 83 82 52 729 inv_x0
xsubckt_1626_and2_x1 83 82 1492 1493 777 and2_x1
xfeed_282 83 82 tie
xsubckt_1150_and21nor_x0 83 82 1956 1960 1959 1957 and21nor_x0
xsubckt_259_nand3_x0 83 82 590 614 783 141 nand3_x0
xsubckt_606_nand3_x0 83 82 260 614 70 141 nand3_x0
xsubckt_1638_and4_x1 83 82 1480 757 808 140 810 and4_x1
xfeed_283 83 82 tie
xsubckt_758_nand4_x0 83 82 2340 749 808 140 139 nand4_x0
xsubckt_209_nand3_x0 83 82 632 100 85 86 nand3_x0
xsubckt_362_nexor2_x0 83 82 493 498 492 nexor2_x0
xsubckt_499_nand2_x0 83 82 365 699 753 nand2_x0
xsubckt_511_nand3_x0 83 82 353 701 788 810 nand3_x0
xsubckt_1353_nor2_x0 83 82 1758 1759 264 nor2_x0
xfeed_389 83 82 tie
xfeed_280 83 82 tie
xsubckt_133_nor2_x0 83 82 683 2522 2521 nor2_x0
xsubckt_1620_and21nor_x0 83 82 1497 65 327 1498 and21nor_x0
xfeed_388 83 82 tie
xfeed_281 83 82 tie
xsubckt_837_nand4_x0 83 82 2263 75 141 809 139 nand4_x0
xsubckt_730_or21nand_x0 83 82 2367 200 179 180 or21nand_x0
xsubckt_126_and2_x1 83 82 690 691 771 and2_x1
xsubckt_526_or2_x1 83 82 338 93 162 or2_x1
xsubckt_1348_mux2_x1 83 82 1764 231 335 1763 mux2_x1
xsubckt_1618_or21nand_x0 83 82 1499 285 1513 1500 or21nand_x0
xsubckt_1622_and2_x1 83 82 1496 277 715 and2_x1
xsubckt_1830_and21nor_x0 83 82 1294 278 1908 1295 and21nor_x0
xfeed_790 83 82 decap_w0
xfeed_387 83 82 tie
xspare_feed_93 83 82 decap_w0
xsubckt_1187_or21nand_x0 83 82 1920 1975 1950 1972 or21nand_x0
xsubckt_809_nand2_x0 83 82 2290 2294 27 nand2_x0
xsubckt_663_nand4_x0 83 82 204 721 93 811 812 nand4_x0
xsubckt_451_nexor2_x0 83 82 409 414 408 nexor2_x0
xsubckt_1558_and21nor_x0 83 82 1558 1563 539 753 and21nor_x0
xsubckt_1886_and21nor_x0 83 82 1241 1243 1244 770 and21nor_x0
xfeed_791 83 82 decap_w0
xfeed_386 83 82 tie
xspare_feed_92 83 82 tie
xsubckt_1162_nor4_x0 83 82 1945 73 141 140 139 nor4_x0
xsubckt_1134_or2_x1 83 82 1972 1980 34 or2_x1
xsubckt_1689_and21nor_x0 83 82 1430 1434 1433 1431 and21nor_x0
xsubckt_1794_nexor2_x0 83 82 1330 1343 1328 nexor2_x0
xsubckt_2442_dff_x1 83 82 2436 2590 2508 dff_x1
xfeed_792 83 82 decap_w0
xfeed_385 83 82 tie
xspare_feed_91 83 82 tie
xsubckt_912_nexor2_x0 83 82 2233 733 2189 nexor2_x0
xsubckt_861_or21nand_x0 83 82 2239 2269 2289 2290 or21nand_x0
xsubckt_520_nor2_x0 83 82 344 345 347 nor2_x0
xsubckt_1777_nand3_x0 83 82 1345 1353 431 747 nand3_x0
xsubckt_2015_nexor2_x0 83 82 690 2512 1122 nexor2_x0
xfeed_793 83 82 decap_w0
xfeed_384 83 82 tie
xsubckt_1236_or21nand_x0 83 82 1873 1884 1880 1876 or21nand_x0
xsubckt_572_and21nor_x0 83 82 293 348 375 39 and21nor_x0
xsubckt_1922_or21nand_x0 83 82 1205 671 1208 1206 or21nand_x0
xfeed_383 83 82 tie
xspare_feed_97 83 82 tie
xsubckt_1104_nexor2_x0 83 82 2048 51 2001 nexor2_x0
xsubckt_971_nand2_x0 83 82 2131 2132 289 nand2_x0
xsubckt_70_inv_x0 83 82 80 743 inv_x0
xsubckt_396_nexor2_x0 83 82 464 716 460 nexor2_x0
xsubckt_522_nand2_x0 83 82 342 93 90 nand2_x0
xsubckt_1521_or21nand_x0 83 82 1594 1600 555 67 or21nand_x0
xsubckt_1863_nexor2_x0 83 82 1264 1273 1263 nexor2_x0
xsubckt_1973_nand3_x0 83 82 1158 670 777 798 nand3_x0
xfeed_795 83 82 tie
xfeed_382 83 82 tie
xspare_feed_96 83 82 decap_w0
xsubckt_1272_nand2_x0 83 82 1838 29 141 nand2_x0
xsubckt_685_and2_x1 83 82 182 183 198 and2_x1
xsubckt_130_and21nor_x0 83 82 686 689 2511 2510 and21nor_x0
xsubckt_542_nand3_x0 83 82 323 614 71 141 nand3_x0
xsubckt_1634_and21nor_x0 83 82 1484 139 809 1485 and21nor_x0
xsubckt_1699_and2_x1 83 82 1421 1422 810 and2_x1
xsubckt_2079_mux2_x1 83 82 1071 1072 1073 2428 mux2_x1
xfeed_796 83 82 tie
xfeed_381 83 82 tie
xfeed_288 83 82 tie
xspare_feed_95 83 82 tie
xsubckt_235_or2_x1 83 82 613 140 139 or2_x1
xsubckt_1516_nand2_x0 83 82 1599 1602 1603 nand2_x0
xsubckt_1570_or21nand_x0 83 82 1546 1551 1549 1547 or21nand_x0
xsubckt_1965_mux2_x1 83 82 162 1167 671 1166 mux2_x1
xsubckt_2263_mux2_x1 83 82 752 749 606 914 mux2_x1
xfeed_797 83 82 tie
xfeed_380 83 82 tie
xfeed_289 83 82 tie
xspare_feed_94 83 82 tie
xsubckt_218_nand3_x0 83 82 626 97 85 86 nand3_x0
xsubckt_162_and2_x1 83 82 119 662 2537 and2_x1
xsubckt_88_inv_x0 83 82 48 725 inv_x0
xsubckt_109_nand2_x0 83 82 705 140 810 nand2_x0
xsubckt_110_and3_x1 83 82 704 808 140 810 and3_x1
xsubckt_376_mux2_x1 83 82 760 757 606 479 mux2_x1
xsubckt_1795_or21nand_x0 83 82 1327 285 1328 265 or21nand_x0
xsubckt_2448_dff_x1 83 82 2430 2588 2502 dff_x1
xfeed_1106 83 82 decap_w0
xfeed_985 83 82 tie
xsubckt_1525_or21nand_x0 83 82 1590 1634 1636 1637 or21nand_x0
xsubckt_1806_and21nor_x0 83 82 1317 1342 1349 1352 and21nor_x0
xsubckt_2017_and2_x1 83 82 1120 1121 1277 and2_x1
xfeed_1107 83 82 decap_w0
xfeed_984 83 82 tie
xsubckt_1237_nand3_x0 83 82 1872 616 782 139 nand3_x0
xsubckt_1189_nexor2_x0 83 82 1920 1940 1918 nexor2_x0
xsubckt_938_or21nand_x0 83 82 2164 2168 2166 2165 or21nand_x0
xsubckt_903_nand2_x0 83 82 2198 2200 25 nand2_x0
xsubckt_536_nand2_x0 83 82 328 329 762 nand2_x0
xsubckt_2325_nand2_x0 83 82 856 616 72 nand2_x0
xspare_buffer_3 83 82 88 2545 buf_x4
xfeed_1104 83 82 decap_w0
xfeed_987 83 82 tie
xfeed_679 83 82 tie
xsubckt_1163_and21nor_x0 83 82 1944 731 611 1945 and21nor_x0
xsubckt_1022_or21nand_x0 83 82 2081 2152 2127 2149 or21nand_x0
xsubckt_930_and2_x1 83 82 2171 327 25 and2_x1
xsubckt_231_nand3_x0 83 82 617 700 138 810 nand3_x0
xsubckt_1398_and21nor_x0 83 82 1714 290 1723 1715 and21nor_x0
xsubckt_1800_and21nor_x0 83 82 1323 714 611 1324 and21nor_x0
xsubckt_1998_nand4_x0 83 82 1137 670 762 2514 777 nand4_x0
xsubckt_2071_nand3_x0 83 82 1076 644 744 152 nand3_x0
xsubckt_2356_and2_x1 83 82 2394 828 837 and2_x1
xspare_buffer_0 83 82 161 2598 buf_x4
xfeed_1105 83 82 decap_w0
xfeed_986 83 82 tie
xfeed_678 83 82 decap_w0
xsubckt_786_nand3_x0 83 82 2312 44 93 812 nand3_x0
xsubckt_737_nexor2_x0 83 82 211 737 2360 nexor2_x0
xsubckt_1812_and21nor_x0 83 82 1311 1313 1320 285 and21nor_x0
xsubckt_1979_and21nor_x0 83 82 1153 162 798 2517 and21nor_x0
xsubckt_2282_or21nand_x0 83 82 896 916 912 913 or21nand_x0
xdiode_38 83 82 142 diode_w1
xfeed_1102 83 82 decap_w0
xfeed_981 83 82 decap_w0
xsubckt_980_or21nand_x0 83 82 2475 2129 2125 2123 or21nand_x0
xsubckt_863_or21nand_x0 83 82 2237 2239 2241 286 or21nand_x0
xsubckt_2271_nand3_x0 83 82 906 907 921 925 nand3_x0
xsubckt_2441_dff_x1 83 82 135 2594 159 dff_x1
xdiode_39 83 82 142 diode_w1
xfeed_1103 83 82 tie
xfeed_980 83 82 tie
xsubckt_476_or2_x1 83 82 386 9 32 or2_x1
xspare_buffer_7 83 82 2545 2544 buf_x4
xfeed_1100 83 82 decap_w0
xfeed_983 83 82 tie
xsubckt_1053_and21nor_x0 83 82 2051 2098 2100 2103 and21nor_x0
xsubckt_76_inv_x0 83 82 45 737 inv_x0
xsubckt_1365_nand2_x0 83 82 1747 1749 2212 nand2_x0
xsubckt_1798_or21nand_x0 83 82 2455 1331 1327 1325 or21nand_x0
xsubckt_2196_or2_x1 83 82 977 979 981 or2_x1
xsubckt_2341_nexor2_x0 83 82 845 51 841 nexor2_x0
xsubckt_2346_nand2_x0 83 82 837 617 727 nand2_x0
xspare_buffer_4 83 82 2598 2597 buf_x4
xfeed_1101 83 82 decap_w0
xfeed_982 83 82 decap_w0
xsubckt_650_and2_x1 83 82 216 217 286 and2_x1
xsubckt_1859_and2_x1 83 82 1267 1269 1271 and2_x1
xdiode_34 83 82 285 diode_w1
xfeed_673 83 82 decap_w0
xsubckt_1140_and2_x1 83 82 1966 2003 727 and2_x1
xsubckt_1129_nor2_x0 83 82 1977 1980 755 nor2_x0
xsubckt_799_and21nor_x0 83 82 2300 810 791 140 and21nor_x0
xsubckt_683_and21nor_x0 83 82 184 192 190 185 and21nor_x0
xsubckt_56_inv_x0 83 82 36 757 inv_x0
xsubckt_624_nand3_x0 83 82 242 245 260 31 nand3_x0
xsubckt_1486_nand2_x0 83 82 1628 1629 290 nand2_x0
xsubckt_2340_nand2_x0 83 82 842 845 51 nand2_x0
xsubckt_2354_nexor2_x0 83 82 830 836 829 nexor2_x0
xdiode_35 83 82 285 diode_w1
xfeed_672 83 82 decap_w0
xsubckt_1276_nand2_x0 83 82 1834 1836 1837 nand2_x0
xsubckt_1268_and2_x1 83 82 1842 1843 2212 and2_x1
xsubckt_1001_nand2_x0 83 82 2102 2106 37 nand2_x0
xsubckt_192_and21nor_x0 83 82 112 645 668 763 and21nor_x0
xsubckt_183_mux2_x1 83 82 102 73 669 651 mux2_x1
xsubckt_435_or21nand_x0 83 82 423 34 32 33 or21nand_x0
xsubckt_595_and2_x1 83 82 270 271 777 and2_x1
xsubckt_1319_nand2_x0 83 82 1792 26 141 nand2_x0
xsubckt_1321_and2_x1 83 82 1790 1791 2212 and2_x1
xsubckt_2298_and2_x1 83 82 881 883 40 and2_x1
xdiode_36 83 82 142 diode_w1
xfeed_671 83 82 decap_w0
xsubckt_803_nand2_x0 83 82 2296 2297 140 nand2_x0
xsubckt_759_mux2_x1 83 82 77 2340 366 2339 mux2_x1
xsubckt_87_inv_x0 83 82 49 726 inv_x0
xsubckt_322_or3_x1 83 82 530 545 573 574 or3_x1
xsubckt_573_or21nand_x0 83 82 292 349 376 778 or21nand_x0
xsubckt_578_and2_x1 83 82 287 288 291 and2_x1
xsubckt_1597_nand3_x0 83 82 1520 1523 516 65 nand3_x0
xsubckt_2278_mux2_x1 83 82 751 748 606 900 mux2_x1
xspare_buffer_8 83 82 2598 2584 buf_x4
xdiode_37 83 82 142 diode_w1
xfeed_670 83 82 decap_w0
xsubckt_972_or21nand_x0 83 82 2130 2131 2133 285 or21nand_x0
xsubckt_1805_or21nand_x0 83 82 1318 1341 1350 1351 or21nand_x0
xsubckt_2209_nor3_x0 83 82 965 978 993 994 nor3_x0
xsubckt_2280_nand2_x0 83 82 898 901 41 nand2_x0
xsubckt_2357_and2_x1 83 82 827 617 726 and2_x1
xdiode_30 83 82 25 diode_w1
xfeed_989 83 82 tie
xfeed_677 83 82 decap_w0
xsubckt_899_and2_x1 83 82 2202 2204 607 and2_x1
xsubckt_282_nand3_x0 83 82 568 614 784 141 nand3_x0
xsubckt_1433_and21nor_x0 83 82 1680 1730 1725 1729 and21nor_x0
xsubckt_1828_or21nand_x0 83 82 1296 90 764 8 or21nand_x0
xsubckt_1992_mux2_x1 83 82 1143 1144 670 1142 mux2_x1
xsubckt_2299_nexor2_x0 83 82 884 40 880 nexor2_x0
xdiode_31 83 82 25 diode_w1
xfeed_988 83 82 decap_w0
xfeed_676 83 82 decap_w0
xsubckt_893_and21nor_x0 83 82 2208 2216 2213 2209 and21nor_x0
xsubckt_419_xor2_x0 83 82 32 33 438 xor2_x0
xsubckt_1544_mux2_x1 83 82 34 1573 373 1572 mux2_x1
xsubckt_1726_or21nand_x0 83 82 1394 285 1403 1395 or21nand_x0
xsubckt_2221_and2_x1 83 82 2403 954 973 and2_x1
xsubckt_2247_or2_x1 83 82 929 944 958 or2_x1
xdiode_32 83 82 285 diode_w1
xfeed_1108 83 82 decap_w0
xfeed_675 83 82 decap_w0
xsubckt_1564_nexor2_x0 83 82 1554 1574 1552 nexor2_x0
xsubckt_1615_nand2_x0 83 82 1502 1503 777 nand2_x0
xdiode_33 83 82 285 diode_w1
xfeed_1109 83 82 decap_w0
xfeed_674 83 82 tie
xsubckt_849_and2_x1 83 82 2251 2252 2264 and2_x1
xsubckt_787_nand2_x0 83 82 2311 2312 332 nand2_x0
xsubckt_673_mux2_x1 83 82 65 195 366 194 mux2_x1
xsubckt_190_and21nor_x0 83 82 113 646 648 763 and21nor_x0
xsubckt_482_and21nor_x0 83 82 381 384 386 387 and21nor_x0
xsubckt_588_nand3_x0 83 82 277 93 91 812 nand3_x0
xsubckt_976_nexor2_x0 83 82 2128 2147 2126 nexor2_x0
xsubckt_27_inv_x0 83 82 79 785 inv_x0
xsubckt_1358_nand4_x0 83 82 1754 759 808 140 139 nand4_x0
xsubckt_1571_and2_x1 83 82 1545 1546 285 and2_x1
xsubckt_1833_and21nor_x0 83 82 1291 1297 1294 1292 and21nor_x0
xsubckt_1918_or21nand_x0 83 82 1209 1218 1216 1210 or21nand_x0
xsubckt_1954_and3_x1 83 82 1176 162 2519 799 and3_x1
xsubckt_2182_or21nand_x0 83 82 990 610 997 991 or21nand_x0
xsubckt_2308_and21nor_x0 83 82 871 872 873 617 and21nor_x0
xsubckt_2311_mux2_x1 83 82 749 746 606 869 mux2_x1
xsubckt_1250_nand2_x0 83 82 1859 1860 1862 nand2_x0
xsubckt_454_and2_x1 83 82 406 617 711 and2_x1
xsubckt_1281_or21nand_x0 83 82 1829 1840 1834 1832 or21nand_x0
xsubckt_1628_and2_x1 83 82 1490 1491 289 and2_x1
xsubckt_2455_dff_x1 83 82 2423 2594 58 dff_x1
xsubckt_680_nand3_x0 83 82 187 701 791 810 nand3_x0
xsubckt_270_or21nand_x0 83 82 579 610 582 580 or21nand_x0
xsubckt_247_mux2_x1 83 82 782 779 605 601 mux2_x1
xsubckt_1725_nor2_x0 83 82 1395 1396 142 nor2_x0
xsubckt_2320_and3_x1 83 82 860 861 612 138 and3_x1
xsubckt_950_and3_x1 83 82 2152 2158 2161 24 and3_x1
xsubckt_694_nexor2_x0 83 82 182 781 173 nexor2_x0
xfeed_1018 83 82 tie
xfeed_888 83 82 decap_w0
xsubckt_1657_or21nand_x0 83 82 1461 1515 1517 1518 or21nand_x0
xsubckt_2382_dff_x1 83 82 2493 2574 2 dff_x1
xfeed_1019 83 82 tie
xfeed_889 83 82 tie
xsubckt_1116_and2_x1 83 82 1989 1990 762 and2_x1
xsubckt_239_nand2_x0 83 82 609 612 138 nand2_x0
xsubckt_348_nexor2_x0 83 82 36 37 505 nexor2_x0
xsubckt_488_and3_x1 83 82 376 614 78 141 and3_x1
xsubckt_1960_nand4_x0 83 82 1170 1172 679 110 799 nand4_x0
xsubckt_2140_and2_x1 83 82 2408 1030 762 and2_x1
xfeed_378 83 82 tie
xfeed_129 83 82 tie
xsubckt_678_nand2_x0 83 82 189 191 705 nand2_x0
xsubckt_150_nand3_x0 83 82 668 92 766 86 nand3_x0
xsubckt_332_and2_x1 83 82 520 521 618 and2_x1
xsubckt_408_and2_x1 83 82 449 617 715 and2_x1
xsubckt_559_or21nand_x0 83 82 306 318 312 309 or21nand_x0
xsubckt_1316_mux2_x1 83 82 760 1797 373 1795 mux2_x1
xsubckt_1410_and2_x1 83 82 1703 24 141 and2_x1
xsubckt_2094_mux2_x1 83 82 1061 1062 1073 2423 mux2_x1
xsubckt_2108_or21nand_x0 83 82 1051 638 84 21 or21nand_x0
xsubckt_2155_mux2_x1 83 82 790 787 605 1016 mux2_x1
xfeed_379 83 82 tie
xfeed_128 83 82 decap_w0
xsubckt_1113_nand4_x0 83 82 1992 711 93 811 812 nand4_x0
xsubckt_594_nand4_x0 83 82 271 723 93 811 812 nand4_x0
xsubckt_1818_nand2_x0 83 82 1305 1306 777 nand2_x0
xsubckt_1940_and3_x1 83 82 1189 162 2520 799 and3_x1
xsubckt_2440_dff_x1 83 82 136 2589 160 dff_x1
xfeed_1014 83 82 tie
xfeed_376 83 82 tie
xfeed_127 83 82 decap_w0
xsubckt_468_and2_x1 83 82 393 394 710 and2_x1
xsubckt_1572_or21nand_x0 83 82 1544 289 1552 1545 or21nand_x0
xfeed_1015 83 82 decap_w0
xfeed_885 83 82 tie
xfeed_126 83 82 decap_w0
xsubckt_1123_nand3_x0 83 82 1983 1984 2214 314 nand3_x0
xsubckt_999_nand3_x0 83 82 2104 2107 2111 37 nand3_x0
xsubckt_858_nand3_x0 83 82 2242 2252 2264 761 nand3_x0
xsubckt_392_mux2_x1 83 82 759 756 606 464 mux2_x1
xsubckt_1344_or21nand_x0 83 82 1767 1819 1826 1827 or21nand_x0
xsubckt_1346_nand2_x0 83 82 1765 1766 290 nand2_x0
xsubckt_1568_nand4_x0 83 82 1548 734 93 811 812 nand4_x0
xsubckt_2411_dff_x1 83 82 2464 2557 69 dff_x1
xfeed_1016 83 82 tie
xfeed_886 83 82 decap_w0
xfeed_374 83 82 tie
xfeed_125 83 82 tie
xsubckt_1230_and2_x1 83 82 1879 28 141 and2_x1
xsubckt_889_mux2_x1 83 82 615 700 810 2212 mux2_x1
xsubckt_538_nor3_x0 83 82 327 142 93 162 nor3_x0
xsubckt_1924_and2_x1 83 82 1204 670 162 and2_x1
xfeed_1017 83 82 tie
xfeed_887 83 82 decap_w0
xfeed_375 83 82 tie
xfeed_124 83 82 decap_w0
xsubckt_891_nand4_x0 83 82 2210 74 141 809 139 nand4_x0
xsubckt_286_nand2_x0 83 82 564 566 722 nand2_x0
xsubckt_225_nand3_x0 83 82 621 103 85 767 nand3_x0
xsubckt_485_and2_x1 83 82 378 379 380 and2_x1
xsubckt_574_nand2_x0 83 82 291 292 294 nand2_x0
xsubckt_1341_nexor2_x0 83 82 1772 1774 1770 nexor2_x0
xsubckt_2065_nand3_x0 83 82 1080 644 744 154 nand3_x0
xsubckt_2408_dff_x1 83 82 2467 2561 78 dff_x1
xsubckt_2501_dff_x1 83 82 2401 2554 43 dff_x1
xfeed_1010 83 82 decap_w0
xfeed_880 83 82 tie
xfeed_372 83 82 decap_w0
xfeed_123 83 82 decap_w0
xsubckt_1253_and21nor_x0 83 82 1856 1857 1858 162 and21nor_x0
xsubckt_1139_nexor2_x0 83 82 1969 1971 1967 nexor2_x0
xsubckt_229_nand2_x0 83 82 143 619 620 nand2_x0
xsubckt_339_mux2_x1 83 82 784 759 606 514 mux2_x1
xsubckt_1684_or21nand_x0 83 82 1435 91 342 713 or21nand_x0
xsubckt_2492_dff_x1 83 82 2410 2587 139 dff_x1
xfeed_1011 83 82 decap_w0
xfeed_881 83 82 tie
xfeed_373 83 82 tie
xfeed_122 83 82 decap_w0
xsubckt_1245_and21nor_x0 83 82 1864 1873 1869 1865 and21nor_x0
xsubckt_1127_and2_x1 83 82 1979 1980 755 and2_x1
xsubckt_854_nand3_x0 83 82 2246 2252 2264 26 nand3_x0
xsubckt_1710_nexor2_x0 83 82 1419 749 1410 nexor2_x0
xsubckt_2073_or21nand_x0 83 82 1075 643 159 2501 or21nand_x0
xsubckt_2424_dff_x1 83 82 2451 2569 2523 dff_x1
xfeed_1012 83 82 decap_w0
xfeed_882 83 82 tie
xfeed_370 83 82 decap_w0
xfeed_121 83 82 tie
xsubckt_1149_nand2_x0 83 82 1957 1958 332 nand2_x0
xsubckt_675_nand3_x0 83 82 192 194 196 361 nand3_x0
xsubckt_549_nexor2_x0 83 82 141 140 316 nexor2_x0
xsubckt_1413_nand2_x0 83 82 1700 1701 2212 nand2_x0
xsubckt_1499_mux2_x1 83 82 27 34 699 1616 mux2_x1
xsubckt_2063_and21nor_x0 83 82 2433 1082 1083 1090 and21nor_x0
xsubckt_2200_and2_x1 83 82 2404 974 989 and2_x1
xsubckt_2266_nexor2_x0 83 82 915 42 911 nexor2_x0
xfeed_1013 83 82 decap_w0
xfeed_883 83 82 tie
xfeed_371 83 82 decap_w0
xsubckt_62_inv_x0 83 82 64 751 inv_x0
xsubckt_2082_mux2_x1 83 82 1069 1070 1073 2427 mux2_x1
xfeed_1155 83 82 decap_w0
xfeed_934 83 82 decap_w0
xfeed_501 83 82 tie
xsubckt_1014_nand3_x0 83 82 2089 53 93 812 nand3_x0
xsubckt_953_nand2_x0 83 82 2149 2157 759 nand2_x0
xsubckt_546_nand4_x0 83 82 319 753 808 140 139 nand4_x0
xsubckt_1372_nand4_x0 83 82 1740 28 808 140 810 nand4_x0
xsubckt_1567_mux2_x1 83 82 1550 2232 335 1549 mux2_x1
xsubckt_1774_and3_x1 83 82 1348 1354 1355 74 and3_x1
xsubckt_1815_or21nand_x0 83 82 1308 335 1309 332 or21nand_x0
xsubckt_2085_mux2_x1 83 82 1067 1068 1073 2426 mux2_x1
xsubckt_2120_or21nand_x0 83 82 1043 638 84 17 or21nand_x0
xspare_feed_0 83 82 tie
xfeed_1154 83 82 decap_w0
xfeed_935 83 82 decap_w0
xfeed_500 83 82 tie
xsubckt_116_and3_x1 83 82 699 141 140 139 and3_x1
xsubckt_400_and21nor_x0 83 82 456 487 470 457 and21nor_x0
xsubckt_1426_nexor2_x0 83 82 1694 789 1687 nexor2_x0
xsubckt_1555_or21nand_x0 83 82 1561 1564 540 753 or21nand_x0
xsubckt_2486_dff_x1 83 82 137 2561 162 dff_x1
xspare_feed_1 83 82 tie
xfeed_1157 83 82 decap_w0
xfeed_936 83 82 decap_w0
xfeed_608 83 82 decap_w0
xfeed_503 83 82 tie
xsubckt_995_nand2_x0 83 82 2108 2109 315 nand2_x0
xsubckt_987_nand3_x0 83 82 2116 315 72 139 nand3_x0
xsubckt_753_or21nand_x0 83 82 2480 2345 2346 2391 or21nand_x0
xsubckt_695_nexor2_x0 83 82 182 30 172 nexor2_x0
xsubckt_2272_or21nand_x0 83 82 905 926 922 908 or21nand_x0
xspare_feed_2 83 82 tie
xfeed_1156 83 82 decap_w0
xfeed_937 83 82 decap_w0
xfeed_609 83 82 decap_w0
xfeed_502 83 82 tie
xsubckt_949_nand2_x0 83 82 2153 2157 24 nand2_x0
xsubckt_651_nand2_x0 83 82 215 220 265 nand2_x0
xsubckt_1858_nand2_x0 83 82 1268 1270 368 nand2_x0
xsubckt_2444_dff_x1 83 82 2434 2589 2506 dff_x1
xspare_feed_3 83 82 tie
xfeed_1151 83 82 decap_w0
xfeed_930 83 82 decap_w0
xfeed_505 83 82 decap_w0
xsubckt_1157_nexor2_x0 83 82 1951 1970 1949 nexor2_x0
xsubckt_944_or21nand_x0 83 82 2158 706 2164 2159 or21nand_x0
xsubckt_1401_nexor2_x0 83 82 1713 1727 1711 nexor2_x0
xsubckt_1895_nand2_x0 83 82 1232 1233 285 nand2_x0
xspare_feed_4 83 82 tie
xfeed_1150 83 82 decap_w0
xfeed_931 83 82 decap_w0
xfeed_504 83 82 decap_w0
xsubckt_916_and21nor_x0 83 82 2185 334 2189 278 and21nor_x0
xsubckt_187_nand2_x0 83 82 648 649 745 nand2_x0
xsubckt_60_inv_x0 83 82 66 753 inv_x0
xsubckt_455_mux2_x1 83 82 34 32 606 405 mux2_x1
xsubckt_2283_nexor2_x0 83 82 896 897 895 nexor2_x0
xspare_feed_5 83 82 tie
xfeed_1153 83 82 decap_w0
xfeed_932 83 82 decap_w0
xfeed_507 83 82 decap_w0
xsubckt_1138_or21nand_x0 83 82 1968 2008 2013 2017 or21nand_x0
xsubckt_1527_and21nor_x0 83 82 1588 1630 1636 1640 and21nor_x0
xsubckt_2410_dff_x1 83 82 2465 2557 70 dff_x1
xspare_feed_6 83 82 tie
xfeed_1152 83 82 decap_w0
xfeed_933 83 82 decap_w0
xfeed_506 83 82 decap_w0
xsubckt_697_and21nor_x0 83 82 170 290 171 202 and21nor_x0
xsubckt_654_nexor2_x0 83 82 234 721 213 nexor2_x0
xsubckt_1458_nand2_x0 83 82 1656 37 141 nand2_x0
xsubckt_1599_nand2_x0 83 82 1518 1522 65 nand2_x0
xsubckt_1953_or21nand_x0 83 82 1177 2517 777 797 or21nand_x0
xsubckt_2383_dff_x1 83 82 2492 2577 1 dff_x1
xspare_feed_7 83 82 tie
xfeed_602 83 82 tie
xfeed_509 83 82 decap_w0
xsubckt_926_and21nor_x0 83 82 2175 2244 2240 2243 and21nor_x0
xsubckt_206_nand3_x0 83 82 634 101 85 86 nand3_x0
xsubckt_2427_dff_x1 83 82 2448 2564 2520 dff_x1
xspare_feed_8 83 82 tie
xfeed_603 83 82 tie
xfeed_508 83 82 decap_w0
xsubckt_1205_and21nor_x0 83 82 1903 1907 1906 1904 and21nor_x0
xsubckt_42_inv_x0 83 82 2514 770 inv_x0
xsubckt_340_and2_x1 83 82 513 514 719 and2_x1
xsubckt_1307_and2_x1 83 82 1803 1804 338 and2_x1
xsubckt_2251_nand2_x0 83 82 925 75 76 nand2_x0
xsubckt_2477_dff_x1 83 82 122 2580 100 dff_x1
xsubckt_2499_dff_x1 83 82 2403 2548 45 dff_x1
xspare_feed_9 83 82 tie
xfeed_600 83 82 tie
xsubckt_592_and2_x1 83 82 273 274 332 and2_x1
xsubckt_1549_or21nand_x0 83 82 1567 2211 1571 1568 or21nand_x0
xsubckt_1655_and21nor_x0 83 82 1463 290 1464 1490 and21nor_x0
xsubckt_1942_nexor2_x0 83 82 286 2520 1187 nexor2_x0
xsubckt_2232_and3_x1 83 82 943 944 958 961 and3_x1
xsubckt_2294_or21nand_x0 83 82 885 899 896 898 or21nand_x0
xsubckt_1179_and21nor_x0 83 82 1928 334 1933 278 and21nor_x0
xsubckt_985_nand2_x0 83 82 2118 698 750 nand2_x0
xsubckt_290_nexor2_x0 83 82 561 570 560 nexor2_x0
xsubckt_4_inv_x0 83 82 141 808 inv_x0
xsubckt_1460_and2_x1 83 82 1654 1655 2212 and2_x1
xsubckt_2048_and21nor_x0 83 82 1092 1097 1094 1093 and21nor_x0
xsubckt_2307_and21nor_x0 83 82 872 875 876 609 and21nor_x0
xsubckt_2353_nexor2_x0 83 82 835 727 830 nexor2_x0
xfeed_1159 83 82 decap_w0
xfeed_938 83 82 decap_w0
xfeed_606 83 82 decap_w0
xsubckt_1267_nand3_x0 83 82 1843 1845 809 139 nand3_x0
xsubckt_1036_nand3_x0 83 82 2068 614 748 141 nand3_x0
xsubckt_16_inv_x0 83 82 2520 796 inv_x0
xsubckt_158_and2_x1 83 82 121 664 2537 and2_x1
xsubckt_1513_and2_x1 83 82 1602 1617 607 and2_x1
xsubckt_1874_nexor2_x0 83 82 286 612 1253 nexor2_x0
xsubckt_1890_nand3_x0 83 82 1237 2160 286 361 nand3_x0
xfeed_1158 83 82 decap_w0
xfeed_939 83 82 decap_w0
xfeed_607 83 82 decap_w0
xsubckt_1057_nand3_x0 83 82 2047 2143 729 730 nand3_x0
xsubckt_1494_and21nor_x0 83 82 1620 286 1632 1621 and21nor_x0
xsubckt_1875_nexor2_x0 83 82 286 611 1252 nexor2_x0
xsubckt_2180_nexor2_x0 83 82 993 995 992 nexor2_x0
xsubckt_2316_or21nand_x0 83 82 864 885 881 882 or21nand_x0
xfeed_604 83 82 tie
xsubckt_1075_or21nand_x0 83 82 2473 2033 2032 2030 or21nand_x0
xsubckt_788_and21nor_x0 83 82 2310 2314 2313 2311 and21nor_x0
xfeed_605 83 82 decap_w0
xsubckt_1016_and21nor_x0 83 82 2087 2091 2090 2088 and21nor_x0
xsubckt_648_or21nand_x0 83 82 218 346 294 298 or21nand_x0
xsubckt_26_inv_x0 83 82 78 786 inv_x0
xsubckt_2019_nand2_x0 83 82 1118 142 804 nand2_x0
xsubckt_2045_and4_x1 83 82 1095 1096 676 677 110 and4_x1
xsubckt_2300_and2_x1 83 82 879 880 885 and2_x1
xfeed_1142 83 82 tie
xfeed_941 83 82 decap_w0
xfeed_637 83 82 tie
xsubckt_960_nand4_x0 83 82 2142 2284 732 733 734 nand4_x0
xsubckt_1831_nand4_x0 83 82 1293 725 93 811 812 nand4_x0
xfeed_1143 83 82 decap_w0
xfeed_940 83 82 decap_w0
xfeed_636 83 82 tie
xsubckt_6_inv_x0 83 82 2501 806 inv_x0
xsubckt_453_nor2_x0 83 82 2489 407 418 nor2_x0
xsubckt_1681_and21nor_x0 83 82 1438 1466 1473 1476 and21nor_x0
xsubckt_1930_nand3_x0 83 82 1198 670 777 795 nand3_x0
xsubckt_2491_dff_x1 83 82 2411 2589 140 dff_x1
xfeed_1140 83 82 tie
xfeed_943 83 82 tie
xfeed_635 83 82 tie
xsubckt_201_or21nand_x0 83 82 637 638 84 2543 or21nand_x0
xsubckt_500_nand4_x0 83 82 364 791 808 140 139 nand4_x0
xsubckt_1310_and21nor_x0 83 82 2467 1807 1803 1801 and21nor_x0
xsubckt_1532_mux2_x1 83 82 1584 2283 335 1583 mux2_x1
xsubckt_2458_dff_x1 83 82 2420 2589 23 dff_x1
xfeed_1141 83 82 tie
xfeed_942 83 82 tie
xfeed_634 83 82 tie
xsubckt_1020_and2_x1 83 82 2083 2084 285 and2_x1
xsubckt_330_or21nand_x0 83 82 522 531 528 525 or21nand_x0
xsubckt_342_nexor2_x0 83 82 515 4 511 nexor2_x0
xsubckt_1405_nand4_x0 83 82 1708 27 808 140 810 nand4_x0
xsubckt_1685_mux2_x1 83 82 1435 2093 341 1434 mux2_x1
xsubckt_2024_nand2_x0 83 82 1114 1115 670 nand2_x0
xsubckt_2387_dff_x1 83 82 2488 2578 11 dff_x1
xfeed_1209 83 82 tie
xfeed_1146 83 82 decap_w0
xfeed_945 83 82 tie
xfeed_633 83 82 tie
xsubckt_1009_and2_x1 83 82 2094 2140 713 and2_x1
xsubckt_1676_nexor2_x0 83 82 1449 750 1443 nexor2_x0
xsubckt_1819_and21nor_x0 83 82 1304 1310 1307 1305 and21nor_x0
xsubckt_2093_and2_x1 83 82 1061 2543 58 and2_x1
xsubckt_2438_dff_x1 83 82 2437 2564 2509 dff_x1
xfeed_1208 83 82 tie
xfeed_1147 83 82 decap_w0
xfeed_944 83 82 tie
xfeed_632 83 82 tie
xsubckt_275_xor2_x0 83 82 25 26 575 xor2_x0
xsubckt_1656_and21nor_x0 83 82 1462 1514 1516 1519 and21nor_x0
xsubckt_1703_or2_x1 83 82 1417 1419 76 or2_x1
xsubckt_1993_nand2_x0 83 82 1141 1142 1277 nand2_x0
xfeed_1144 83 82 decap_w0
xfeed_947 83 82 decap_w0
xfeed_631 83 82 tie
xsubckt_978_and2_x1 83 82 2124 142 21 and2_x1
xsubckt_750_nexor2_x0 83 82 2349 2368 2347 nexor2_x0
xsubckt_10_inv_x0 83 82 2507 802 inv_x0
xfeed_1145 83 82 decap_w0
xfeed_946 83 82 tie
xfeed_630 83 82 tie
xsubckt_352_and21nor_x0 83 82 501 502 503 617 and21nor_x0
xsubckt_1305_nand3_x0 83 82 1805 1821 1823 1860 nand3_x0
xsubckt_1623_mux2_x1 83 82 1496 2141 335 1495 mux2_x1
xsubckt_1637_or4_x1 83 82 1481 1482 1483 1484 355 or4_x1
xsubckt_2007_nexor2_x0 83 82 691 2513 1129 nexor2_x0
xfeed_1205 83 82 tie
xfeed_949 83 82 decap_w0
xsubckt_777_nand2_x0 83 82 2321 2324 2325 nand2_x0
xsubckt_1364_and2_x1 83 82 1748 1749 2212 and2_x1
xsubckt_1654_nexor2_x0 83 82 1466 1468 1464 nexor2_x0
xsubckt_1907_and21nor_x0 83 82 1220 1257 1221 1256 and21nor_x0
xsubckt_1950_nand2_x0 83 82 1179 1180 762 nand2_x0
xsubckt_2478_dff_x1 83 82 121 2579 99 dff_x1
xsubckt_2496_dff_x1 83 82 2406 2551 54 dff_x1
xfeed_1204 83 82 tie
xfeed_948 83 82 decap_w0
xsubckt_1155_and21nor_x0 83 82 1951 2011 2013 2016 and21nor_x0
xsubckt_699_or21nand_x0 83 82 168 219 239 240 or21nand_x0
xsubckt_659_and21nor_x0 83 82 208 334 209 278 and21nor_x0
xsubckt_1944_nand2_x0 83 82 1185 1188 1190 nand2_x0
xsubckt_2218_nand3_x0 83 82 956 957 958 610 nand3_x0
xsubckt_2310_nand2_x0 83 82 870 617 53 nand2_x0
xsubckt_2396_dff_x1 83 82 2479 2557 28 dff_x1
xfeed_1207 83 82 tie
xfeed_1148 83 82 decap_w0
xsubckt_762_nand2_x0 83 82 2336 2337 705 nand2_x0
xsubckt_739_and21nor_x0 83 82 2358 335 2363 278 and21nor_x0
xsubckt_465_and21nor_x0 83 82 396 403 400 402 and21nor_x0
xsubckt_1356_mux2_x1 83 82 781 758 699 1756 mux2_x1
xsubckt_2126_or3_x1 83 82 1039 162 138 141 or3_x1
xsubckt_2208_nexor2_x0 83 82 967 968 966 nexor2_x0
xfeed_1206 83 82 tie
xfeed_1149 83 82 decap_w0
xsubckt_728_nexor2_x0 83 82 2374 782 2369 nexor2_x0
xsubckt_1600_nexor2_x0 83 82 1522 65 1517 nexor2_x0
xsubckt_2435_dff_x1 83 82 2440 2569 2512 dff_x1
xfeed_1201 83 82 decap_w0
xsubckt_1770_and3_x1 83 82 1352 1354 1355 747 and3_x1
xsubckt_2003_nand2_x0 83 82 1132 1133 1277 nand2_x0
xsubckt_2360_xor2_x0 83 82 49 72 824 xor2_x0
xfeed_1200 83 82 decap_w0
xsubckt_1105_nexor2_x0 83 82 2048 728 2000 nexor2_x0
xsubckt_216_nand3_x0 83 82 627 106 85 767 nand3_x0
xsubckt_1339_and21nor_x0 83 82 1772 1860 1821 1824 and21nor_x0
xsubckt_1862_nexor2_x0 83 82 1267 2523 1264 nexor2_x0
xsubckt_2056_nand3_x0 83 82 1086 644 744 157 nand3_x0
xfeed_1203 83 82 decap_w0
xfeed_639 83 82 tie
xsubckt_1278_and2_x1 83 82 1832 1833 607 and2_x1
xsubckt_847_and3_x1 83 82 2253 2254 2255 607 and3_x1
xsubckt_2095_and2_x1 83 82 1060 744 152 and2_x1
xsubckt_2154_and2_x1 83 82 1017 617 740 and2_x1
xfeed_1202 83 82 decap_w0
xfeed_638 83 82 tie
xsubckt_221_nand3_x0 83 82 624 96 85 86 nand3_x0
xsubckt_1791_and21nor_x0 83 82 1331 290 1340 1332 and21nor_x0
xsubckt_2220_or21nand_x0 83 82 954 610 966 955 or21nand_x0
xsubckt_2339_and2_x1 83 82 843 844 728 and2_x1
xfeed_848 83 82 decap_w0
xfeed_211 83 82 tie
xsubckt_1266_nand2_x0 83 82 1844 27 141 nand2_x0
xsubckt_1042_and21nor_x0 83 82 2062 2066 2069 757 and21nor_x0
xsubckt_819_nexor2_x0 83 82 2319 718 2280 nexor2_x0
xsubckt_38_inv_x0 83 82 2510 774 inv_x0
xsubckt_1367_or21nand_x0 83 82 1745 367 1752 1748 or21nand_x0
xsubckt_1848_nand4_x0 83 82 1278 670 762 777 2523 nand4_x0
xsubckt_2344_or21nand_x0 83 82 838 610 839 855 or21nand_x0
xspare_buffer_19 83 82 2545 2529 buf_x4
xfeed_849 83 82 decap_w0
xfeed_210 83 82 tie
xsubckt_1865_or21nand_x0 83 82 2451 1262 1276 1278 or21nand_x0
xsubckt_2005_nexor2_x0 83 82 1248 771 1131 nexor2_x0
xsubckt_2122_nand3_x0 83 82 1042 644 159 151 nand3_x0
xfeed_338 83 82 tie
xfeed_213 83 82 decap_w0
xsubckt_797_or21nand_x0 83 82 2479 2302 2303 2344 or21nand_x0
xsubckt_1691_or21nand_x0 83 82 1428 285 1440 1429 or21nand_x0
xsubckt_2077_and2_x1 83 82 1072 744 158 and2_x1
xfeed_339 83 82 tie
xfeed_212 83 82 tie
xsubckt_877_nand4_x0 83 82 2223 717 93 811 812 nand4_x0
xsubckt_1926_and21nor_x0 83 82 1202 799 162 2521 and21nor_x0
xsubckt_2090_and2_x1 83 82 1063 2543 59 and2_x1
xsubckt_2151_and2_x1 83 82 1019 1020 618 and2_x1
xsubckt_2417_dff_x1 83 82 2458 2581 77 dff_x1
xfeed_215 83 82 tie
xsubckt_1169_and21nor_x0 83 82 1938 1969 1976 1979 and21nor_x0
xsubckt_478_or21nand_x0 83 82 384 396 393 392 or21nand_x0
xsubckt_1337_nexor2_x0 83 82 1780 71 1774 nexor2_x0
xsubckt_2178_nexor2_x0 83 82 65 66 994 nexor2_x0
xfeed_214 83 82 tie
xsubckt_313_nand3_x0 83 82 539 614 760 141 nand3_x0
xsubckt_1451_and4_x1 83 82 1663 26 808 140 810 and4_x1
xsubckt_1470_nand2_x0 83 82 1644 1662 607 nand2_x0
xsubckt_1505_and2_x1 83 82 1610 1611 2212 and2_x1
xsubckt_1861_and3_x1 83 82 1265 1269 1271 793 and3_x1
xsubckt_1945_nand3_x0 83 82 1184 1187 1191 1193 nand3_x0
xfeed_518 83 82 decap_w0
xfeed_217 83 82 decap_w0
xsubckt_493_and2_x1 83 82 371 140 139 and2_x1
xsubckt_1420_mux2_x1 83 82 28 1695 607 1693 mux2_x1
xsubckt_1834_or2_x1 83 82 1290 1291 286 or2_x1
xsubckt_1923_or21nand_x0 83 82 2450 1276 1205 1261 or21nand_x0
xfeed_519 83 82 decap_w0
xfeed_216 83 82 decap_w0
xsubckt_8_inv_x0 83 82 2504 804 inv_x0
xsubckt_1317_mux2_x1 83 82 25 1796 373 1794 mux2_x1
xsubckt_2181_and21nor_x0 83 82 991 992 610 617 and21nor_x0
xsubckt_2439_dff_x1 83 82 111 2589 84 dff_x1
xfeed_840 83 82 tie
xfeed_516 83 82 decap_w0
xfeed_332 83 82 tie
xfeed_219 83 82 decap_w0
xsubckt_2043_nand2_x0 83 82 1097 1098 670 nand2_x0
xspare_buffer_11 83 82 2545 2539 buf_x4
xfeed_841 83 82 tie
xfeed_517 83 82 tie
xfeed_333 83 82 tie
xfeed_218 83 82 decap_w0
xsubckt_1195_or21nand_x0 83 82 2470 1921 1917 1913 or21nand_x0
xsubckt_1088_or2_x1 83 82 2017 2019 756 or2_x1
xsubckt_366_nexor2_x0 83 82 35 36 488 nexor2_x0
xsubckt_1528_or21nand_x0 83 82 1587 1631 1635 1639 or21nand_x0
xsubckt_2406_dff_x1 83 82 2469 2593 32 dff_x1
xfeed_842 83 82 tie
xfeed_514 83 82 decap_w0
xfeed_330 83 82 tie
xsubckt_1061_nexor2_x0 83 82 2094 12 2043 nexor2_x0
xsubckt_808_and2_x1 83 82 2291 2294 27 and2_x1
xsubckt_254_xor2_x0 83 82 28 27 594 xor2_x0
xsubckt_1964_nexor2_x0 83 82 680 2518 1167 nexor2_x0
xfeed_843 83 82 decap_w0
xfeed_515 83 82 decap_w0
xsubckt_934_nand2_x0 83 82 2168 2169 361 nand2_x0
xsubckt_567_nand2_x0 83 82 298 300 38 nand2_x0
xsubckt_2352_nand2_x0 83 82 831 835 50 nand2_x0
xspare_buffer_12 83 82 2598 2571 buf_x4
xfeed_844 83 82 decap_w0
xfeed_512 83 82 decap_w0
xfeed_336 83 82 tie
xsubckt_1277_nand4_x0 83 82 1833 30 808 140 810 nand4_x0
xsubckt_635_nexor2_x0 83 82 280 47 231 nexor2_x0
xsubckt_1518_and3_x1 83 82 1597 1599 554 67 and3_x1
xsubckt_2000_nexor2_x0 83 82 1224 1239 1135 nexor2_x0
xspare_buffer_15 83 82 2545 2534 buf_x4
xfeed_845 83 82 decap_w0
xfeed_513 83 82 decap_w0
xfeed_337 83 82 tie
xsubckt_1063_nand2_x0 83 82 2041 2042 335 nand2_x0
xsubckt_765_and3_x1 83 82 2333 2334 2335 607 and3_x1
xsubckt_740_nand3_x0 83 82 2357 45 93 812 nand3_x0
xsubckt_1318_and2_x1 83 82 1793 26 141 and2_x1
xfeed_846 83 82 decap_w0
xfeed_510 83 82 decap_w0
xfeed_334 83 82 tie
xsubckt_766_or21nand_x0 83 82 2332 2338 2336 2333 or21nand_x0
xsubckt_2254_and21nor_x0 83 82 922 929 928 923 and21nor_x0
xfeed_847 83 82 decap_w0
xfeed_511 83 82 decap_w0
xsubckt_827_or2_x1 83 82 2272 2273 2275 or2_x1
xsubckt_710_mux2_x1 83 82 2388 69 810 2387 mux2_x1
xsubckt_1580_and21nor_x0 83 82 1536 66 327 1537 and21nor_x0
xsubckt_1748_nand2_x0 83 82 1373 2001 335 nand2_x0
xspare_buffer_16 83 82 2598 2558 buf_x4
xfeed_1191 83 82 tie
xfeed_729 83 82 decap_w0
xfeed_71 83 82 tie
xsubckt_2470_dff_x1 83 82 129 2579 107 dff_x1
xfeed_1190 83 82 decap_w0
xfeed_728 83 82 tie
xfeed_70 83 82 tie
xsubckt_160_and2_x1 83 82 120 663 2537 and2_x1
xsubckt_541_and3_x1 83 82 324 614 71 141 and3_x1
xsubckt_2336_nand2_x0 83 82 846 617 728 nand2_x0
xsubckt_2389_dff_x1 83 82 2486 2582 9 dff_x1
xfeed_1193 83 82 tie
xfeed_73 83 82 tie
xsubckt_923_and2_x1 83 82 2178 2179 285 and2_x1
xsubckt_736_nexor2_x0 83 82 211 45 2361 nexor2_x0
xsubckt_672_nand4_x0 83 82 195 751 808 140 139 nand4_x0
xsubckt_556_and2_x1 83 82 309 310 705 and2_x1
xfeed_1192 83 82 tie
xfeed_72 83 82 tie
xsubckt_636_nexor2_x0 83 82 280 739 230 nexor2_x0
xsubckt_1327_and2_x1 83 82 1784 1785 1786 and2_x1
xfeed_1195 83 82 decap_w0
xfeed_75 83 82 tie
xspare_feed_48 83 82 tie
xsubckt_1115_or2_x1 83 82 1990 1991 1993 or2_x1
xsubckt_104_inv_x0 83 82 9 709 inv_x0
xsubckt_1334_nand2_x0 83 82 1777 1779 71 nand2_x0
xsubckt_1565_and21nor_x0 83 82 1551 91 2228 340 and21nor_x0
xfeed_1194 83 82 tie
xfeed_74 83 82 tie
xspare_feed_49 83 82 tie
xsubckt_1133_nor2_x0 83 82 1973 1980 34 nor2_x0
xsubckt_484_and21nor_x0 83 82 379 708 381 610 and21nor_x0
xsubckt_1312_and4_x1 83 82 1799 29 808 140 810 and4_x1
xsubckt_1670_and21nor_x0 83 82 1449 1450 1454 1456 and21nor_x0
xsubckt_2028_nand4_x0 83 82 1110 670 762 773 777 nand4_x0
xfeed_1197 83 82 decap_w0
xfeed_77 83 82 tie
xsubckt_973_and21nor_x0 83 82 2129 290 2144 2130 and21nor_x0
xsubckt_794_nexor2_x0 83 82 2306 2326 2304 nexor2_x0
xsubckt_326_nand2_x0 83 82 526 37 24 nand2_x0
xsubckt_412_mux2_x1 83 82 37 34 606 445 mux2_x1
xsubckt_1471_and21nor_x0 83 82 1643 1651 1648 1644 and21nor_x0
xfeed_1196 83 82 decap_w0
xfeed_76 83 82 tie
xsubckt_945_nand2_x0 83 82 2157 2158 2161 nand2_x0
xsubckt_243_nand3_x0 83 82 605 614 138 141 nand3_x0
xsubckt_1407_nand2_x0 83 82 1706 1707 373 nand2_x0
xsubckt_1608_and2_x1 83 82 1509 1510 290 and2_x1
xsubckt_2002_mux2_x1 83 82 1134 1135 670 1133 mux2_x1
xsubckt_2394_dff_x1 83 82 2481 2551 30 dff_x1
xfeed_1199 83 82 decap_w0
xfeed_721 83 82 tie
xspare_feed_44 83 82 tie
xsubckt_1243_and2_x1 83 82 1866 1867 607 and2_x1
xsubckt_1154_and21nor_x0 83 82 1952 290 1967 1953 and21nor_x0
xsubckt_1114_nand2_x0 83 82 1991 1992 777 nand2_x0
xsubckt_1060_and3_x1 83 82 2044 2140 712 713 and3_x1
xsubckt_382_nand2_x0 83 82 473 474 475 nand2_x0
xsubckt_598_nexor2_x0 83 82 295 347 267 nexor2_x0
xsubckt_1402_and21nor_x0 83 82 1710 788 339 142 and21nor_x0
xsubckt_1955_nand3_x0 83 82 1175 162 2519 799 nand3_x0
xsubckt_2164_or21nand_x0 83 82 1007 1008 609 618 or21nand_x0
xfeed_1198 83 82 decap_w0
xfeed_720 83 82 tie
xfeed_78 83 82 decap_w0
xspare_feed_45 83 82 tie
xsubckt_271_mux2_x1 83 82 14 579 618 2499 mux2_x1
xsubckt_1296_or21nand_x0 83 82 1814 91 342 14 or21nand_x0
xsubckt_1575_nand2_x0 83 82 1541 1543 1553 nand2_x0
xsubckt_1784_or21nand_x0 83 82 1338 90 764 10 or21nand_x0
xfeed_723 83 82 decap_w0
xspare_feed_46 83 82 tie
xsubckt_1178_nand2_x0 83 82 1929 1930 335 nand2_x0
xsubckt_1071_and21nor_x0 83 82 2033 290 2049 2034 and21nor_x0
xsubckt_745_or2_x1 83 82 2352 2353 2355 or2_x1
xsubckt_230_and3_x1 83 82 618 700 138 810 and3_x1
xsubckt_43_inv_x0 83 82 2515 769 inv_x0
xsubckt_371_or21nand_x0 83 82 483 610 492 484 or21nand_x0
xsubckt_1443_and2_x1 83 82 1670 1671 93 and2_x1
xsubckt_2450_dff_x1 83 82 2428 2596 63 dff_x1
xfeed_722 83 82 tie
xspare_feed_47 83 82 tie
xsubckt_798_nand2_x0 83 82 2301 327 27 nand2_x0
xsubckt_715_and2_x1 83 82 2382 2383 139 and2_x1
xsubckt_48_inv_x0 83 82 93 764 inv_x0
xsubckt_123_or3_x1 83 82 693 2516 2524 2523 or3_x1
xsubckt_143_or21nand_x0 83 82 673 776 675 674 or21nand_x0
xsubckt_619_or3_x1 83 82 247 249 250 608 or3_x1
xsubckt_1697_or2_x1 83 82 1423 36 140 or2_x1
xfeed_725 83 82 tie
xspare_feed_40 83 82 tie
xsubckt_23_inv_x0 83 82 69 789 inv_x0
xsubckt_621_or21nand_x0 83 82 245 255 251 248 or21nand_x0
xsubckt_1693_and21nor_x0 83 82 1426 77 327 1427 and21nor_x0
xfeed_724 83 82 decap_w0
xspare_feed_41 83 82 tie
xsubckt_204_mux2_x1 83 82 160 142 84 635 mux2_x1
xsubckt_46_inv_x0 83 82 85 766 inv_x0
xsubckt_1665_nand2_x0 83 82 1454 1455 139 nand2_x0
xspare_feed_42 83 82 tie
xsubckt_223_nand2_x0 83 82 145 623 624 nand2_x0
xsubckt_54_inv_x0 83 82 24 759 inv_x0
xsubckt_106_or21nand_x0 83 82 707 767 85 92 or21nand_x0
xsubckt_519_and3_x1 83 82 345 348 375 778 and3_x1
xsubckt_1602_or21nand_x0 83 82 1515 1558 1542 1555 or21nand_x0
xsubckt_2345_and2_x1 83 82 2395 838 846 and2_x1
xfeed_726 83 82 tie
xspare_feed_43 83 82 tie
xsubckt_1218_and21nor_x0 83 82 1890 285 1894 1891 and21nor_x0
xsubckt_776_nand2_x0 83 82 2322 2323 2326 nand2_x0
xsubckt_701_and21nor_x0 83 82 166 167 286 339 and21nor_x0
xsubckt_1301_nor3_x0 83 82 1809 1810 1811 1813 nor3_x0
xsubckt_1904_and21nor_x0 83 82 1223 1224 1240 1241 and21nor_x0
xfeed_1087 83 82 tie
xfeed_817 83 82 decap_w0
xfeed_444 83 82 decap_w0
xsubckt_662_and2_x1 83 82 205 206 332 and2_x1
xsubckt_177_mux2_x1 83 82 105 76 669 654 mux2_x1
xsubckt_89_inv_x0 83 82 15 724 inv_x0
xsubckt_1534_nand4_x0 83 82 1581 43 93 811 812 nand4_x0
xsubckt_1908_nexor2_x0 83 82 286 775 1219 nexor2_x0
xsubckt_2367_nand3_x0 83 82 817 818 819 609 nand3_x0
xfeed_1086 83 82 tie
xfeed_816 83 82 decap_w0
xfeed_445 83 82 decap_w0
xsubckt_289_nexor2_x0 83 82 567 722 561 nexor2_x0
xsubckt_165_mux2_x1 83 82 95 34 669 660 mux2_x1
xsubckt_1432_or21nand_x0 83 82 1681 1731 1724 1728 or21nand_x0
xsubckt_2023_nexor2_x0 83 82 1116 1221 1115 nexor2_x0
xsubckt_2351_and2_x1 83 82 832 835 50 and2_x1
xfeed_1085 83 82 decap_w0
xfeed_815 83 82 decap_w0
xfeed_446 83 82 decap_w0
xfeed_198 83 82 tie
xfeed_172 83 82 tie
xsubckt_981_and2_x1 83 82 2122 615 810 and2_x1
xsubckt_862_and2_x1 83 82 2238 2239 2241 and2_x1
xsubckt_58_inv_x0 83 82 34 755 inv_x0
xsubckt_491_nand3_x0 83 82 373 808 140 139 nand3_x0
xsubckt_1976_nand4_x0 83 82 1156 670 762 777 2517 nand4_x0
xsubckt_2086_and2_x1 83 82 1066 744 155 and2_x1
xsubckt_2368_and21nor_x0 83 82 2393 855 817 827 and21nor_x0
xfeed_1084 83 82 decap_w0
xfeed_814 83 82 tie
xfeed_447 83 82 tie
xfeed_199 83 82 decap_w0
xfeed_173 83 82 tie
xsubckt_1217_and2_x1 83 82 1891 1892 286 and2_x1
xsubckt_1172_nand3_x0 83 82 1935 2003 726 727 nand3_x0
xsubckt_1706_nor2_x0 83 82 1414 1419 749 nor2_x0
xsubckt_1838_or21nand_x0 83 82 1286 1288 1898 286 or21nand_x0
xsubckt_2187_mux2_x1 83 82 69 66 606 986 mux2_x1
xsubckt_2303_or21nand_x0 83 82 876 892 890 891 or21nand_x0
xfeed_1083 83 82 decap_w0
xfeed_813 83 82 decap_w0
xfeed_549 83 82 decap_w0
xfeed_440 83 82 tie
xfeed_174 83 82 tie
xsubckt_1064_and21nor_x0 83 82 2040 334 2045 278 and21nor_x0
xsubckt_908_or21nand_x0 83 82 2193 2235 2247 2248 or21nand_x0
xsubckt_760_and3_x1 83 82 2338 2339 2341 361 and3_x1
xsubckt_215_nand3_x0 83 82 628 98 85 86 nand3_x0
xsubckt_1297_and21nor_x0 83 82 1813 1814 1815 341 and21nor_x0
xsubckt_1514_nand2_x0 83 82 1601 1617 607 nand2_x0
xsubckt_1598_and21nor_x0 83 82 1519 1523 516 752 and21nor_x0
xsubckt_1972_or21nand_x0 83 82 1159 671 1160 1166 or21nand_x0
xfeed_1082 83 82 decap_w0
xfeed_812 83 82 tie
xfeed_548 83 82 decap_w0
xfeed_441 83 82 tie
xfeed_175 83 82 decap_w0
xsubckt_161_mux2_x1 83 82 97 36 669 662 mux2_x1
xsubckt_1295_nand3_x0 83 82 1815 279 343 811 nand3_x0
xsubckt_1397_nor2_x0 83 82 1715 1716 290 nor2_x0
xsubckt_2459_dff_x1 83 82 2419 2589 22 dff_x1
xfeed_1081 83 82 tie
xfeed_811 83 82 decap_w0
xfeed_442 83 82 tie
xfeed_176 83 82 decap_w0
xsubckt_25_inv_x0 83 82 71 787 inv_x0
xsubckt_1480_and21nor_x0 83 82 1634 1685 1687 1690 and21nor_x0
xfeed_1080 83 82 tie
xfeed_810 83 82 decap_w0
xfeed_443 83 82 decap_w0
xfeed_177 83 82 decap_w0
xsubckt_101_inv_x0 83 82 12 712 inv_x0
xsubckt_2363_nand2_x0 83 82 821 833 836 nand2_x0
xfeed_545 83 82 decap_w0
xfeed_192 83 82 tie
xfeed_178 83 82 tie
xsubckt_1248_and3_x1 83 82 1861 1863 1886 785 and3_x1
xsubckt_979_and21nor_x0 83 82 2123 24 327 2124 and21nor_x0
xsubckt_393_mux2_x1 83 82 24 35 606 463 mux2_x1
xsubckt_1396_and21nor_x0 83 82 1716 1722 1720 1717 and21nor_x0
xsubckt_1537_or2_x1 83 82 1578 1579 264 or2_x1
xsubckt_1900_nexor2_x0 83 82 1230 2516 1227 nexor2_x0
xsubckt_1943_and21nor_x0 83 82 1186 1193 1191 1187 and21nor_x0
xsubckt_2481_dff_x1 83 82 118 2580 96 dff_x1
xfeed_544 83 82 decap_w0
xfeed_179 83 82 decap_w0
xsubckt_301_nand2_x0 83 82 550 553 6 nand2_x0
xsubckt_208_nand2_x0 83 82 150 633 634 nand2_x0
xsubckt_186_and2_x1 83 82 649 85 86 and2_x1
xsubckt_421_or2_x1 83 82 436 438 439 or2_x1
xsubckt_510_nand2_x0 83 82 354 701 810 nand2_x0
xsubckt_1652_and21nor_x0 83 82 1466 1511 1517 1521 and21nor_x0
xsubckt_1879_nexor2_x0 83 82 286 614 1248 nexor2_x0
xsubckt_2027_and2_x1 83 82 1111 1112 1277 and2_x1
xfeed_547 83 82 decap_w0
xsubckt_1264_nand2_x0 83 82 1846 1848 366 nand2_x0
xsubckt_1035_nand2_x0 83 82 2069 2071 2073 nand2_x0
xsubckt_927_nexor2_x0 83 82 2176 2195 2174 nexor2_x0
xsubckt_283_mux2_x1 83 82 27 30 605 567 mux2_x1
xsubckt_1320_nand3_x0 83 82 1791 1793 809 139 nand3_x0
xfeed_546 83 82 decap_w0
xfeed_191 83 82 tie
xsubckt_816_nexor2_x0 83 82 2317 43 2283 nexor2_x0
xsubckt_2087_and2_x1 83 82 1065 2543 60 and2_x1
xsubckt_2211_or21nand_x0 83 82 963 66 64 65 or21nand_x0
xfeed_541 83 82 tie
xfeed_448 83 82 tie
xfeed_196 83 82 decap_w0
xsubckt_266_nexor2_x0 83 82 589 723 583 nexor2_x0
xsubckt_1314_mux2_x1 83 82 780 759 699 1797 mux2_x1
xsubckt_1847_nand3_x0 83 82 1279 670 762 777 nand3_x0
xsubckt_2124_and21nor_x0 83 82 2413 1041 1042 763 and21nor_x0
xfeed_540 83 82 tie
xfeed_449 83 82 tie
xfeed_197 83 82 tie
xsubckt_1141_nexor2_x0 83 82 2003 50 1965 nexor2_x0
xsubckt_1087_nor2_x0 83 82 2018 2019 756 nor2_x0
xsubckt_1939_nand2_x0 83 82 1190 1191 1193 nand2_x0
xsubckt_2495_dff_x1 83 82 2407 2551 55 dff_x1
xfeed_1089 83 82 tie
xfeed_819 83 82 decap_w0
xfeed_543 83 82 tie
xfeed_194 83 82 tie
xsubckt_1003_nexor2_x0 83 82 2106 758 2100 nexor2_x0
xsubckt_947_nand3_x0 83 82 2155 2158 2161 759 nand3_x0
xsubckt_398_nexor2_x0 83 82 459 460 458 nexor2_x0
xsubckt_1856_nand3_x0 83 82 1270 316 162 799 nand3_x0
xfeed_1088 83 82 tie
xfeed_818 83 82 decap_w0
xfeed_542 83 82 tie
xfeed_195 83 82 decap_w0
xsubckt_940_nand3_x0 83 82 2162 701 75 810 nand3_x0
xsubckt_867_and2_x1 83 82 2233 2284 734 and2_x1
xsubckt_302_nexor2_x0 83 82 553 721 549 nexor2_x0
xsubckt_1529_nexor2_x0 83 82 1588 1592 1586 nexor2_x0
xsubckt_1724_and21nor_x0 83 82 1396 1402 1399 1397 and21nor_x0
xsubckt_2083_and2_x1 83 82 1068 744 156 and2_x1
xfeed_1094 83 82 tie
xfeed_804 83 82 tie
xfeed_431 83 82 tie
xspare_buffer_55 83 82 2534 2533 buf_x4
xsubckt_948_and21nor_x0 83 82 2154 2158 2161 759 and21nor_x0
xsubckt_137_nand4_x0 83 82 679 683 685 796 797 nand4_x0
xsubckt_582_xor2_x0 83 82 14 15 283 xor2_x0
xsubckt_1465_nand3_x0 83 82 1649 1750 140 810 nand3_x0
xsubckt_2215_nexor2_x0 83 82 77 64 959 nexor2_x0
xfeed_1095 83 82 tie
xfeed_805 83 82 tie
xfeed_430 83 82 tie
xspare_buffer_54 83 82 2571 2568 buf_x4
xsubckt_1221_nand2_x0 83 82 1888 327 79 nand2_x0
xsubckt_831_or21nand_x0 83 82 2268 2306 2326 2327 or21nand_x0
xsubckt_64_inv_x0 83 82 76 749 inv_x0
xsubckt_1533_or21nand_x0 83 82 1582 811 2280 341 or21nand_x0
xsubckt_1829_or21nand_x0 83 82 1295 335 1296 332 or21nand_x0
xsubckt_1949_nand3_x0 83 82 1180 670 777 796 nand3_x0
xsubckt_2055_or21nand_x0 83 82 1087 643 159 2507 or21nand_x0
xfeed_1096 83 82 tie
xfeed_806 83 82 decap_w0
xfeed_558 83 82 tie
xfeed_433 83 82 tie
xspare_buffer_57 83 82 2571 2566 buf_x4
xsubckt_189_and2_x1 83 82 646 647 650 and2_x1
xsubckt_2030_nand2_x0 83 82 1108 1109 1110 nand2_x0
xsubckt_2190_nexor2_x0 83 82 987 46 983 nexor2_x0
xsubckt_2384_dff_x1 83 82 2491 2577 0 dff_x1
xfeed_1097 83 82 tie
xfeed_807 83 82 decap_w0
xfeed_559 83 82 tie
xfeed_432 83 82 tie
xspare_buffer_56 83 82 2571 2567 buf_x4
xsubckt_790_nand2_x0 83 82 2308 2309 777 nand2_x0
xsubckt_1308_or3_x1 83 82 1802 93 162 78 or3_x1
xsubckt_1590_and2_x1 83 82 1527 1528 1529 and2_x1
xsubckt_2025_nexor2_x0 83 82 689 773 1113 nexor2_x0
xsubckt_2130_and21nor_x0 83 82 1036 1040 316 142 and21nor_x0
xsubckt_2335_and2_x1 83 82 2396 847 857 and2_x1
xfeed_1090 83 82 tie
xfeed_909 83 82 decap_w0
xfeed_800 83 82 tie
xfeed_435 83 82 tie
xspare_buffer_51 83 82 2539 2535 buf_x4
xsubckt_622_and2_x1 83 82 244 245 260 and2_x1
xfeed_1091 83 82 tie
xfeed_908 83 82 decap_w0
xfeed_801 83 82 tie
xfeed_434 83 82 tie
xspare_buffer_50 83 82 2584 2572 buf_x4
xsubckt_653_nor4_x0 83 82 214 6 7 14 15 nor4_x0
xsubckt_277_or21nand_x0 83 82 573 26 28 27 or21nand_x0
xsubckt_182_and2_x1 83 82 125 652 2543 and2_x1
xsubckt_1393_nand4_x0 83 82 1719 46 93 811 812 nand4_x0
xsubckt_1493_or2_x1 83 82 1621 1622 264 or2_x1
xfeed_1188 83 82 decap_w0
xfeed_1092 83 82 tie
xfeed_802 83 82 tie
xfeed_437 83 82 tie
xfeed_68 83 82 tie
xspare_buffer_53 83 82 2571 2569 buf_x4
xsubckt_179_mux2_x1 83 82 104 75 669 653 mux2_x1
xsubckt_543_and4_x1 83 82 322 67 141 809 139 and4_x1
xsubckt_1870_nand3_x0 83 82 1257 2511 162 799 nand3_x0
xfeed_1189 83 82 decap_w0
xfeed_1093 83 82 tie
xfeed_803 83 82 tie
xfeed_436 83 82 tie
xspare_buffer_52 83 82 2571 2570 buf_x4
xsubckt_778_and3_x1 83 82 2320 2321 2322 290 and3_x1
xsubckt_210_nand3_x0 83 82 631 108 85 767 nand3_x0
xsubckt_508_nand3_x0 83 82 356 616 789 139 nand3_x0
xsubckt_1370_and2_x1 83 82 1742 1743 1744 and2_x1
xsubckt_1441_or21nand_x0 83 82 1672 1673 1675 1676 or21nand_x0
xsubckt_1461_nand2_x0 83 82 1653 1655 2212 nand2_x0
xsubckt_1679_nexor2_x0 83 82 1442 1443 1440 nexor2_x0
xsubckt_2050_nand3_x0 83 82 1091 639 160 81 nand3_x0
xsubckt_2127_or21nand_x0 83 82 1038 162 138 141 or21nand_x0
xsubckt_2270_nexor2_x0 83 82 74 75 907 nexor2_x0
xsubckt_2331_and2_x1 83 82 850 853 52 and2_x1
xfeed_1186 83 82 decap_w0
xfeed_905 83 82 tie
xfeed_552 83 82 tie
xfeed_439 83 82 tie
xsubckt_1424_nand2_x0 83 82 1689 1694 69 nand2_x0
xsubckt_1842_and3_x1 83 82 1283 2212 314 162 and3_x1
xfeed_1187 83 82 decap_w0
xfeed_904 83 82 tie
xfeed_553 83 82 decap_w0
xfeed_67 83 82 tie
xsubckt_1270_and21nor_x0 83 82 1840 1849 1847 1841 and21nor_x0
xsubckt_921_nand2_x0 83 82 2180 2181 777 nand2_x0
xsubckt_554_nand2_x0 83 82 311 313 314 nand2_x0
xsubckt_1912_nand3_x0 83 82 1215 687 162 799 nand3_x0
xfeed_1184 83 82 decap_w0
xfeed_907 83 82 decap_w0
xfeed_550 83 82 decap_w0
xfeed_64 83 82 tie
xsubckt_986_and3_x1 83 82 2117 2118 2214 314 and3_x1
xsubckt_29_inv_x0 83 82 28 783 inv_x0
xsubckt_467_mux2_x1 83 82 754 714 606 394 mux2_x1
xsubckt_1439_or21nand_x0 83 82 1674 91 342 5 or21nand_x0
xsubckt_1901_or21nand_x0 83 82 1226 1274 1265 1266 or21nand_x0
xfeed_1185 83 82 decap_w0
xfeed_906 83 82 decap_w0
xfeed_551 83 82 tie
xfeed_65 83 82 tie
xsubckt_1171_and3_x1 83 82 1936 2003 726 727 and3_x1
xsubckt_626_or21nand_x0 83 82 240 246 261 31 or21nand_x0
xsubckt_1582_nand2_x0 83 82 1535 699 714 nand2_x0
xsubckt_2479_dff_x1 83 82 120 2579 98 dff_x1
xsubckt_2497_dff_x1 83 82 2405 2548 47 dff_x1
xfeed_1182 83 82 tie
xfeed_1098 83 82 decap_w0
xfeed_901 83 82 tie
xfeed_808 83 82 decap_w0
xfeed_62 83 82 tie
xspare_buffer_59 83 82 2534 2532 buf_x4
xsubckt_734_nexor2_x0 83 82 214 720 2363 nexor2_x0
xsubckt_155_mux2_x1 83 82 100 25 669 665 mux2_x1
xsubckt_1566_and2_x1 83 82 1550 277 2 and2_x1
xsubckt_2084_and2_x1 83 82 1067 2543 61 and2_x1
xsubckt_2456_dff_x1 83 82 2422 2595 57 dff_x1
xfeed_1183 83 82 tie
xfeed_1099 83 82 decap_w0
xfeed_900 83 82 tie
xfeed_809 83 82 decap_w0
xfeed_63 83 82 tie
xspare_buffer_58 83 82 2571 2565 buf_x4
xsubckt_581_nor2_x0 83 82 284 14 15 nor2_x0
xsubckt_627_nexor2_x0 83 82 244 780 239 nexor2_x0
xsubckt_1559_or21nand_x0 83 82 1557 1564 540 66 or21nand_x0
xsubckt_2034_nexor2_x0 83 82 688 774 1105 nexor2_x0
xfeed_1180 83 82 decap_w0
xfeed_903 83 82 tie
xfeed_554 83 82 tie
xfeed_60 83 82 tie
xsubckt_1442_nand4_x0 83 82 1671 45 93 811 812 nand4_x0
xfeed_1181 83 82 decap_w0
xfeed_902 83 82 decap_w0
xfeed_555 83 82 decap_w0
xfeed_61 83 82 tie
xfeed_765 83 82 decap_w0
xspare_feed_88 83 82 tie
xsubckt_557_nand2_x0 83 82 308 310 705 nand2_x0
xsubckt_1284_and21nor_x0 83 82 1826 1829 1852 78 and21nor_x0
xsubckt_1587_nand2_x0 83 82 1530 1531 2212 nand2_x0
xsubckt_2274_and21nor_x0 83 82 903 910 609 617 and21nor_x0
xsubckt_2416_dff_x1 83 82 2459 2581 64 dff_x1
xfeed_764 83 82 decap_w0
xspare_feed_89 83 82 tie
xsubckt_1054_or21nand_x0 83 82 2050 2099 2101 2102 or21nand_x0
xsubckt_843_nand3_x0 83 82 2257 616 76 139 nand3_x0
xsubckt_410_nand3_x0 83 82 447 614 34 141 nand3_x0
xsubckt_2239_and21nor_x0 83 82 937 952 949 948 and21nor_x0
xsubckt_2295_mux2_x1 83 82 750 747 606 884 mux2_x1
xsubckt_7_inv_x0 83 82 2503 805 inv_x0
xsubckt_2414_dff_x1 83 82 2461 2583 66 dff_x1
xfeed_766 83 82 tie
xsubckt_785_and21nor_x0 83 82 2313 335 2318 278 and21nor_x0
xsubckt_79_inv_x0 83 82 42 734 inv_x0
xsubckt_460_or21nand_x0 83 82 400 414 411 410 or21nand_x0
xsubckt_1690_nor2_x0 83 82 1429 1430 264 nor2_x0
xfeed_761 83 82 tie
xfeed_398 83 82 decap_w0
xsubckt_910_nexor2_x0 83 82 2193 2194 2191 nexor2_x0
xsubckt_447_mux2_x1 83 82 756 714 606 412 mux2_x1
xsubckt_1767_or21nand_x0 83 82 1355 1356 1357 607 or21nand_x0
xsubckt_2125_or2_x1 83 82 1040 162 138 or2_x1
xfeed_760 83 82 decap_w0
xfeed_399 83 82 decap_w0
xfeed_258 83 82 tie
xsubckt_1151_nand4_x0 83 82 1955 710 93 811 812 nand4_x0
xsubckt_909_and21nor_x0 83 82 2192 2236 2246 2249 and21nor_x0
xsubckt_11_inv_x0 83 82 2508 801 inv_x0
xsubckt_327_xor2_x0 83 82 37 24 525 xor2_x0
xsubckt_1797_and21nor_x0 83 82 1325 74 327 1326 and21nor_x0
xfeed_763 83 82 tie
xsubckt_601_nand2_x0 83 82 264 338 762 nand2_x0
xfeed_762 83 82 decap_w0
xsubckt_840_mux2_x1 83 82 753 746 699 2260 mux2_x1
xsubckt_135_nand3_x0 83 82 681 683 685 796 nand3_x0
xsubckt_2195_nexor2_x0 83 82 64 65 978 nexor2_x0
xsubckt_2475_dff_x1 83 82 124 2595 102 dff_x1
xfeed_394 83 82 decap_w0
xfeed_255 83 82 tie
xspare_feed_80 83 82 tie
xsubckt_719_nor2_x0 83 82 2378 2379 139 nor2_x0
xsubckt_357_mux2_x1 83 82 26 37 606 497 mux2_x1
xsubckt_449_nand2_x0 83 82 410 413 12 nand2_x0
xsubckt_1428_and21nor_x0 83 82 1685 1713 1732 1735 and21nor_x0
xsubckt_2399_dff_x1 83 82 2476 2594 25 dff_x1
xfeed_395 83 82 decap_w0
xfeed_254 83 82 tie
xspare_feed_81 83 82 tie
xsubckt_897_nand4_x0 83 82 2204 77 808 140 810 nand4_x0
xsubckt_193_and4_x1 83 82 644 742 80 81 2541 and4_x1
xsubckt_497_and3_x1 83 82 367 141 809 139 and3_x1
xfeed_396 83 82 decap_w0
xfeed_257 83 82 tie
xspare_feed_82 83 82 tie
xsubckt_681_and3_x1 83 82 186 187 188 607 and3_x1
xsubckt_2296_mux2_x1 83 82 77 74 606 883 mux2_x1
xfeed_397 83 82 decap_w0
xfeed_256 83 82 tie
xspare_feed_83 83 82 tie
xsubckt_1287_or21nand_x0 83 82 1823 1830 1853 78 or21nand_x0
xsubckt_1734_and2_x1 83 82 1387 1388 607 and2_x1
xsubckt_2398_dff_x1 83 82 2477 2577 26 dff_x1
xfeed_390 83 82 tie
xfeed_251 83 82 tie
xspare_feed_84 83 82 decap_w0
xsubckt_724_and3_x1 83 82 2373 2375 2389 29 and3_x1
xsubckt_5_inv_x0 83 82 59 807 inv_x0
xsubckt_131_and21nor_x0 83 82 685 2511 689 687 and21nor_x0
xsubckt_1959_nand3_x0 83 82 1171 670 777 797 nand3_x0
xsubckt_2216_or21nand_x0 83 82 958 965 962 960 or21nand_x0
xsubckt_2322_nand2_x0 83 82 858 859 618 nand2_x0
xsubckt_2377_dff_x1 83 82 2498 2551 7 dff_x1
xsubckt_2485_dff_x1 83 82 132 2569 110 dff_x1
xfeed_768 83 82 tie
xfeed_391 83 82 decap_w0
xfeed_250 83 82 decap_w0
xspare_feed_85 83 82 tie
xsubckt_1209_and21nor_x0 83 82 1899 1938 1941 1943 and21nor_x0
xsubckt_1083_nand4_x0 83 82 2022 746 808 140 810 nand4_x0
xsubckt_1079_nand3_x0 83 82 2026 2027 2214 314 nand3_x0
xsubckt_696_nexor2_x0 83 82 173 201 171 nexor2_x0
xsubckt_19_inv_x0 83 82 2523 793 inv_x0
xsubckt_503_nand2_x0 83 82 361 616 139 nand2_x0
xsubckt_1827_nand2_x0 83 82 1297 1910 335 nand2_x0
xfeed_392 83 82 decap_w0
xspare_feed_86 83 82 tie
xsubckt_156_and2_x1 83 82 122 665 2537 and2_x1
xsubckt_2421_dff_x1 83 82 2454 2593 73 dff_x1
xfeed_393 83 82 decap_w0
xfeed_252 83 82 tie
xspare_feed_87 83 82 decap_w0
xsubckt_1126_or21nand_x0 83 82 1980 1981 1982 1985 or21nand_x0
xsubckt_901_nand2_x0 83 82 2200 2201 2203 nand2_x0
xsubckt_314_mux2_x1 83 82 28 25 606 538 mux2_x1
xsubckt_2227_and2_x1 83 82 948 951 44 and2_x1
xsubckt_2291_and21nor_x0 83 82 887 888 889 617 and21nor_x0
xsubckt_2457_dff_x1 83 82 2421 2596 56 dff_x1
xdiode_49 83 82 140 diode_w1
xfeed_1133 83 82 tie
xfeed_992 83 82 tie
xfeed_668 83 82 tie
xsubckt_487_mux2_x1 83 82 8 377 618 2485 mux2_x1
xsubckt_1913_and2_x1 83 82 1214 1215 1217 and2_x1
xsubckt_2189_and2_x1 83 82 984 986 46 and2_x1
xdiode_48 83 82 140 diode_w1
xfeed_1132 83 82 decap_w0
xfeed_669 83 82 tie
xsubckt_691_or21nand_x0 83 82 176 184 199 30 or21nand_x0
xsubckt_288_nand2_x0 83 82 562 567 7 nand2_x0
xsubckt_383_or21nand_x0 83 82 472 490 488 489 or21nand_x0
xsubckt_1542_or21nand_x0 83 82 1574 1588 1592 1596 or21nand_x0
xsubckt_2143_or21nand_x0 83 82 1027 1028 610 618 or21nand_x0
xfeed_1131 83 82 decap_w0
xfeed_990 83 82 tie
xsubckt_1246_or21nand_x0 83 82 1863 1874 1868 1866 or21nand_x0
xsubckt_677_and2_x1 83 82 190 191 705 and2_x1
xsubckt_21_inv_x0 83 82 67 791 inv_x0
xsubckt_472_and21nor_x0 83 82 389 609 390 415 and21nor_x0
xsubckt_1835_and21nor_x0 83 82 1289 290 1298 1290 and21nor_x0
xsubckt_2041_and21nor_x0 83 82 1099 1260 1220 1259 and21nor_x0
xfeed_1130 83 82 decap_w0
xfeed_991 83 82 tie
xsubckt_925_or21nand_x0 83 82 2176 2245 2239 2242 or21nand_x0
xsubckt_248_or21nand_x0 83 82 600 602 610 618 or21nand_x0
xsubckt_637_nand2_x0 83 82 229 230 334 nand2_x0
xsubckt_1645_nand2_x0 83 82 1473 1477 64 nand2_x0
xsubckt_2471_dff_x1 83 82 128 2579 106 dff_x1
xfeed_1137 83 82 decap_w0
xfeed_996 83 82 decap_w0
xfeed_39 83 82 tie
xsubckt_769_nand3_x0 83 82 2329 2332 2343 28 nand3_x0
xsubckt_1592_nand4_x0 83 82 1525 37 808 140 810 nand4_x0
xsubckt_2014_nand2_x0 83 82 1123 1124 670 nand2_x0
xfeed_1136 83 82 tie
xfeed_997 83 82 decap_w0
xfeed_38 83 82 tie
xsubckt_747_or21nand_x0 83 82 2350 289 2365 2351 or21nand_x0
xsubckt_422_and21nor_x0 83 82 435 438 439 609 and21nor_x0
xsubckt_1511_and21nor_x0 83 82 1604 1614 1610 1605 and21nor_x0
xfeed_1135 83 82 decap_w0
xfeed_994 83 82 decap_w0
xsubckt_1045_nand3_x0 83 82 2059 2066 2069 36 nand3_x0
xsubckt_1039_nand2_x0 83 82 2065 2067 2068 nand2_x0
xsubckt_3_inv_x0 83 82 140 809 inv_x0
xsubckt_384_nand2_x0 83 82 471 34 35 nand2_x0
xsubckt_1752_nand4_x0 83 82 1369 728 93 811 812 nand4_x0
xsubckt_2144_nand2_x0 83 82 1026 1027 741 nand2_x0
xfeed_1134 83 82 tie
xfeed_995 83 82 tie
xsubckt_1254_nor2_x0 83 82 1855 1856 142 nor2_x0
xsubckt_1208_or2_x1 83 82 1900 1901 1903 or2_x1
xsubckt_1019_or2_x1 83 82 2084 2085 2087 or2_x1
xsubckt_664_nand2_x0 83 82 203 204 289 nand2_x0
xsubckt_346_or2_x1 83 82 507 36 37 or2_x1
xsubckt_1612_nand2_x0 83 82 1505 1506 332 nand2_x0
xsubckt_1779_nand2_x0 83 82 1343 1349 1351 nand2_x0
xsubckt_2129_or3_x1 83 82 1037 162 138 140 or3_x1
xsubckt_2238_and2_x1 83 82 938 617 735 and2_x1
xdiode_41 83 82 289 diode_w1
xfeed_660 83 82 tie
xsubckt_997_nand2_x0 83 82 2106 2107 2111 nand2_x0
xsubckt_856_nand2_x0 83 82 2244 2250 26 nand2_x0
xsubckt_420_nexor2_x0 83 82 32 33 437 nexor2_x0
xsubckt_1453_mux2_x1 83 82 783 756 699 1661 mux2_x1
xsubckt_2337_mux2_x1 83 82 74 72 606 845 mux2_x1
xdiode_40 83 82 289 diode_w1
xfeed_661 83 82 tie
xfeed_34 83 82 tie
xsubckt_86_inv_x0 83 82 50 727 inv_x0
xsubckt_1552_and2_x1 83 82 1564 1565 1567 and2_x1
xdiode_43 83 82 286 diode_w1
xfeed_1139 83 82 tie
xfeed_998 83 82 decap_w0
xfeed_662 83 82 tie
xfeed_37 83 82 tie
xsubckt_915_nand2_x0 83 82 2186 2187 335 nand2_x0
xsubckt_1768_nand3_x0 83 82 1354 614 33 141 nand3_x0
xsubckt_1928_nexor2_x0 83 82 286 795 1200 nexor2_x0
xsubckt_2033_and2_x1 83 82 1106 1107 670 and2_x1
xsubckt_2502_dff_x1 83 82 2400 2554 42 dff_x1
xdiode_42 83 82 286 diode_w1
xfeed_1138 83 82 tie
xfeed_999 83 82 decap_w0
xsubckt_71_inv_x0 83 82 160 742 inv_x0
xsubckt_1452_nand4_x0 83 82 1662 26 808 140 810 nand4_x0
xdiode_45 83 82 140 diode_w1
xfeed_664 83 82 tie
xsubckt_1210_nexor2_x0 83 82 32 72 1898 nexor2_x0
xsubckt_1147_and21nor_x0 83 82 1959 334 1964 278 and21nor_x0
xsubckt_830_and21nor_x0 83 82 2269 2305 2325 2328 and21nor_x0
xsubckt_2039_and2_x1 83 82 1100 1101 1102 and2_x1
xdiode_44 83 82 140 diode_w1
xfeed_665 83 82 tie
xfeed_30 83 82 decap_w0
xsubckt_1228_and2_x1 83 82 1881 1882 366 and2_x1
xsubckt_1174_nexor2_x0 83 82 1966 726 1933 nexor2_x0
xsubckt_743_nand4_x0 83 82 2354 720 93 811 812 nand4_x0
xsubckt_717_and2_x1 83 82 2380 2382 2384 and2_x1
xsubckt_417_and21nor_x0 83 82 440 442 448 610 and21nor_x0
xsubckt_1384_or21nand_x0 83 82 1728 1737 604 788 or21nand_x0
xsubckt_1793_or21nand_x0 83 82 1329 1364 1379 1380 or21nand_x0
xsubckt_2088_mux2_x1 83 82 1065 1066 1073 2425 mux2_x1
xdiode_47 83 82 140 diode_w1
xfeed_666 83 82 tie
xfeed_33 83 82 tie
xsubckt_18_inv_x0 83 82 2522 794 inv_x0
xsubckt_146_and3_x1 83 82 671 676 677 110 and3_x1
xsubckt_1551_and2_x1 83 82 1565 1566 607 and2_x1
xsubckt_1994_nand4_x0 83 82 1140 670 762 769 777 nand4_x0
xsubckt_2172_and2_x1 83 82 1000 1002 739 and2_x1
xdiode_46 83 82 140 diode_w1
xfeed_32 83 82 tie
xsubckt_1018_nand2_x0 83 82 2085 2086 777 nand2_x0
xsubckt_358_mux2_x1 83 82 761 758 606 496 mux2_x1
xsubckt_1300_nand2_x0 83 82 1810 1812 777 nand2_x0
xsubckt_1604_nexor2_x0 83 82 1515 1516 1513 nexor2_x0
xfeed_1069 83 82 decap_w0
xsubckt_1118_nor2_x0 83 82 1987 1988 2004 nor2_x0
xsubckt_904_and3_x1 83 82 2197 2201 2203 25 and3_x1
xsubckt_767_and2_x1 83 82 2331 2332 2343 and2_x1
xsubckt_682_nand3_x0 83 82 185 187 188 607 nand3_x0
xsubckt_531_and3_x1 83 82 333 93 811 812 and3_x1
xsubckt_1522_nexor2_x0 83 82 1598 67 1593 nexor2_x0
xsubckt_1680_or21nand_x0 83 82 1439 1465 1474 1475 or21nand_x0
xsubckt_1723_nand2_x0 83 82 1397 1398 777 nand2_x0
xsubckt_2069_and21nor_x0 83 82 2431 1078 1079 1090 and21nor_x0
xfeed_1068 83 82 decap_w0
xsubckt_498_nand3_x0 83 82 366 141 809 139 nand3_x0
xfeed_349 83 82 tie
xsubckt_174_and2_x1 83 82 129 656 2537 and2_x1
xsubckt_1497_nand2_x0 83 82 1618 327 67 nand2_x0
xsubckt_1871_and21nor_x0 83 82 1256 799 162 2511 and21nor_x0
xfeed_348 83 82 decap_w0
xsubckt_1241_nand2_x0 83 82 1868 1870 1872 nand2_x0
xsubckt_347_xor2_x0 83 82 36 37 506 xor2_x0
xsubckt_1489_or21nand_x0 83 82 1625 811 2318 341 or21nand_x0
xsubckt_1739_nand2_x0 83 82 1382 1384 75 nand2_x0
xsubckt_2191_nexor2_x0 83 82 983 988 982 nexor2_x0
xsubckt_2255_or21nand_x0 83 82 921 930 927 924 or21nand_x0
xsubckt_1028_and21nor_x0 83 82 2075 2082 2078 2076 and21nor_x0
xsubckt_1732_mux2_x1 83 82 32 1390 1391 1389 mux2_x1
xsubckt_2223_or21nand_x0 83 82 952 970 967 969 or21nand_x0
xsubckt_2412_dff_x1 83 82 2463 2557 68 dff_x1
xfeed_139 83 82 tie
xsubckt_1098_and21nor_x0 83 82 2007 2051 2061 2064 and21nor_x0
xsubckt_814_nexor2_x0 83 82 2287 2288 2285 nexor2_x0
xsubckt_461_nexor2_x0 83 82 400 401 399 nexor2_x0
xsubckt_1361_and2_x1 83 82 1751 25 141 and2_x1
xsubckt_1996_and2_x1 83 82 1138 1139 1140 and2_x1
xsubckt_2402_dff_x1 83 82 2473 2593 36 dff_x1
xsubckt_353_or21nand_x0 83 82 500 610 510 501 or21nand_x0
xsubckt_1501_nand2_x0 83 82 1614 1615 366 nand2_x0
xsubckt_1773_nand3_x0 83 82 1349 1353 431 74 nand3_x0
xsubckt_1970_and3_x1 83 82 1161 1163 1165 1177 and3_x1
xsubckt_57_inv_x0 83 82 35 756 inv_x0
xsubckt_2369_or21nand_x0 83 82 816 820 826 48 or21nand_x0
xfeed_1061 83 82 decap_w0
xfeed_343 83 82 tie
xfeed_134 83 82 tie
xsubckt_1244_nand2_x0 83 82 1865 1867 607 nand2_x0
xsubckt_1197_nexor2_x0 83 82 1936 725 1911 nexor2_x0
xsubckt_1038_and2_x1 83 82 2066 2067 2068 and2_x1
xsubckt_9_inv_x0 83 82 2505 803 inv_x0
xsubckt_2128_and3_x1 83 82 2412 1038 1039 762 and3_x1
xsubckt_2145_and2_x1 83 82 1025 1028 55 and2_x1
xfeed_1060 83 82 decap_w0
xfeed_342 83 82 decap_w0
xfeed_135 83 82 tie
xsubckt_937_nand3_x0 83 82 2165 616 747 139 nand3_x0
xsubckt_649_nexor2_x0 83 82 219 239 217 nexor2_x0
xsubckt_295_or21nand_x0 83 82 556 571 565 562 or21nand_x0
xsubckt_124_and2_x1 83 82 692 693 2515 and2_x1
xsubckt_442_nand2_x0 83 82 417 616 32 nand2_x0
xsubckt_1490_nand4_x0 83 82 1624 44 93 811 812 nand4_x0
xsubckt_2060_and21nor_x0 83 82 2434 1084 1085 1090 and21nor_x0
xsubckt_2113_nand3_x0 83 82 1048 644 159 154 nand3_x0
xsubckt_2114_or21nand_x0 83 82 1047 638 84 19 or21nand_x0
xfeed_1063 83 82 decap_w0
xfeed_341 83 82 tie
xfeed_136 83 82 tie
xsubckt_1704_and2_x1 83 82 1416 1419 76 and2_x1
xfeed_1062 83 82 decap_w0
xfeed_137 83 82 tie
xsubckt_1076_nand2_x0 83 82 2029 327 35 nand2_x0
xsubckt_1059_nexor2_x0 83 82 2096 729 2045 nexor2_x0
xsubckt_917_nand3_x0 83 82 2184 41 93 812 nand3_x0
xsubckt_749_and21nor_x0 83 82 2348 168 174 177 and21nor_x0
xsubckt_1621_or21nand_x0 83 82 2460 1509 1499 1497 or21nand_x0
xsubckt_1661_and21nor_x0 83 82 1457 64 327 1458 and21nor_x0
xsubckt_1999_nand2_x0 83 82 1136 142 2506 nand2_x0
xsubckt_2426_dff_x1 83 82 2449 2564 2521 dff_x1
xfeed_1065 83 82 decap_w0
xfeed_347 83 82 tie
xfeed_130 83 82 tie
xsubckt_1106_and4_x1 83 82 1999 2140 711 712 713 and4_x1
xsubckt_593_or21nand_x0 83 82 272 276 275 273 or21nand_x0
xsubckt_1289_nand3_x0 83 82 1821 1829 1852 786 nand3_x0
xsubckt_2237_and2_x1 83 82 2402 939 953 and2_x1
xfeed_1064 83 82 decap_w0
xfeed_346 83 82 decap_w0
xfeed_131 83 82 tie
xsubckt_1184_nand2_x0 83 82 1923 1924 289 nand2_x0
xsubckt_316_nand2_x0 83 82 536 537 720 nand2_x0
xsubckt_480_or21nand_x0 83 82 382 610 383 416 or21nand_x0
xsubckt_1395_nand2_x0 83 82 1717 1718 1719 nand2_x0
xsubckt_1982_nand4_x0 83 82 1151 670 762 768 777 nand4_x0
xsubckt_2314_nand2_x0 83 82 866 868 53 nand2_x0
xfeed_1067 83 82 decap_w0
xfeed_345 83 82 decap_w0
xfeed_132 83 82 tie
xsubckt_865_or21nand_x0 83 82 2235 2287 2288 2292 or21nand_x0
xsubckt_234_nor2_x0 83 82 614 140 139 nor2_x0
xsubckt_509_and2_x1 83 82 355 701 810 and2_x1
xsubckt_628_nexor2_x0 83 82 244 31 238 nexor2_x0
xsubckt_1936_nand4_x0 83 82 1193 1194 1219 1220 1258 nand4_x0
xsubckt_2252_xor2_x0 83 82 75 76 924 xor2_x0
xfeed_1066 83 82 decap_w0
xfeed_344 83 82 tie
xfeed_133 83 82 tie
xsubckt_806_nor2_x0 83 82 2293 2294 784 nor2_x0
xsubckt_661_nand3_x0 83 82 206 46 93 812 nand3_x0
xsubckt_514_nand4_x0 83 82 350 352 353 356 607 nand4_x0
xsubckt_2262_mux2_x1 83 82 65 76 606 915 mux2_x1
xsubckt_2338_mux2_x1 83 82 747 731 606 844 mux2_x1
xfeed_1076 83 82 tie
xfeed_493 83 82 tie
xfeed_149 83 82 tie
xsubckt_1099_nand2_x0 83 82 2006 2008 2013 nand2_x0
xsubckt_74_inv_x0 83 82 47 739 inv_x0
xfeed_1077 83 82 decap_w0
xfeed_492 83 82 tie
xfeed_359 83 82 tie
xfeed_148 83 82 tie
xsubckt_1251_or2_x1 83 82 1858 55 91 or2_x1
xsubckt_590_nand2_x0 83 82 275 277 281 nand2_x0
xsubckt_1498_nand4_x0 83 82 1617 25 808 140 810 nand4_x0
xsubckt_1540_nand2_x0 83 82 2462 1576 1618 nand2_x0
xfeed_1074 83 82 decap_w0
xfeed_491 83 82 tie
xsubckt_784_nand2_x0 83 82 2314 2315 334 nand2_x0
xsubckt_731_and21nor_x0 83 82 2366 201 178 181 and21nor_x0
xsubckt_1668_or21nand_x0 83 82 1451 615 758 810 or21nand_x0
xsubckt_1772_and21nor_x0 83 82 1350 1354 1355 747 and21nor_x0
xsubckt_2207_or21nand_x0 83 82 967 988 984 985 or21nand_x0
xfeed_1075 83 82 decap_w0
xfeed_490 83 82 decap_w0
xsubckt_1023_and21nor_x0 83 82 2080 2151 2128 2150 and21nor_x0
xsubckt_818_and4_x1 83 82 2281 214 718 719 720 and4_x1
xsubckt_53_inv_x0 83 82 25 760 inv_x0
xsubckt_1892_and3_x1 83 82 1235 1237 1271 769 and3_x1
xsubckt_1899_nand3_x0 83 82 1228 1231 1232 768 nand3_x0
xsubckt_2091_mux2_x1 83 82 1063 1064 1073 2424 mux2_x1
xsubckt_2213_nand2_x0 83 82 961 77 64 nand2_x0
xfeed_1072 83 82 decap_w0
xfeed_479 83 82 decap_w0
xsubckt_967_nand3_x0 83 82 2135 40 93 812 nand3_x0
xsubckt_670_mux2_x1 83 82 788 750 699 197 mux2_x1
xsubckt_197_or21nand_x0 83 82 136 159 643 641 or21nand_x0
xsubckt_114_and2_x1 83 82 701 141 140 and2_x1
xsubckt_1288_and3_x1 83 82 1822 1829 1852 786 and3_x1
xfeed_1073 83 82 decap_w0
xfeed_496 83 82 decap_w0
xfeed_478 83 82 decap_w0
xsubckt_918_nand2_x0 83 82 2183 2184 332 nand2_x0
xsubckt_99_inv_x0 83 82 32 714 inv_x0
xsubckt_458_and2_x1 83 82 402 405 11 and2_x1
xsubckt_1369_nand3_x0 83 82 1743 1844 140 810 nand3_x0
xsubckt_1586_nand4_x0 83 82 1531 34 141 809 139 nand4_x0
xsubckt_1632_nand2_x0 83 82 1486 714 139 nand2_x0
xsubckt_2415_dff_x1 83 82 2460 2581 65 dff_x1
xfeed_1070 83 82 decap_w0
xfeed_495 83 82 tie
xsubckt_1255_or21nand_x0 83 82 1854 777 1859 1855 or21nand_x0
xsubckt_1422_nand2_x0 83 82 1691 1693 69 nand2_x0
xsubckt_2177_xor2_x0 83 82 65 66 995 xor2_x0
xsubckt_2476_dff_x1 83 82 123 2580 101 dff_x1
xsubckt_2498_dff_x1 83 82 2404 2548 46 dff_x1
xfeed_1071 83 82 decap_w0
xfeed_494 83 82 decap_w0
xsubckt_1247_or21nand_x0 83 82 1862 1864 1887 79 or21nand_x0
xsubckt_703_or3_x1 83 82 164 93 162 30 or3_x1
xsubckt_251_nand2_x0 83 82 597 602 15 nand2_x0
xsubckt_184_and2_x1 83 82 124 651 2542 and2_x1
xsubckt_440_nand2_x0 83 82 2490 419 432 nand2_x0
xsubckt_1454_mux2_x1 83 82 28 35 699 1660 mux2_x1
xsubckt_2011_nand2_x0 83 82 1125 1126 1127 nand2_x0
xsubckt_2466_dff_x1 83 82 113 2596 86 dff_x1
xfeed_475 83 82 decap_w0
xfeed_350 83 82 tie
xfeed_141 83 82 tie
xsubckt_643_nand2_x0 83 82 223 224 777 nand2_x0
xsubckt_214_nand2_x0 83 82 148 629 630 nand2_x0
xsubckt_405_nand2_x0 83 82 451 452 453 nand2_x0
xsubckt_429_mux2_x1 83 82 757 754 606 429 mux2_x1
xsubckt_445_and21nor_x0 83 82 414 428 425 427 and21nor_x0
xsubckt_1639_and21nor_x0 83 82 1479 1487 1481 1480 and21nor_x0
xsubckt_1933_nand3_x0 83 82 1195 1196 1198 762 nand3_x0
xsubckt_2102_or21nand_x0 83 82 1055 638 84 23 or21nand_x0
xsubckt_2163_nexor2_x0 83 82 1022 66 1008 nexor2_x0
xsubckt_2361_nexor2_x0 83 82 49 72 823 nexor2_x0
xfeed_474 83 82 decap_w0
xfeed_351 83 82 tie
xfeed_140 83 82 tie
xsubckt_331_nand3_x0 83 82 521 522 523 610 nand3_x0
xsubckt_1605_or21nand_x0 83 82 1512 1574 1560 1561 or21nand_x0
xsubckt_1743_nexor2_x0 83 82 1385 748 1378 nexor2_x0
xsubckt_1935_nor4_x0 83 82 1194 1201 1202 1212 1213 nor4_x0
xsubckt_2096_and2_x1 83 82 1059 2543 57 and2_x1
xsubckt_2157_and2_x1 83 82 1014 1015 54 and2_x1
xsubckt_2306_or2_x1 83 82 873 875 876 or2_x1
xfeed_499 83 82 tie
xfeed_477 83 82 decap_w0
xfeed_352 83 82 tie
xfeed_143 83 82 tie
xsubckt_1152_nand2_x0 83 82 1954 1955 289 nand2_x0
xsubckt_1383_and21nor_x0 83 82 1729 1736 603 70 and21nor_x0
xfeed_498 83 82 tie
xfeed_476 83 82 decap_w0
xfeed_142 83 82 tie
xsubckt_2066_and21nor_x0 83 82 2432 1080 1081 1090 and21nor_x0
xsubckt_2123_or21nand_x0 83 82 1041 638 84 16 or21nand_x0
xsubckt_2317_nexor2_x0 83 82 864 865 863 nexor2_x0
xsubckt_2321_or21nand_x0 83 82 859 889 874 860 or21nand_x0
xfeed_471 83 82 tie
xfeed_354 83 82 tie
xfeed_145 83 82 tie
xsubckt_1226_nand2_x0 83 82 1883 1885 373 nand2_x0
xsubckt_319_and21nor_x0 83 82 533 557 550 551 and21nor_x0
xsubckt_49_inv_x0 83 82 2543 763 inv_x0
xsubckt_324_nand2_x0 83 82 528 546 577 nand2_x0
xsubckt_495_and2_x1 83 82 369 809 139 and2_x1
xfeed_470 83 82 decap_w0
xfeed_355 83 82 tie
xfeed_144 83 82 tie
xsubckt_411_mux2_x1 83 82 758 755 606 446 mux2_x1
xsubckt_1500_mux2_x1 83 82 35 1616 373 1615 mux2_x1
xsubckt_1790_or2_x1 83 82 1332 1333 286 or2_x1
xfeed_1078 83 82 decap_w0
xfeed_473 83 82 decap_w0
xfeed_356 83 82 tie
xsubckt_1031_nand2_x0 83 82 2073 2074 2122 nand2_x0
xsubckt_939_nand4_x0 83 82 2163 76 808 140 810 nand4_x0
xsubckt_425_and21nor_x0 83 82 2491 433 434 449 and21nor_x0
xsubckt_1840_and21nor_x0 83 82 1284 72 327 1301 and21nor_x0
xsubckt_1927_and3_x1 83 82 1201 162 2521 799 and3_x1
xsubckt_2388_dff_x1 83 82 2487 2582 10 dff_x1
xfeed_1079 83 82 tie
xfeed_472 83 82 decap_w0
xfeed_357 83 82 tie
xsubckt_1299_and4_x1 83 82 1811 283 93 91 812 and4_x1
xsubckt_1910_nand3_x0 83 82 1217 1219 1220 1258 nand3_x0
xsubckt_2135_and4_x1 83 82 1033 676 677 110 91 and4_x1
xsubckt_2267_nexor2_x0 83 82 911 916 910 nexor2_x0
xfeed_624 83 82 decap_w0
xspare_feed_109 83 82 tie
xsubckt_993_and21nor_x0 83 82 2110 141 614 748 and21nor_x0
xsubckt_1885_and2_x1 83 82 1242 1243 1244 and2_x1
xfeed_625 83 82 decap_w0
xspare_feed_108 83 82 decap_w0
xsubckt_111_nand3_x0 83 82 703 808 140 810 nand3_x0
xsubckt_2081_and2_x1 83 82 1069 2543 62 and2_x1
xsubckt_2275_and21nor_x0 83 82 2400 903 904 917 and21nor_x0
xfeed_626 83 82 decap_w0
xsubckt_65_inv_x0 83 82 75 748 inv_x0
xsubckt_151_and21nor_x0 83 82 667 142 81 763 and21nor_x0
xsubckt_1508_nand3_x0 83 82 1607 1702 140 810 nand3_x0
xsubckt_1530_nand2_x0 83 82 1585 1586 290 nand2_x0
xsubckt_1596_and3_x1 83 82 1521 1523 516 65 and3_x1
xsubckt_1864_mux2_x1 83 82 1263 1275 671 1262 mux2_x1
xfeed_627 83 82 decap_w0
xsubckt_733_and2_x1 83 82 2364 214 720 and2_x1
xsubckt_565_or21nand_x0 83 82 300 302 307 323 or21nand_x0
xsubckt_2031_and21nor_x0 83 82 2439 1114 1111 1108 and21nor_x0
xfeed_620 83 82 decap_w0
xsubckt_1204_nand2_x0 83 82 1904 1905 332 nand2_x0
xsubckt_1015_nand2_x0 83 82 2088 2089 332 nand2_x0
xsubckt_173_mux2_x1 83 82 107 64 669 656 mux2_x1
xsubckt_1662_or21nand_x0 83 82 2459 1463 1459 1457 or21nand_x0
xfeed_621 83 82 decap_w0
xsubckt_1233_and2_x1 83 82 1876 1877 2212 and2_x1
xsubckt_668_and3_x1 83 82 199 614 69 141 and3_x1
xsubckt_432_nexor2_x0 83 82 430 13 426 nexor2_x0
xsubckt_1472_or21nand_x0 83 82 1642 1652 1647 1645 or21nand_x0
xfeed_622 83 82 decap_w0
xsubckt_397_and21nor_x0 83 82 459 481 477 478 and21nor_x0
xsubckt_1335_and2_x1 83 82 1776 1780 71 and2_x1
xsubckt_1717_nexor2_x0 83 82 1405 1410 1403 nexor2_x0
xfeed_623 83 82 decap_w0
xsubckt_1117_or21nand_x0 83 82 1988 2010 2009 1989 or21nand_x0
xsubckt_125_and21nor_x0 83 82 691 693 2515 2514 and21nor_x0
xsubckt_395_and2_x1 83 82 461 463 1 and2_x1
xsubckt_1324_or21nand_x0 83 82 1787 367 1795 1790 or21nand_x0
xsubckt_1338_nexor2_x0 83 82 1780 787 1773 nexor2_x0
xsubckt_1649_nand2_x0 83 82 1469 1477 751 nand2_x0
xfeed_1212 83 82 tie
xspare_feed_101 83 82 tie
xsubckt_1108_nexor2_x0 83 82 2044 711 1997 nexor2_x0
xsubckt_905_nand3_x0 83 82 2196 2201 2203 25 nand3_x0
xsubckt_100_inv_x0 83 82 13 713 inv_x0
xsubckt_1373_and2_x1 83 82 1739 1740 607 and2_x1
xsubckt_1727_and21nor_x0 83 82 1393 807 142 327 and21nor_x0
xspare_feed_100 83 82 tie
xsubckt_707_and3_x1 83 82 2390 614 68 141 and3_x1
xsubckt_28_inv_x0 83 82 27 784 inv_x0
xsubckt_1737_nand2_x0 83 82 1384 1386 447 nand2_x0
xfeed_1210 83 82 tie
xspare_feed_103 83 82 tie
xsubckt_50_inv_x0 83 82 84 81 inv_x0
xsubckt_388_and21nor_x0 83 82 467 468 469 617 and21nor_x0
xsubckt_1347_nand2_x0 83 82 1764 277 722 nand2_x0
xsubckt_2067_or21nand_x0 83 82 1079 643 159 2503 or21nand_x0
xfeed_1211 83 82 tie
xspare_feed_102 83 82 decap_w0
xsubckt_1275_and2_x1 83 82 1835 1836 1837 and2_x1
xsubckt_370_and21nor_x0 83 82 484 485 486 617 and21nor_x0
xsubckt_373_and2_x1 83 82 482 617 717 and2_x1
xsubckt_1331_mux2_x1 83 82 781 1782 607 1780 mux2_x1
xsubckt_2098_and2_x1 83 82 1058 744 151 and2_x1
xsubckt_2159_and2_x1 83 82 1012 1016 740 and2_x1
xsubckt_2226_nand2_x0 83 82 949 950 736 nand2_x0
xsubckt_2286_and21nor_x0 83 82 892 922 908 893 and21nor_x0
xfeed_628 83 82 tie
xspare_feed_105 83 82 decap_w0
xsubckt_1222_and3_x1 83 82 1887 614 779 141 and3_x1
xsubckt_1065_nand3_x0 83 82 2039 52 93 812 nand3_x0
xsubckt_966_and21nor_x0 83 82 2136 334 2141 278 and21nor_x0
xsubckt_841_nand2_x0 83 82 2259 2260 314 nand2_x0
xsubckt_203_and21nor_x0 83 82 636 80 159 84 and21nor_x0
xsubckt_1468_and21nor_x0 83 82 1646 1648 1651 1663 and21nor_x0
xsubckt_1503_nand2_x0 83 82 1612 36 141 nand2_x0
xsubckt_1984_nexor2_x0 83 82 1226 1227 1149 nexor2_x0
xsubckt_2203_mux2_x1 83 82 68 65 606 971 mux2_x1
xfeed_629 83 82 tie
xspare_feed_104 83 82 tie
xsubckt_1252_and21nor_x0 83 82 1857 91 724 764 and21nor_x0
xsubckt_1164_nor2_x0 83 82 1943 1944 754 nor2_x0
xsubckt_838_and4_x1 83 82 2262 747 808 140 139 and4_x1
xsubckt_642_nand4_x0 83 82 224 722 93 811 812 nand4_x0
xsubckt_1629_nand2_x0 83 82 1489 1657 614 nand2_x0
xsubckt_2001_nexor2_x0 83 82 692 2514 1134 nexor2_x0
xsubckt_2451_dff_x1 83 82 2427 2594 62 dff_x1
xfeed_1214 83 82 tie
xspare_feed_107 83 82 tie
xsubckt_942_nand2_x0 83 82 2160 315 810 nand2_x0
xsubckt_303_nexor2_x0 83 82 549 556 548 nexor2_x0
xsubckt_292_or21nand_x0 83 82 558 610 560 559 or21nand_x0
xsubckt_479_nexor2_x0 83 82 384 385 383 nexor2_x0
xsubckt_2210_or3_x1 83 82 964 978 993 994 or3_x1
xsubckt_2305_nexor2_x0 83 82 72 73 874 nexor2_x0
xsubckt_2418_dff_x1 83 82 2457 2583 76 dff_x1
xfeed_1215 83 82 tie
xspare_feed_106 83 82 tie
xsubckt_1196_or4_x1 83 82 1912 32 142 93 162 or4_x1
xsubckt_1049_and21nor_x0 83 82 2055 2080 2101 2105 and21nor_x0
xsubckt_844_nand2_x0 83 82 2256 2257 705 nand2_x0
xsubckt_789_nand4_x0 83 82 2309 719 93 811 812 nand4_x0
xsubckt_655_nand2_x0 83 82 212 213 335 nand2_x0
xsubckt_75_inv_x0 83 82 46 738 inv_x0
xsubckt_377_and2_x1 83 82 478 479 717 and2_x1
xsubckt_552_mux2_x1 83 82 786 752 699 313 mux2_x1
xsubckt_1391_or21nand_x0 83 82 1721 90 764 721 or21nand_x0
xsubckt_1809_or21nand_x0 83 82 1314 1348 1329 1345 or21nand_x0
xsubckt_2246_nor2_x0 83 82 930 944 958 nor2_x0
xsubckt_2505_dff_x1 83 82 2397 2574 53 dff_x1
xfeed_1025 83 82 tie
xfeed_307 83 82 decap_w0
xsubckt_941_nand3_x0 83 82 2161 614 750 141 nand3_x0
xsubckt_1419_or21nand_x0 83 82 1694 608 1695 590 or21nand_x0
xsubckt_1759_nexor2_x0 83 82 1364 1378 1362 nexor2_x0
xsubckt_1817_nand4_x0 83 82 1306 726 93 811 812 nand4_x0
xfeed_1024 83 82 tie
xfeed_306 83 82 decap_w0
xsubckt_1170_nexor2_x0 83 82 1939 1941 1937 nexor2_x0
xsubckt_964_nexor2_x0 83 82 2188 715 2138 nexor2_x0
xsubckt_15_inv_x0 83 82 2519 797 inv_x0
xsubckt_1523_nexor2_x0 83 82 1598 791 1592 nexor2_x0
xfeed_1027 83 82 tie
xfeed_529 83 82 decap_w0
xfeed_305 83 82 decap_w0
xsubckt_1262_nand4_x0 83 82 1848 761 808 140 139 nand4_x0
xsubckt_1148_nand3_x0 83 82 1958 50 93 812 nand3_x0
xsubckt_1412_nand3_x0 83 82 1701 1703 809 139 nand3_x0
xsubckt_2258_and21nor_x0 83 82 918 931 609 617 and21nor_x0
xsubckt_2342_and21nor_x0 83 82 840 854 851 850 and21nor_x0
xfeed_1026 83 82 tie
xfeed_528 83 82 decap_w0
xfeed_304 83 82 decap_w0
xsubckt_108_and2_x1 83 82 706 140 810 and2_x1
xsubckt_381_and21nor_x0 83 82 474 476 481 610 and21nor_x0
xsubckt_1609_nand2_x0 83 82 1508 2187 341 nand2_x0
xsubckt_1700_nand2_x0 83 82 1420 1486 607 nand2_x0
xfeed_1021 83 82 decap_w0
xfeed_303 83 82 decap_w0
xsubckt_85_inv_x0 83 82 51 728 inv_x0
xsubckt_132_and2_x1 83 82 684 685 794 and2_x1
xsubckt_492_nand2_x0 83 82 372 140 139 nand2_x0
xsubckt_548_or21nand_x0 83 82 317 369 320 321 or21nand_x0
xsubckt_1785_or21nand_x0 83 82 1337 335 1338 332 or21nand_x0
xsubckt_1903_and21nor_x0 83 82 1224 1236 1225 1235 and21nor_x0
xfeed_1020 83 82 tie
xfeed_302 83 82 decap_w0
xsubckt_1220_and2_x1 83 82 2469 1889 1912 and2_x1
xsubckt_884_or21nand_x0 83 82 2477 2220 2219 2217 or21nand_x0
xsubckt_853_and3_x1 83 82 2247 2252 2264 26 and3_x1
xsubckt_439_or21nand_x0 83 82 419 610 424 420 or21nand_x0
xsubckt_477_xor2_x0 83 82 9 32 385 xor2_x0
xsubckt_2392_dff_x1 83 82 2483 2561 38 dff_x1
xfeed_1179 83 82 tie
xfeed_1023 83 82 tie
xfeed_301 83 82 tie
xsubckt_1037_nand4_x0 83 82 2067 747 808 140 810 nand4_x0
xsubckt_850_nand2_x0 83 82 2250 2252 2264 nand2_x0
xsubckt_693_nand3_x0 83 82 174 183 198 781 nand3_x0
xsubckt_281_and3_x1 83 82 569 614 784 141 and3_x1
xsubckt_61_inv_x0 83 82 65 752 inv_x0
xsubckt_1286_and21nor_x0 83 82 1824 1829 1852 786 and21nor_x0
xsubckt_1425_nexor2_x0 83 82 1694 69 1688 nexor2_x0
xsubckt_2380_dff_x1 83 82 2495 2554 4 dff_x1
xfeed_1178 83 82 tie
xfeed_1022 83 82 tie
xfeed_959 83 82 tie
xfeed_300 83 82 tie
xsubckt_1165_and2_x1 83 82 1942 1944 33 and2_x1
xsubckt_93_inv_x0 83 82 5 720 inv_x0
xsubckt_1986_mux2_x1 83 82 1148 1149 670 1147 mux2_x1
xfeed_1177 83 82 tie
xfeed_956 83 82 tie
xfeed_523 83 82 tie
xfeed_97 83 82 tie
xsubckt_842_and2_x1 83 82 2258 2259 2261 and2_x1
xsubckt_1409_and2_x1 83 82 1704 1705 366 and2_x1
xsubckt_1607_nexor2_x0 83 82 1512 1516 1510 nexor2_x0
xsubckt_1745_and21nor_x0 83 82 1376 1409 1415 1418 and21nor_x0
xfeed_1176 83 82 decap_w0
xfeed_522 83 82 tie
xfeed_96 83 82 decap_w0
xsubckt_1915_and3_x1 83 82 1212 162 2522 799 and3_x1
xsubckt_1962_nand2_x0 83 82 1168 1169 1171 nand2_x0
xsubckt_2089_and2_x1 83 82 1064 744 154 and2_x1
xsubckt_2264_nand2_x0 83 82 913 914 734 nand2_x0
xfeed_1175 83 82 decap_w0
xfeed_954 83 82 tie
xfeed_521 83 82 decap_w0
xfeed_95 83 82 decap_w0
xsubckt_667_or21nand_x0 83 82 200 237 238 242 or21nand_x0
xsubckt_1869_nexor2_x0 83 82 286 774 1258 nexor2_x0
xfeed_1174 83 82 decap_w0
xfeed_955 83 82 tie
xfeed_520 83 82 decap_w0
xfeed_94 83 82 tie
xsubckt_2192_or21nand_x0 83 82 981 993 994 996 or21nand_x0
xfeed_1173 83 82 decap_w0
xfeed_1029 83 82 decap_w0
xfeed_952 83 82 tie
xfeed_527 83 82 decap_w0
xfeed_93 83 82 tie
xsubckt_265_nand2_x0 83 82 584 588 723 nand2_x0
xsubckt_464_and2_x1 83 82 397 617 710 and2_x1
xsubckt_583_nexor2_x0 83 82 14 15 282 nexor2_x0
xsubckt_1635_and3_x1 83 82 1483 616 755 139 and3_x1
xsubckt_1671_nor2_x0 83 82 1448 1449 750 nor2_x0
xsubckt_1873_and21nor_x0 83 82 1254 799 162 611 and21nor_x0
xsubckt_2370_nand3_x0 83 82 815 819 825 725 nand3_x0
xsubckt_2430_dff_x1 83 82 2445 2564 2517 dff_x1
xfeed_1172 83 82 tie
xfeed_1028 83 82 tie
xfeed_953 83 82 tie
xfeed_526 83 82 decap_w0
xfeed_92 83 82 tie
xsubckt_1130_or2_x1 83 82 1976 1980 755 or2_x1
xsubckt_1058_or21nand_x0 83 82 2046 53 2142 52 or21nand_x0
xsubckt_305_nand2_x0 83 82 546 24 25 nand2_x0
xsubckt_1467_nand2_x0 83 82 1647 1649 1650 nand2_x0
xsubckt_1475_nand3_x0 83 82 1639 1642 568 68 nand3_x0
xsubckt_2202_mux2_x1 83 82 790 752 606 972 mux2_x1
xfeed_1171 83 82 tie
xfeed_950 83 82 decap_w0
xfeed_525 83 82 decap_w0
xfeed_309 83 82 tie
xfeed_91 83 82 tie
xsubckt_1185_or21nand_x0 83 82 1922 1923 1925 285 or21nand_x0
xsubckt_639_nand3_x0 83 82 227 47 93 812 nand3_x0
xsubckt_2188_nand2_x0 83 82 985 987 738 nand2_x0
xsubckt_2432_dff_x1 83 82 2443 2588 2515 dff_x1
xfeed_1170 83 82 tie
xfeed_951 83 82 tie
xfeed_524 83 82 decap_w0
xfeed_308 83 82 tie
xfeed_90 83 82 tie
xsubckt_1175_and3_x1 83 82 1932 1999 709 710 and3_x1
xsubckt_1146_nand2_x0 83 82 1960 1961 335 nand2_x0
xsubckt_1121_nand3_x0 83 82 1985 614 73 141 nand3_x0
xsubckt_39_inv_x0 83 82 2511 773 inv_x0
xsubckt_122_nor3_x0 83 82 694 2516 2524 2523 nor3_x0
xsubckt_427_nand3_x0 83 82 431 614 754 141 nand3_x0
xsubckt_618_nor3_x0 83 82 248 249 250 608 nor3_x0
xfeed_736 83 82 tie
xspare_feed_39 83 82 tie
xsubckt_647_and21nor_x0 83 82 219 347 295 299 and21nor_x0
xsubckt_1309_nand2_x0 83 82 1801 1802 762 nand2_x0
xsubckt_1536_and21nor_x0 83 82 1579 1583 1582 1580 and21nor_x0
xsubckt_1975_and2_x1 83 82 2446 1157 1159 and2_x1
xsubckt_2049_mux2_x1 83 82 2509 1092 1279 2437 mux2_x1
xfeed_737 83 82 tie
xspare_feed_38 83 82 tie
xsubckt_741_nand2_x0 83 82 2356 2357 332 nand2_x0
xsubckt_73_inv_x0 83 82 54 740 inv_x0
xsubckt_127_and21nor_x0 83 82 689 691 771 772 and21nor_x0
xsubckt_524_nand2_x0 83 82 340 93 812 nand2_x0
xsubckt_1755_or2_x1 83 82 1366 1367 286 or2_x1
xsubckt_2447_dff_x1 83 82 2431 2590 2503 dff_x1
xfeed_735 83 82 tie
xsubckt_258_and2_x1 83 82 2500 591 599 and2_x1
xsubckt_97_inv_x0 83 82 1 716 inv_x0
xsubckt_525_nor2_x0 83 82 339 93 162 nor2_x0
xsubckt_530_nand2_x0 83 82 334 343 811 nand2_x0
xsubckt_1801_nor2_x0 83 82 1322 1323 746 nor2_x0
xfeed_732 83 82 tie
xsubckt_833_and2_x1 83 82 2266 2267 286 and2_x1
xsubckt_562_and3_x1 83 82 303 304 305 607 and3_x1
xsubckt_1576_and21nor_x0 83 82 1540 1542 1554 285 and21nor_x0
xsubckt_2328_mux2_x1 83 82 75 72 606 853 mux2_x1
xsubckt_1085_nand2_x0 83 82 2020 2021 2023 nand2_x0
xsubckt_227_nand3_x0 83 82 620 94 85 86 nand3_x0
xsubckt_612_nand3_x0 83 82 254 256 258 361 nand3_x0
xsubckt_2268_nand2_x0 83 82 909 74 75 nand2_x0
xfeed_730 83 82 decap_w0
xfeed_208 83 82 tie
xsubckt_1232_nand3_x0 83 82 1877 1879 809 139 nand3_x0
xsubckt_1007_and2_x1 83 82 2096 2143 730 and2_x1
xsubckt_296_and3_x1 83 82 555 614 761 141 and3_x1
xsubckt_1636_and4_x1 83 82 1482 754 141 809 139 and4_x1
xfeed_731 83 82 decap_w0
xfeed_209 83 82 tie
xsubckt_1095_and2_x1 83 82 2010 2012 2014 and2_x1
xsubckt_80_inv_x0 83 82 41 733 inv_x0
xsubckt_416_or2_x1 83 82 441 442 448 or2_x1
xsubckt_558_and21nor_x0 83 82 307 317 311 308 and21nor_x0
xsubckt_1446_nand3_x0 83 82 1667 1668 1677 1682 nand3_x0
xsubckt_2035_nand4_x0 83 82 1104 1105 676 677 110 nand4_x0
xsubckt_2109_and21nor_x0 83 82 2418 1051 1052 763 and21nor_x0
xfeed_206 83 82 tie
xspare_feed_31 83 82 tie
xsubckt_990_and2_x1 83 82 2113 2114 354 and2_x1
xsubckt_914_nexor2_x0 83 82 2229 716 2187 nexor2_x0
xsubckt_154_and2_x1 83 82 123 666 2537 and2_x1
xsubckt_1811_nand2_x0 83 82 1312 1314 1319 nand2_x0
xsubckt_2013_nexor2_x0 83 82 1222 1249 1124 nexor2_x0
xfeed_207 83 82 tie
xspare_feed_30 83 82 tie
xsubckt_970_nand4_x0 83 82 2132 715 93 811 812 nand4_x0
xsubckt_168_and2_x1 83 82 116 659 2543 and2_x1
xsubckt_450_nexor2_x0 83 82 413 712 409 nexor2_x0
xsubckt_2165_and21nor_x0 83 82 1006 609 1009 1007 and21nor_x0
xfeed_204 83 82 tie
xspare_feed_33 83 82 tie
xsubckt_198_nand3_x0 83 82 640 160 80 81 nand3_x0
xsubckt_1512_or21nand_x0 83 82 1603 2211 1609 1606 or21nand_x0
xsubckt_1844_or21nand_x0 83 82 1281 1283 671 2524 or21nand_x0
xsubckt_1851_xor2_x0 83 82 2524 2523 1275 xor2_x0
xsubckt_1963_and21nor_x0 83 82 2447 1204 1173 1168 and21nor_x0
xsubckt_2244_nexor2_x0 83 82 936 735 932 nexor2_x0
xfeed_205 83 82 tie
xspare_feed_32 83 82 tie
xsubckt_860_and21nor_x0 83 82 2240 2268 2288 2291 and21nor_x0
xsubckt_2480_dff_x1 83 82 119 2579 97 dff_x1
xfeed_202 83 82 tie
xspare_feed_35 83 82 tie
xsubckt_1265_and2_x1 83 82 1845 27 141 and2_x1
xsubckt_1034_and2_x1 83 82 2070 2071 2073 and2_x1
xsubckt_580_nand2_x0 83 82 285 162 799 nand2_x0
xsubckt_1548_and2_x1 83 82 1568 1569 1570 and2_x1
xsubckt_2173_nand2_x0 83 82 999 1001 47 nand2_x0
xspare_feed_34 83 82 tie
xsubckt_1160_and21nor_x0 83 82 1946 34 327 1947 and21nor_x0
xsubckt_1122_nand2_x0 83 82 1984 698 747 nand2_x0
xsubckt_1120_or21nand_x0 83 82 2472 1986 1987 2029 or21nand_x0
xsubckt_974_and21nor_x0 83 82 2128 2175 2194 2197 and21nor_x0
xsubckt_807_or2_x1 83 82 2292 2294 784 or2_x1
xsubckt_704_and2_x1 83 82 163 164 762 and2_x1
xsubckt_169_mux2_x1 83 82 109 66 669 658 mux2_x1
xsubckt_1476_and21nor_x0 83 82 1638 1642 568 790 and21nor_x0
xsubckt_1956_nexor2_x0 83 82 286 797 1174 nexor2_x0
xfeed_738 83 82 tie
xfeed_200 83 82 decap_w0
xspare_feed_37 83 82 tie
xsubckt_1192_nand2_x0 83 82 1915 142 16 nand2_x0
xsubckt_968_nand2_x0 83 82 2134 2135 332 nand2_x0
xsubckt_304_or21nand_x0 83 82 547 573 576 577 or21nand_x0
xsubckt_1747_and21nor_x0 83 82 1374 1376 1379 289 and21nor_x0
xsubckt_1839_or21nand_x0 83 82 1285 1286 1287 265 or21nand_x0
xfeed_739 83 82 decap_w0
xfeed_201 83 82 decap_w0
xspare_feed_36 83 82 tie
xsubckt_1650_nor2_x0 83 82 1468 1474 1476 nor2_x0
xsubckt_2176_nand2_x0 83 82 996 65 66 nand2_x0
xfeed_703 83 82 tie
xsubckt_1259_mux2_x1 83 82 779 760 699 1851 mux2_x1
xsubckt_1235_and21nor_x0 83 82 1874 1883 1881 1875 and21nor_x0
xsubckt_529_and2_x1 83 82 335 343 811 and2_x1
xsubckt_2022_nexor2_x0 83 82 286 773 1116 nexor2_x0
xsubckt_2401_dff_x1 83 82 2474 2593 37 dff_x1
xsubckt_2508_dff_x1 83 82 2394 2578 50 dff_x1
xfeed_702 83 82 tie
xsubckt_1260_and2_x1 83 82 1850 1851 373 and2_x1
xsubckt_857_and3_x1 83 82 2243 2252 2264 761 and3_x1
xsubckt_722_nand3_x0 83 82 2375 2377 2386 607 nand3_x0
xsubckt_1303_or2_x1 83 82 1807 1808 1816 or2_x1
xsubckt_1897_and2_x1 83 82 1230 1231 1232 and2_x1
xsubckt_2149_xor2_x0 83 82 68 67 1021 xor2_x0
xsubckt_2433_dff_x1 83 82 2442 2588 2514 dff_x1
xfeed_701 83 82 tie
xfeed_239 83 82 tie
xsubckt_2186_mux2_x1 83 82 789 753 606 987 mux2_x1
xspare_feed_24 83 82 tie
xfeed_700 83 82 decap_w0
xfeed_238 83 82 decap_w0
xsubckt_1069_nand2_x0 83 82 2035 2036 289 nand2_x0
xsubckt_1024_nexor2_x0 83 82 2081 2100 2079 nexor2_x0
xsubckt_795_and2_x1 83 82 2303 2304 286 and2_x1
xsubckt_1371_nand2_x0 83 82 1741 1743 1744 nand2_x0
xsubckt_1506_mux2_x1 83 82 36 1615 366 1609 mux2_x1
xsubckt_1595_nand2_x0 83 82 1522 1523 516 nand2_x0
xsubckt_1788_nand2_x0 83 82 1334 1335 289 nand2_x0
xsubckt_2330_nand2_x0 83 82 851 852 729 nand2_x0
xfeed_707 83 82 decap_w0
xsubckt_1125_or21nand_x0 83 82 1981 72 360 607 or21nand_x0
xsubckt_989_nand3_x0 83 82 2114 616 746 139 nand3_x0
xsubckt_931_and21nor_x0 83 82 2170 2177 2173 2171 and21nor_x0
xsubckt_859_nexor2_x0 83 82 2251 761 2241 nexor2_x0
xsubckt_294_and21nor_x0 83 82 557 570 564 563 and21nor_x0
xsubckt_586_xor2_x0 83 82 54 55 279 xor2_x0
xsubckt_629_and21nor_x0 83 82 237 292 294 297 and21nor_x0
xsubckt_2115_and21nor_x0 83 82 2416 1047 1048 763 and21nor_x0
xspare_feed_22 83 82 tie
xfeed_706 83 82 decap_w0
xsubckt_1050_or21nand_x0 83 82 2054 2081 2100 2104 or21nand_x0
xsubckt_1479_nexor2_x0 83 82 1641 790 1635 nexor2_x0
xsubckt_1941_nexor2_x0 83 82 286 796 1188 nexor2_x0
xsubckt_2315_nexor2_x0 83 82 869 730 865 nexor2_x0
xspare_feed_23 83 82 tie
xfeed_705 83 82 tie
xsubckt_793_or21nand_x0 83 82 2305 2348 2369 2370 or21nand_x0
xsubckt_674_and3_x1 83 82 193 194 196 361 and3_x1
xsubckt_633_nexor2_x0 83 82 284 722 233 nexor2_x0
xsubckt_2006_nexor2_x0 83 82 1131 1223 1130 nexor2_x0
xspare_feed_20 83 82 tie
xfeed_704 83 82 tie
xsubckt_2026_nand4_x0 83 82 1112 1113 676 677 110 nand4_x0
xspare_feed_21 83 82 tie
xfeed_233 83 82 tie
xsubckt_1033_or21nand_x0 83 82 2071 139 700 2072 or21nand_x0
xsubckt_892_nand2_x0 83 82 2209 2210 2212 nand2_x0
xsubckt_517_and21nor_x0 83 82 347 348 375 778 and21nor_x0
xsubckt_1546_nand3_x0 83 82 1570 1656 140 810 nand3_x0
xsubckt_2434_dff_x1 83 82 2441 2570 2513 dff_x1
xsubckt_1229_nand2_x0 83 82 1880 1882 366 nand2_x0
xsubckt_716_nand2_x0 83 82 2381 2383 139 nand2_x0
xsubckt_37_inv_x0 83 82 2509 775 inv_x0
xsubckt_1616_and21nor_x0 83 82 1501 1508 1504 1502 and21nor_x0
xfeed_709 83 82 decap_w0
xfeed_231 83 82 tie
xsubckt_866_nexor2_x0 83 82 2236 2241 2234 nexor2_x0
xsubckt_252_or21nand_x0 83 82 596 724 601 609 or21nand_x0
xsubckt_354_and2_x1 83 82 2495 500 518 and2_x1
xsubckt_1611_nand2_x0 83 82 1506 1507 334 nand2_x0
xsubckt_2494_dff_x1 83 82 2408 2551 90 dff_x1
xfeed_708 83 82 decap_w0
xsubckt_1052_or21nand_x0 83 82 2052 2054 2056 286 or21nand_x0
xsubckt_310_mux2_x1 83 82 6 542 618 2497 mux2_x1
xsubckt_22_inv_x0 83 82 68 790 inv_x0
xsubckt_2312_mux2_x1 83 82 76 73 606 868 mux2_x1
xsubckt_2362_and2_x1 83 82 822 833 836 and2_x1
xfeed_237 83 82 decap_w0
xsubckt_1274_nand3_x0 83 82 1836 616 783 139 nand3_x0
xsubckt_1224_mux2_x1 83 82 778 761 699 1885 mux2_x1
xsubckt_1046_and21nor_x0 83 82 2058 2066 2069 36 and21nor_x0
xsubckt_907_nexor2_x0 83 82 2200 25 2194 nexor2_x0
xsubckt_705_and2_x1 83 82 2481 163 165 and2_x1
xsubckt_597_nand2_x0 83 82 268 269 285 nand2_x0
xsubckt_1438_and2_x1 83 82 1675 2361 335 and2_x1
xsubckt_2146_nand2_x0 83 82 1024 1028 55 nand2_x0
xfeed_236 83 82 decap_w0
xsubckt_880_and21nor_x0 83 82 2220 290 2234 2221 and21nor_x0
xsubckt_128_and2_x1 83 82 688 689 2511 and2_x1
xsubckt_1386_nand2_x0 83 82 1726 1732 1734 nand2_x0
xsubckt_2510_dff_x1 83 82 2392 2578 48 dff_x1
xfeed_235 83 82 decap_w0
xspare_feed_28 83 82 tie
xsubckt_249_nand2_x0 83 82 599 600 724 nand2_x0
xsubckt_551_nand2_x0 83 82 314 315 139 nand2_x0
xsubckt_1329_and21nor_x0 83 82 1782 1784 1787 1799 and21nor_x0
xsubckt_1416_nand3_x0 83 82 1697 1792 140 810 nand3_x0
xsubckt_1581_nand2_x0 83 82 2461 1536 1538 nand2_x0
xsubckt_2290_and21nor_x0 83 82 888 890 892 609 and21nor_x0
xfeed_234 83 82 decap_w0
xspare_feed_29 83 82 tie
xsubckt_781_and3_x1 83 82 2317 211 736 737 and3_x1
xsubckt_13_inv_x0 83 82 2517 799 inv_x0
xsubckt_571_nexor2_x0 83 82 301 779 294 nexor2_x0
xsubckt_632_nor3_x0 83 82 234 7 14 15 nor3_x0
xsubckt_1345_nexor2_x0 83 82 1768 1773 1766 nexor2_x0
xsubckt_2112_and21nor_x0 83 82 2417 1049 1050 763 and21nor_x0
xsubckt_2366_nand3_x0 83 82 818 821 823 831 nand3_x0
xfeed_871 83 82 tie
xfeed_567 83 82 tie
xspare_buffer_42 83 82 2584 2578 buf_x4
xsubckt_1131_and2_x1 83 82 1975 1980 34 and2_x1
xsubckt_1110_and21nor_x0 83 82 1995 334 2000 278 and21nor_x0
xsubckt_822_nand3_x0 83 82 2277 43 93 812 nand3_x0
xsubckt_657_nexor2_x0 83 82 232 46 210 nexor2_x0
xsubckt_656_nor4_x0 83 82 211 46 47 54 55 nor4_x0
xsubckt_415_nexor2_x0 83 82 446 715 442 nexor2_x0
xsubckt_1323_and21nor_x0 83 82 1788 366 1794 1789 and21nor_x0
xsubckt_1562_and2_x1 83 82 1554 1559 1561 and2_x1
xsubckt_2080_and2_x1 83 82 1070 744 157 and2_x1
xfeed_870 83 82 tie
xfeed_566 83 82 tie
xspare_buffer_43 83 82 2539 2537 buf_x4
xsubckt_378_nand2_x0 83 82 477 480 2 nand2_x0
xsubckt_1311_nand2_x0 83 82 1800 327 71 nand2_x0
xsubckt_2152_nand2_x0 83 82 1018 1019 1023 nand2_x0
xfeed_873 83 82 tie
xfeed_565 83 82 tie
xfeed_59 83 82 tie
xspare_buffer_40 83 82 2584 2580 buf_x4
xsubckt_1142_nexor2_x0 83 82 2003 727 1964 nexor2_x0
xsubckt_775_or21nand_x0 83 82 2323 2367 2368 2372 or21nand_x0
xsubckt_1541_and21nor_x0 83 82 1575 1587 1593 1597 and21nor_x0
xsubckt_1854_and2_x1 83 82 1272 2122 285 and2_x1
xsubckt_2052_and3_x1 83 82 1089 644 744 800 and3_x1
xfeed_919 83 82 tie
xfeed_564 83 82 tie
xspare_buffer_41 83 82 2584 2579 buf_x4
xsubckt_1100_and21nor_x0 83 82 2005 2007 2014 289 and21nor_x0
xsubckt_782_nexor2_x0 83 82 2362 44 2316 nexor2_x0
xsubckt_117_nand3_x0 83 82 698 141 140 139 nand3_x0
xsubckt_1630_nand2_x0 83 82 1488 756 141 nand2_x0
xfeed_875 83 82 tie
xfeed_563 83 82 tie
xspare_buffer_46 83 82 2584 2575 buf_x4
xsubckt_725_nand3_x0 83 82 2372 2375 2389 29 nand3_x0
xsubckt_139_or21nand_x0 83 82 677 679 2518 2517 or21nand_x0
xsubckt_1411_nand2_x0 83 82 1702 24 141 nand2_x0
xsubckt_1488_mux2_x1 83 82 1627 2316 335 1626 mux2_x1
xsubckt_1648_and21nor_x0 83 82 1470 1478 1489 64 and21nor_x0
xsubckt_1866_nand4_x0 83 82 1261 670 762 777 2522 nand4_x0
xsubckt_2106_and21nor_x0 83 82 2419 1053 1054 763 and21nor_x0
xsubckt_2214_xor2_x0 83 82 77 64 960 xor2_x0
xsubckt_2371_and3_x1 83 82 814 815 816 609 and3_x1
xfeed_874 83 82 tie
xfeed_562 83 82 tie
xspare_buffer_47 83 82 2539 2536 buf_x4
xsubckt_1101_and2_x1 83 82 2004 2005 2006 and2_x1
xsubckt_1043_or21nand_x0 83 82 2061 2065 2070 36 or21nand_x0
xsubckt_2092_and2_x1 83 82 1062 744 153 and2_x1
xsubckt_2153_and2_x1 83 82 2407 1018 1026 and2_x1
xsubckt_2473_dff_x1 83 82 126 2580 104 dff_x1
xfeed_877 83 82 tie
xfeed_561 83 82 tie
xspare_buffer_44 83 82 2584 2577 buf_x4
xsubckt_1216_nexor2_x0 83 82 1893 1897 1892 nexor2_x0
xsubckt_431_and2_x1 83 82 427 430 13 and2_x1
xsubckt_1435_nand2_x0 83 82 1678 1680 1688 nand2_x0
xsubckt_2193_nand2_x0 83 82 980 64 65 nand2_x0
xfeed_876 83 82 tie
xfeed_560 83 82 tie
xspare_buffer_45 83 82 2584 2576 buf_x4
xsubckt_826_nand2_x0 83 82 2273 2274 289 nand2_x0
xsubckt_323_or21nand_x0 83 82 529 26 24 25 or21nand_x0
xsubckt_2053_and21nor_x0 83 82 1088 644 744 2508 and21nor_x0
xfeed_912 83 82 tie
xfeed_879 83 82 decap_w0
xfeed_53 83 82 decap_w0
xsubckt_1190_or21nand_x0 83 82 1917 285 1918 265 or21nand_x0
xsubckt_355_nand2_x0 83 82 499 617 718 nand2_x0
xfeed_913 83 82 tie
xfeed_878 83 82 decap_w0
xfeed_52 83 82 decap_w0
xsubckt_2136_nand4_x0 83 82 1032 676 677 110 91 nand4_x0
xfeed_910 83 82 tie
xfeed_51 83 82 tie
xspare_buffer_48 83 82 2584 2574 buf_x4
xsubckt_1306_nand3_x0 83 82 1804 1805 1806 286 nand3_x0
xfeed_911 83 82 tie
xfeed_50 83 82 tie
xspare_buffer_49 83 82 2584 2573 buf_x4
xsubckt_1585_and4_x1 83 82 1532 1533 1534 1535 366 and4_x1
xfeed_57 83 82 tie
xsubckt_1166_nexor2_x0 83 82 1944 33 1941 nexor2_x0
xfeed_917 83 82 decap_w0
xfeed_56 83 82 tie
xsubckt_103_inv_x0 83 82 10 710 inv_x0
xsubckt_1736_and2_x1 83 82 1385 1386 447 and2_x1
xsubckt_1948_mux2_x1 83 82 162 1182 671 1181 mux2_x1
xsubckt_2503_dff_x1 83 82 2399 2574 41 dff_x1
xfeed_914 83 82 tie
xfeed_569 83 82 decap_w0
xfeed_55 83 82 tie
xsubckt_1004_or21nand_x0 83 82 2099 2145 2154 2155 or21nand_x0
xsubckt_325_and2_x1 83 82 527 37 24 and2_x1
xsubckt_515_and21nor_x0 83 82 349 362 358 350 and21nor_x0
xsubckt_1642_and3_x1 83 82 1476 1478 1489 751 and3_x1
xfeed_915 83 82 tie
xfeed_54 83 82 tie
xsubckt_1002_nexor2_x0 83 82 2106 37 2101 nexor2_x0
xsubckt_922_or2_x1 83 82 2179 2180 2182 or2_x1
xsubckt_107_and21nor_x0 83 82 114 764 707 763 and21nor_x0
xsubckt_566_and2_x1 83 82 299 300 38 and2_x1
xsubckt_1464_nand3_x0 83 82 1650 616 759 139 nand3_x0
xsubckt_1603_and21nor_x0 83 82 1514 1557 1543 1556 and21nor_x0
xsubckt_1733_nand4_x0 83 82 1388 754 808 140 810 nand4_x0
xdiode_7 83 82 617 diode_w1
xspare_feed_75 83 82 tie
xsubckt_1257_and3_x1 83 82 1853 614 780 141 and3_x1
xsubckt_1102_and4_x1 83 82 2003 2143 728 729 730 and4_x1
xsubckt_1086_or21nand_x0 83 82 2019 2020 2024 2028 or21nand_x0
xsubckt_399_nand2_x0 83 82 457 471 489 nand2_x0
xsubckt_1408_nand4_x0 83 82 1705 758 808 140 139 nand4_x0
xsubckt_2285_nand2_x0 83 82 893 909 925 nand2_x0
xdiode_6 83 82 617 diode_w1
xfeed_773 83 82 tie
xspare_feed_74 83 82 tie
xsubckt_894_nand3_x0 83 82 2207 2383 140 810 nand3_x0
xsubckt_869_nexor2_x0 83 82 2284 734 2231 nexor2_x0
xsubckt_689_nand3_x0 83 82 178 183 198 30 nand3_x0
xsubckt_1578_nand3_x0 83 82 1538 1539 1544 265 nand3_x0
xdiode_5 83 82 617 diode_w1
xfeed_770 83 82 tie
xfeed_248 83 82 tie
xspare_feed_77 83 82 tie
xsubckt_308_nand2_x0 83 82 543 544 610 nand2_x0
xsubckt_222_nand3_x0 83 82 623 104 85 767 nand3_x0
xsubckt_153_mux2_x1 83 82 101 26 669 666 mux2_x1
xsubckt_2062_nand3_x0 83 82 1082 644 744 155 nand3_x0
xdiode_4 83 82 617 diode_w1
xfeed_771 83 82 tie
xfeed_249 83 82 decap_w0
xspare_feed_76 83 82 tie
xsubckt_2194_xor2_x0 83 82 64 65 979 xor2_x0
xdiode_3 83 82 614 diode_w1
xfeed_776 83 82 decap_w0
xspare_feed_71 83 82 tie
xsubckt_954_nexor2_x0 83 82 2157 759 2148 nexor2_x0
xsubckt_359_nand2_x0 83 82 495 496 718 nand2_x0
xsubckt_2405_dff_x1 83 82 2470 2595 33 dff_x1
xdiode_2 83 82 614 diode_w1
xfeed_777 83 82 decap_w0
xspare_feed_70 83 82 tie
xsubckt_1062_nexor2_x0 83 82 2094 712 2042 nexor2_x0
xsubckt_771_or2_x1 83 82 2327 2331 783 or2_x1
xsubckt_721_and3_x1 83 82 2376 2377 2386 607 and3_x1
xsubckt_2074_nand3_x0 83 82 1074 644 744 151 nand3_x0
xdiode_1 83 82 614 diode_w1
xfeed_774 83 82 tie
xfeed_428 83 82 decap_w0
xspare_feed_73 83 82 tie
xsubckt_991_or21nand_x0 83 82 2112 2117 2115 2113 or21nand_x0
xsubckt_757_nand2_x0 83 82 2341 2342 314 nand2_x0
xsubckt_1643_nand3_x0 83 82 1475 1478 1489 751 nand3_x0
xsubckt_2004_nand3_x0 83 82 2442 1132 1136 1137 nand3_x0
xdiode_0 83 82 614 diode_w1
xfeed_775 83 82 tie
xfeed_429 83 82 decap_w0
xspare_feed_72 83 82 tie
xsubckt_1547_nand3_x0 83 82 1569 616 757 139 nand3_x0
xsubckt_1816_and21nor_x0 83 82 1307 278 1931 1308 and21nor_x0
xsubckt_2158_nand2_x0 83 82 1013 1015 54 nand2_x0
xsubckt_2284_nand2_x0 83 82 894 895 609 nand2_x0
xfeed_426 83 82 tie
xfeed_242 83 82 tie
xsubckt_890_mux2_x1 83 82 616 701 810 2211 mux2_x1
xsubckt_228_nand3_x0 83 82 619 102 85 767 nand3_x0
xsubckt_463_and21nor_x0 83 82 2488 416 398 406 and21nor_x0
xsubckt_1495_nand2_x0 83 82 1619 1620 1628 nand2_x0
xsubckt_1683_and2_x1 83 82 1436 1437 290 and2_x1
xsubckt_1983_nand2_x0 83 82 1150 142 801 nand2_x0
xsubckt_2061_or21nand_x0 83 82 1083 643 159 2505 or21nand_x0
xsubckt_2068_nand3_x0 83 82 1078 644 744 153 nand3_x0
xsubckt_2072_and21nor_x0 83 82 2430 1076 1077 1090 and21nor_x0
xsubckt_2249_nand2_x0 83 82 927 945 961 nand2_x0
xfeed_427 83 82 decap_w0
xfeed_243 83 82 decap_w0
xsubckt_839_or21nand_x0 83 82 2261 369 2262 2263 or21nand_x0
xsubckt_507_nand2_x0 83 82 357 359 360 nand2_x0
xsubckt_1539_nand2_x0 83 82 1576 1577 1585 nand2_x0
xsubckt_1762_and21nor_x0 83 82 1359 75 327 1360 and21nor_x0
xsubckt_1906_and21nor_x0 83 82 1221 1222 1250 1251 and21nor_x0
xsubckt_2198_and21nor_x0 83 82 975 976 977 617 and21nor_x0
xsubckt_2464_dff_x1 83 82 2414 2594 17 dff_x1
xfeed_778 83 82 decap_w0
xfeed_424 83 82 decap_w0
xfeed_240 83 82 tie
xsubckt_1462_and21nor_x0 83 82 1652 366 1658 1653 and21nor_x0
xsubckt_2117_or21nand_x0 83 82 1045 638 84 18 or21nand_x0
xsubckt_2355_or21nand_x0 83 82 828 610 829 855 or21nand_x0
xfeed_779 83 82 decap_w0
xfeed_425 83 82 decap_w0
xfeed_241 83 82 decap_w0
xsubckt_874_nand3_x0 83 82 2226 42 93 812 nand3_x0
xsubckt_389_and21nor_x0 83 82 2493 467 473 482 and21nor_x0
xsubckt_1625_nand4_x0 83 82 1493 40 93 811 812 nand4_x0
xfeed_422 83 82 decap_w0
xfeed_246 83 82 tie
xspare_feed_79 83 82 tie
xsubckt_896_nand2_x0 83 82 2205 2206 2207 nand2_x0
xsubckt_878_nand2_x0 83 82 2222 2223 289 nand2_x0
xfeed_423 83 82 decap_w0
xfeed_247 83 82 tie
xspare_feed_78 83 82 tie
xsubckt_709_mux2_x1 83 82 65 64 141 2388 mux2_x1
xsubckt_257_nand2_x0 83 82 591 592 596 nand2_x0
xsubckt_245_nand3_x0 83 82 603 614 782 141 nand3_x0
xsubckt_550_xor2_x0 83 82 141 140 315 xor2_x0
xsubckt_608_nand2_x0 83 82 258 259 314 nand2_x0
xdiode_9 83 82 762 diode_w1
xfeed_420 83 82 decap_w0
xfeed_244 83 82 decap_w0
xsubckt_1010_nexor2_x0 83 82 2140 13 2093 nexor2_x0
xsubckt_178_and2_x1 83 82 127 654 2537 and2_x1
xsubckt_102_inv_x0 83 82 11 711 inv_x0
xsubckt_1909_and3_x1 83 82 1218 1219 1220 1258 and3_x1
xsubckt_2018_nand4_x0 83 82 1119 670 762 772 777 nand4_x0
xsubckt_2490_dff_x1 83 82 2412 2569 141 dff_x1
xdiode_8 83 82 762 diode_w1
xfeed_421 83 82 decap_w0
xfeed_245 83 82 decap_w0
xsubckt_1070_or21nand_x0 83 82 2034 2035 2037 285 or21nand_x0
xsubckt_969_and21nor_x0 83 82 2133 2137 2136 2134 and21nor_x0
xsubckt_481_and2_x1 83 82 2486 382 388 and2_x1
xsubckt_1947_nexor2_x0 83 82 682 2520 1182 nexor2_x0
xdiode_56 83 82 606 diode_w1
xfeed_1120 83 82 tie
xfeed_695 83 82 tie
xsubckt_936_and2_x1 83 82 2166 2167 366 and2_x1
xsubckt_293_and2_x1 83 82 2498 558 578 and2_x1
xsubckt_269_nand2_x0 83 82 580 581 610 nand2_x0
xsubckt_188_nand2_x0 83 82 647 89 767 nand2_x0
xsubckt_1292_nand3_x0 83 82 1818 1819 1821 1823 nand3_x0
xsubckt_1789_and21nor_x0 83 82 1333 1339 1336 1334 and21nor_x0
xsubckt_1860_or21nand_x0 83 82 1266 1268 1272 2523 or21nand_x0
xsubckt_2029_nand2_x0 83 82 1109 142 805 nand2_x0
xsubckt_2137_and21nor_x0 83 82 1031 811 670 142 and21nor_x0
xsubckt_2160_nand2_x0 83 82 1011 1016 740 nand2_x0
xsubckt_2206_nexor2_x0 83 82 972 737 968 nexor2_x0
xsubckt_2391_dff_x1 83 82 2484 2561 39 dff_x1
xdiode_57 83 82 610 diode_w1
xfeed_1121 83 82 tie
xfeed_694 83 82 decap_w0
xsubckt_1173_or21nand_x0 83 82 1934 50 2002 49 or21nand_x0
xsubckt_1078_nand2_x0 83 82 2027 698 748 nand2_x0
xsubckt_802_mux2_x1 83 82 2298 2388 810 2297 mux2_x1
xsubckt_1431_or2_x1 83 82 1682 1683 1684 or2_x1
xsubckt_1974_and2_x1 83 82 1157 1158 762 and2_x1
xsubckt_2419_dff_x1 83 82 2456 2583 75 dff_x1
xdiode_54 83 82 606 diode_w1
xfeed_1122 83 82 tie
xfeed_697 83 82 tie
xfeed_28 83 82 tie
xsubckt_1624_and21nor_x0 83 82 1494 91 2139 340 and21nor_x0
xsubckt_1807_nexor2_x0 83 82 1318 1319 1316 nexor2_x0
xsubckt_2393_dff_x1 83 82 2482 2551 31 dff_x1
xdiode_55 83 82 606 diode_w1
xfeed_1123 83 82 tie
xfeed_696 83 82 tie
xfeed_29 83 82 decap_w0
xsubckt_1363_nand3_x0 83 82 1749 1751 809 139 nand3_x0
xsubckt_2037_nand2_x0 83 82 1102 142 2502 nand2_x0
xdiode_52 83 82 606 diode_w1
xfeed_1124 83 82 tie
xfeed_691 83 82 tie
xsubckt_1820_and21nor_x0 83 82 1303 1312 1311 1304 and21nor_x0
xsubckt_2076_and3_x1 83 82 1073 642 80 81 and3_x1
xdiode_53 83 82 606 diode_w1
xfeed_1125 83 82 decap_w0
xsubckt_1137_and21nor_x0 83 82 1969 2007 2014 2018 and21nor_x0
xsubckt_888_and21nor_x0 83 82 2213 731 699 2215 and21nor_x0
xsubckt_1535_nand2_x0 83 82 1580 1581 777 nand2_x0
xdiode_50 83 82 140 diode_w1
xfeed_1126 83 82 decap_w0
xfeed_693 83 82 decap_w0
xsubckt_1937_or4_x1 83 82 1192 2510 2509 2522 2521 or4_x1
xsubckt_2465_dff_x1 83 82 2413 2594 16 dff_x1
xdiode_51 83 82 606 diode_w1
xfeed_1127 83 82 tie
xfeed_692 83 82 tie
xsubckt_1201_nand2_x0 83 82 1907 1909 335 nand2_x0
xsubckt_1728_or21nand_x0 83 82 1392 1406 1394 1393 or21nand_x0
xsubckt_2032_nexor2_x0 83 82 1220 1258 1107 nexor2_x0
xsubckt_2047_and2_x1 83 82 1093 142 806 and2_x1
xsubckt_2119_nand3_x0 83 82 1044 644 159 152 nand3_x0
xsubckt_2404_dff_x1 83 82 2471 2595 34 dff_x1
xfeed_1128 83 82 decap_w0
xsubckt_828_and2_x1 83 82 2271 2272 285 and2_x1
xsubckt_723_and2_x1 83 82 2374 2375 2389 and2_x1
xsubckt_272_nand2_x0 83 82 578 617 722 nand2_x0
xfeed_1129 83 82 decap_w0
xfeed_23 83 82 tie
xsubckt_1084_and2_x1 83 82 2021 2022 607 and2_x1
xsubckt_1379_and21nor_x0 83 82 1733 1736 603 788 and21nor_x0
xsubckt_1457_and2_x1 83 82 1657 37 141 and2_x1
xsubckt_1735_or21nand_x0 83 82 1386 704 1389 1387 or21nand_x0
xsubckt_1764_nand2_x0 83 82 1358 698 755 nand2_x0
xsubckt_1780_and21nor_x0 83 82 1342 1376 1379 1383 and21nor_x0
xfeed_20 83 82 tie
xsubckt_1041_nand3_x0 83 82 2063 2066 2069 757 nand3_x0
xsubckt_361_nexor2_x0 83 82 497 718 493 nexor2_x0
xsubckt_1390_or21nand_x0 83 82 1722 811 213 341 or21nand_x0
xsubckt_1721_and21nor_x0 83 82 1399 278 2043 1400 and21nor_x0
xsubckt_1932_nand4_x0 83 82 1196 1197 676 677 110 nand4_x0
xsubckt_1989_nand2_x0 83 82 1145 1234 1236 nand2_x0
xsubckt_2243_nand2_x0 83 82 933 936 43 nand2_x0
xfeed_21 83 82 tie
xsubckt_658_nexor2_x0 83 82 232 738 209 nexor2_x0
xsubckt_444_nand2_x0 83 82 415 417 618 nand2_x0
xsubckt_1882_and2_x1 83 82 1245 1248 771 and2_x1
xfeed_699 83 82 decap_w0
xfeed_26 83 82 tie
xsubckt_112_and4_x1 83 82 702 138 808 140 810 and4_x1
xsubckt_1631_nand2_x0 83 82 1487 1488 706 nand2_x0
xsubckt_1946_nand3_x0 83 82 1183 1184 1185 670 nand3_x0
xsubckt_2332_nexor2_x0 83 82 853 729 849 nexor2_x0
xfeed_698 83 82 tie
xfeed_27 83 82 tie
xsubckt_1119_or21nand_x0 83 82 1986 18 762 326 or21nand_x0
xsubckt_820_nand2_x0 83 82 2279 2280 335 nand2_x0
xsubckt_671_nand2_x0 83 82 196 197 314 nand2_x0
xsubckt_300_and2_x1 83 82 551 552 721 and2_x1
xsubckt_1456_mux2_x1 83 82 36 1660 373 1658 mux2_x1
xsubckt_1651_or2_x1 83 82 1467 1474 1476 or2_x1
xsubckt_2333_nexor2_x0 83 82 849 854 848 nexor2_x0
xsubckt_2437_dff_x1 83 82 2438 2568 2510 dff_x1
xdiode_58 83 82 610 diode_w1
xfeed_24 83 82 tie
xsubckt_1219_or21nand_x0 83 82 1889 142 1890 1914 or21nand_x0
xsubckt_47_inv_x0 83 82 92 765 inv_x0
xsubckt_119_and21nor_x0 83 82 696 138 703 697 and21nor_x0
xsubckt_1382_nand3_x0 83 82 1730 1736 603 70 nand3_x0
xsubckt_1563_nand2_x0 83 82 1553 1559 1561 nand2_x0
xdiode_59 83 82 777 diode_w1
xfeed_25 83 82 tie
xsubckt_280_or21nand_x0 83 82 570 597 585 586 or21nand_x0
xsubckt_145_nand2_x0 83 82 672 142 84 nand2_x0
xdiode_63 83 82 26 diode_w1
xfeed_682 83 82 decap_w0
xfeed_17 83 82 tie
xsubckt_1211_xor2_x0 83 82 32 72 1897 xor2_x0
xsubckt_232_nor2_x0 83 82 616 141 140 nor2_x0
xsubckt_459_nexor2_x0 83 82 405 11 401 nexor2_x0
xsubckt_1617_nor2_x0 83 82 1500 1501 264 nor2_x0
xsubckt_2010_nand2_x0 83 82 1126 142 803 nand2_x0
xsubckt_2257_nand3_x0 83 82 919 920 921 610 nand3_x0
xdiode_62 83 82 26 diode_w1
xfeed_683 83 82 decap_w0
xfeed_16 83 82 tie
xsubckt_752_nand2_x0 83 82 2345 2350 265 nand2_x0
xsubckt_1627_or21nand_x0 83 82 1491 1495 1494 1492 or21nand_x0
xsubckt_2229_nexor2_x0 83 82 947 952 946 nexor2_x0
xdiode_61 83 82 777 diode_w1
xfeed_680 83 82 decap_w0
xfeed_15 83 82 tie
xsubckt_902_and21nor_x0 83 82 2199 2201 2203 760 and21nor_x0
xsubckt_261_mux2_x1 83 82 783 780 605 588 mux2_x1
xsubckt_72_inv_x0 83 82 55 741 inv_x0
xsubckt_1440_nand2_x0 83 82 1673 1674 277 nand2_x0
xsubckt_1713_nexor2_x0 83 82 1409 1410 1407 nexor2_x0
xsubckt_2324_nand2_x0 83 82 857 617 729 nand2_x0
xdiode_60 83 82 777 diode_w1
xfeed_681 83 82 tie
xfeed_14 83 82 tie
xsubckt_211_nand2_x0 83 82 149 631 632 nand2_x0
xsubckt_406_and21nor_x0 83 82 450 458 609 617 and21nor_x0
xsubckt_561_nand4_x0 83 82 304 788 808 140 810 nand4_x0
xsubckt_2051_nand2_x0 83 82 1090 1091 2541 nand2_x0
xsubckt_2057_and21nor_x0 83 82 2435 1086 1087 1090 and21nor_x0
xsubckt_2365_or21nand_x0 83 82 819 832 822 824 or21nand_x0
xsubckt_2400_dff_x1 83 82 2475 2593 24 dff_x1
xsubckt_2509_dff_x1 83 82 2393 2578 49 dff_x1
xdiode_89 83 82 808 diode_w1
xdiode_67 83 82 141 diode_w1
xfeed_686 83 82 tie
xsubckt_1891_or21nand_x0 83 82 1236 1238 1272 2515 or21nand_x0
xdiode_88 83 82 290 diode_w1
xdiode_66 83 82 141 diode_w1
xfeed_687 83 82 tie
xfeed_12 83 82 tie
xsubckt_1080_and2_x1 83 82 2025 2116 360 and2_x1
xsubckt_1434_nand2_x0 83 82 1679 1681 1687 nand2_x0
xsubckt_1799_nor4_x0 83 82 1324 33 141 140 139 nor4_x0
xsubckt_2131_and2_x1 83 82 2411 1036 1037 and2_x1
xsubckt_2224_mux2_x1 83 82 67 64 606 951 mux2_x1
xdiode_65 83 82 26 diode_w1
xfeed_749 83 82 decap_w0
xfeed_684 83 82 tie
xfeed_11 83 82 tie
xsubckt_1263_and2_x1 83 82 1847 1848 366 and2_x1
xsubckt_1695_nand2_x0 83 82 1425 327 76 nand2_x0
xsubckt_2293_and2_x1 83 82 886 617 732 and2_x1
xdiode_64 83 82 26 diode_w1
xfeed_748 83 82 decap_w0
xfeed_10 83 82 tie
xsubckt_617_and3_x1 83 82 249 701 790 810 and3_x1
xsubckt_1696_mux2_x1 83 82 34 33 141 1424 mux2_x1
xdiode_85 83 82 810 diode_w1
xfeed_747 83 82 decap_w0
xsubckt_92_inv_x0 83 82 6 721 inv_x0
xdiode_84 83 82 810 diode_w1
xfeed_746 83 82 decap_w0
xsubckt_1168_or21nand_x0 83 82 1939 1968 1977 1978 or21nand_x0
xsubckt_735_and2_x1 83 82 2362 211 737 and2_x1
xsubckt_291_and21nor_x0 83 82 559 572 610 617 and21nor_x0
xsubckt_278_nexor2_x0 83 82 573 575 572 nexor2_x0
xsubckt_238_and2_x1 83 82 610 612 138 and2_x1
xsubckt_2078_and2_x1 83 82 1071 2543 63 and2_x1
xdiode_87 83 82 290 diode_w1
xdiode_69 83 82 141 diode_w1
xfeed_745 83 82 decap_w0
xsubckt_1406_mux2_x1 83 82 782 757 699 1707 mux2_x1
xsubckt_1469_and2_x1 83 82 1645 1662 607 and2_x1
xdiode_86 83 82 290 diode_w1
xdiode_68 83 82 141 diode_w1
xfeed_744 83 82 decap_w0
xfeed_689 83 82 tie
xsubckt_1067_and21nor_x0 83 82 2037 2041 2040 2038 and21nor_x0
xsubckt_368_or2_x1 83 82 486 488 490 or2_x1
xsubckt_386_or2_x1 83 82 469 470 472 or2_x1
xsubckt_1294_and21nor_x0 83 82 1816 1817 1818 289 and21nor_x0
xsubckt_1675_nexor2_x0 83 82 1449 77 1444 nexor2_x0
xsubckt_1786_and21nor_x0 83 82 1336 278 1962 1337 and21nor_x0
xdiode_81 83 82 812 diode_w1
xfeed_743 83 82 decap_w0
xsubckt_1280_and21nor_x0 83 82 1830 1839 1835 1831 and21nor_x0
xsubckt_920_nand4_x0 83 82 2181 716 93 811 812 nand4_x0
xsubckt_852_nand2_x0 83 82 2248 2250 761 nand2_x0
xsubckt_563_nand3_x0 83 82 302 304 305 607 nand3_x0
xsubckt_1333_and2_x1 83 82 1778 1779 71 and2_x1
xsubckt_1545_mux2_x1 83 82 35 1572 366 1571 mux2_x1
xdiode_80 83 82 812 diode_w1
xfeed_742 83 82 decap_w0
xsubckt_906_nexor2_x0 83 82 2200 760 2195 nexor2_x0
xsubckt_202_and21nor_x0 83 82 135 744 640 637 and21nor_x0
xsubckt_164_and2_x1 83 82 118 661 2537 and2_x1
xsubckt_1313_nand4_x0 83 82 1798 29 808 140 810 nand4_x0
xsubckt_1351_nand2_x0 83 82 1760 1761 777 nand2_x0
xsubckt_1520_and21nor_x0 83 82 1595 1599 554 791 and21nor_x0
xsubckt_1836_and21nor_x0 83 82 1288 1313 1320 1322 and21nor_x0
xsubckt_2350_nand2_x0 83 82 833 834 727 nand2_x0
xdiode_83 83 82 812 diode_w1
xfeed_741 83 82 decap_w0
xfeed_19 83 82 tie
xsubckt_613_nand3_x0 83 82 253 616 67 139 nand3_x0
xsubckt_623_and3_x1 83 82 243 245 260 31 and3_x1
xsubckt_1754_and21nor_x0 83 82 1367 1373 1370 1368 and21nor_x0
xsubckt_1824_mux2_x1 83 82 73 1300 326 2454 mux2_x1
xdiode_82 83 82 812 diode_w1
xfeed_740 83 82 decap_w0
xfeed_18 83 82 tie
xsubckt_1005_and21nor_x0 83 82 2098 2146 2153 2156 and21nor_x0
xsubckt_374_and21nor_x0 83 82 481 498 495 494 and21nor_x0
xfeed_1043 83 82 decap_w0
xfeed_480 83 82 decap_w0
xfeed_156 83 82 tie
xsubckt_1213_or21nand_x0 83 82 1895 1897 1899 290 or21nand_x0
xsubckt_311_nand2_x0 83 82 541 617 720 nand2_x0
xsubckt_172_and2_x1 83 82 130 657 2537 and2_x1
xsubckt_1_inv_x0 83 82 91 811 inv_x0
xsubckt_1437_or21nand_x0 83 82 1676 811 2363 341 or21nand_x0
xfeed_1042 83 82 decap_w0
xfeed_588 83 82 tie
xfeed_481 83 82 decap_w0
xfeed_157 83 82 tie
xsubckt_1111_and21nor_x0 83 82 1994 91 728 340 and21nor_x0
xsubckt_20_inv_x0 83 82 2524 792 inv_x0
xsubckt_369_and21nor_x0 83 82 485 488 490 609 and21nor_x0
xsubckt_387_and21nor_x0 83 82 468 470 472 609 and21nor_x0
xsubckt_569_nand2_x0 83 82 296 301 38 nand2_x0
xsubckt_1388_or21nand_x0 83 82 1724 1768 1773 1777 or21nand_x0
xsubckt_1761_and2_x1 83 82 1360 142 58 and2_x1
xsubckt_2327_or21nand_x0 83 82 854 867 864 866 or21nand_x0
xfeed_1041 83 82 decap_w0
xfeed_482 83 82 decap_w0
xfeed_468 83 82 tie
xfeed_154 83 82 decap_w0
xsubckt_1729_nand2_x0 83 82 2457 1392 1425 nand2_x0
xsubckt_1758_and21nor_x0 83 82 1363 1413 1405 1412 and21nor_x0
xsubckt_1934_and21nor_x0 83 82 2449 1204 1199 1195 and21nor_x0
xfeed_1040 83 82 decap_w0
xfeed_483 83 82 decap_w0
xfeed_469 83 82 decap_w0
xfeed_155 83 82 decap_w0
xsubckt_40_inv_x0 83 82 2512 772 inv_x0
xsubckt_527_mux2_x1 83 82 15 55 91 337 mux2_x1
xsubckt_2326_and2_x1 83 82 855 856 618 and2_x1
xsubckt_2462_dff_x1 83 82 2416 2594 19 dff_x1
xsubckt_2488_dff_x1 83 82 115 2570 93 dff_x1
xfeed_1047 83 82 decap_w0
xfeed_839 83 82 tie
xfeed_484 83 82 tie
xfeed_152 83 82 decap_w0
xsubckt_1223_nand3_x0 83 82 1886 614 779 141 nand3_x0
xsubckt_870_nand2_x0 83 82 2230 2231 334 nand2_x0
xsubckt_698_and21nor_x0 83 82 169 218 238 241 and21nor_x0
xsubckt_364_and21nor_x0 83 82 490 491 507 527 and21nor_x0
xsubckt_501_and4_x1 83 82 363 364 365 366 370 and4_x1
xsubckt_1330_or21nand_x0 83 82 1781 1783 1788 1798 or21nand_x0
xsubckt_2395_dff_x1 83 82 2480 2557 29 dff_x1
xfeed_1046 83 82 decap_w0
xfeed_838 83 82 tie
xfeed_485 83 82 tie
xfeed_153 83 82 decap_w0
xsubckt_1269_nand2_x0 83 82 1841 1843 2212 nand2_x0
xsubckt_700_nexor2_x0 83 82 169 172 167 nexor2_x0
xsubckt_205_nor3_x0 83 82 111 635 636 763 nor3_x0
xsubckt_568_and2_x1 83 82 297 301 38 and2_x1
xsubckt_1285_or21nand_x0 83 82 1825 1830 1853 786 or21nand_x0
xsubckt_1893_nand3_x0 83 82 1234 1237 1271 769 nand3_x0
xfeed_1045 83 82 decap_w0
xfeed_486 83 82 tie
xfeed_150 83 82 tie
xsubckt_170_and2_x1 83 82 131 658 2537 and2_x1
xsubckt_471_nexor2_x0 83 82 391 396 390 nexor2_x0
xsubckt_1455_mux2_x1 83 82 757 1661 373 1659 mux2_x1
xsubckt_1776_and21nor_x0 83 82 1346 1354 1355 74 and21nor_x0
xsubckt_2042_nexor2_x0 83 82 1099 1219 1098 nexor2_x0
xfeed_1044 83 82 decap_w0
xfeed_487 83 82 tie
xfeed_151 83 82 tie
xsubckt_943_and3_x1 83 82 2159 2162 2163 607 and3_x1
xsubckt_727_or21nand_x0 83 82 2370 2376 2390 29 or21nand_x0
xsubckt_714_nand2_x0 83 82 2383 76 141 nand2_x0
xsubckt_207_nand3_x0 83 82 633 109 85 767 nand3_x0
xsubckt_31_inv_x0 83 82 30 781 inv_x0
xsubckt_113_and2_x1 83 82 115 702 2533 and2_x1
xsubckt_547_and21nor_x0 83 82 318 368 319 322 and21nor_x0
xsubckt_1753_nand2_x0 83 82 1368 1369 289 nand2_x0
xsubckt_1852_and3_x1 83 82 1274 2212 314 792 and3_x1
xsubckt_2134_and21nor_x0 83 82 2410 1391 1040 1034 and21nor_x0
xfeed_835 83 82 tie
xfeed_581 83 82 decap_w0
xfeed_488 83 82 decap_w0
xsubckt_1206_nand4_x0 83 82 1902 708 93 811 812 nand4_x0
xsubckt_1017_nand4_x0 83 82 2086 713 93 811 812 nand4_x0
xsubckt_913_and3_x1 83 82 2188 2281 716 717 and3_x1
xsubckt_811_nexor2_x0 83 82 2294 784 2288 nexor2_x0
xsubckt_702_or21nand_x0 83 82 165 286 170 166 or21nand_x0
xsubckt_81_inv_x0 83 82 40 732 inv_x0
xsubckt_409_and21nor_x0 83 82 448 462 459 461 and21nor_x0
xsubckt_1579_and2_x1 83 82 1537 142 63 and2_x1
xsubckt_1763_or21nand_x0 83 82 2456 1365 1361 1359 or21nand_x0
xsubckt_1775_nand3_x0 83 82 1347 1354 1355 74 nand3_x0
xsubckt_2199_or21nand_x0 83 82 974 610 982 975 or21nand_x0
xsubckt_2374_buf_x1 83 82 85 87 buf_x1
xfeed_834 83 82 tie
xfeed_580 83 82 decap_w0
xsubckt_932_nand2_x0 83 82 2476 2170 2172 nand2_x0
xsubckt_1355_nand2_x0 83 82 2466 1757 1800 nand2_x0
xsubckt_1718_nand3_x0 83 82 1402 2046 2047 335 nand3_x0
xsubckt_2103_and21nor_x0 83 82 2420 1055 1056 763 and21nor_x0
xsubckt_2381_dff_x1 83 82 2494 2554 3 dff_x1
xfeed_1049 83 82 decap_w0
xfeed_837 83 82 tie
xfeed_583 83 82 decap_w0
xsubckt_213_nand3_x0 83 82 629 107 85 767 nand3_x0
xsubckt_1606_and21nor_x0 83 82 1511 1575 1559 1562 and21nor_x0
xsubckt_1692_and2_x1 83 82 1427 142 60 and2_x1
xsubckt_2241_mux2_x1 83 82 753 750 606 935 mux2_x1
xfeed_1048 83 82 decap_w0
xfeed_836 83 82 tie
xfeed_582 83 82 decap_w0
xfeed_461 83 82 tie
xsubckt_1239_nand3_x0 83 82 1870 1871 140 810 nand3_x0
xsubckt_666_and21nor_x0 83 82 201 236 239 243 and21nor_x0
xsubckt_306_nexor2_x0 83 82 24 25 545 nexor2_x0
xsubckt_1610_and21nor_x0 83 82 1507 812 93 1 and21nor_x0
xsubckt_1741_nand3_x0 83 82 1380 1386 447 75 nand3_x0
xsubckt_1778_and2_x1 83 82 1344 1349 1351 and2_x1
xsubckt_2075_and21nor_x0 83 82 2429 1074 1075 1090 and21nor_x0
xfeed_831 83 82 decap_w0
xfeed_585 83 82 tie
xfeed_466 83 82 tie
xspare_buffer_82 83 82 2558 2546 buf_x4
xsubckt_742_and21nor_x0 83 82 2355 2359 2358 2356 and21nor_x0
xsubckt_224_nand3_x0 83 82 622 95 85 86 nand3_x0
xsubckt_2171_mux2_x1 83 82 67 70 605 1001 mux2_x1
xsubckt_2423_dff_x1 83 82 2452 2570 2524 dff_x1
xfeed_830 83 82 decap_w0
xfeed_584 83 82 tie
xfeed_467 83 82 tie
xspare_buffer_83 83 82 2529 2525 buf_x4
xsubckt_1207_nand2_x0 83 82 1901 1902 289 nand2_x0
xsubckt_55_inv_x0 83 82 37 758 inv_x0
xsubckt_404_and21nor_x0 83 82 452 454 456 609 and21nor_x0
xsubckt_1448_and2_x1 83 82 1665 1666 762 and2_x1
xsubckt_1985_nexor2_x0 83 82 695 2516 1148 nexor2_x0
xfeed_833 83 82 tie
xfeed_587 83 82 decap_w0
xfeed_464 83 82 tie
xfeed_158 83 82 tie
xspare_buffer_80 83 82 2558 2548 buf_x4
xsubckt_90_inv_x0 83 82 14 723 inv_x0
xsubckt_523_and2_x1 83 82 341 93 812 and2_x1
xsubckt_1282_and3_x1 83 82 1828 1829 1852 78 and3_x1
xsubckt_1368_nand3_x0 83 82 1744 616 761 139 nand3_x0
xsubckt_1905_and21nor_x0 83 82 1222 1246 1223 1245 and21nor_x0
xfeed_832 83 82 decap_w0
xfeed_586 83 82 tie
xfeed_465 83 82 tie
xfeed_159 83 82 tie
xspare_buffer_81 83 82 2558 2547 buf_x4
xsubckt_424_and21nor_x0 83 82 433 440 441 617 and21nor_x0
xsubckt_1561_nand3_x0 83 82 1555 1563 539 753 nand3_x0
xdiode_12 83 82 139 diode_w1
xfeed_651 83 82 decap_w0
xsubckt_1249_nand3_x0 83 82 1860 1863 1886 785 nand3_x0
xsubckt_159_mux2_x1 83 82 98 37 669 663 mux2_x1
xsubckt_631_nexor2_x0 83 82 237 238 235 nexor2_x0
xsubckt_1855_nand2_x0 83 82 1271 2122 285 nand2_x0
xsubckt_2219_and2_x1 83 82 955 956 618 and2_x1
xdiode_13 83 82 139 diode_w1
xfeed_650 83 82 decap_w0
xsubckt_345_nand2_x0 83 82 508 36 37 nand2_x0
xsubckt_1707_or2_x1 83 82 1413 1419 749 or2_x1
xsubckt_1872_and3_x1 83 82 1255 611 162 799 and3_x1
xsubckt_2235_nor2_x0 83 82 940 941 617 nor2_x0
xsubckt_2507_dff_x1 83 82 2395 2574 51 dff_x1
xdiode_10 83 82 139 diode_w1
xfeed_653 83 82 decap_w0
xsubckt_1124_and2_x1 83 82 1982 1983 2025 and2_x1
xsubckt_883_and21nor_x0 83 82 2217 26 327 2218 and21nor_x0
xsubckt_783_nexor2_x0 83 82 2362 736 2315 nexor2_x0
xdiode_11 83 82 139 diode_w1
xfeed_652 83 82 decap_w0
xsubckt_596_nand2_x0 83 82 269 270 272 nand2_x0
xsubckt_1322_nand2_x0 83 82 1789 1791 2212 nand2_x0
xsubckt_1802_and2_x1 83 82 1321 1323 73 and2_x1
xdiode_16 83 82 139 diode_w1
xfeed_655 83 82 tie
xspare_feed_112 83 82 tie
xsubckt_687_or21nand_x0 83 82 180 184 199 781 or21nand_x0
xsubckt_1771_nand3_x0 83 82 1351 1354 1355 747 nand3_x0
xsubckt_1997_and2_x1 83 82 2443 1138 1141 and2_x1
xdiode_17 83 82 139 diode_w1
xfeed_654 83 82 tie
xspare_feed_113 83 82 tie
xsubckt_955_nexor2_x0 83 82 2157 24 2147 nexor2_x0
xsubckt_77_inv_x0 83 82 44 736 inv_x0
xsubckt_505_nand4_x0 83 82 359 68 141 809 139 nand4_x0
xsubckt_634_nor3_x0 83 82 232 47 54 55 nor3_x0
xsubckt_1826_nexor2_x0 83 82 1299 1897 1298 nexor2_x0
xdiode_14 83 82 139 diode_w1
xfeed_657 83 82 tie
xspare_feed_110 83 82 tie
xsubckt_1112_and21nor_x0 83 82 1993 1996 1995 1994 and21nor_x0
xsubckt_871_and2_x1 83 82 2229 2281 717 and2_x1
xsubckt_298_mux2_x1 83 82 29 26 606 553 mux2_x1
xsubckt_537_nor2_x0 83 82 2484 328 330 nor2_x0
xsubckt_1283_nand3_x0 83 82 1827 1829 1852 78 nand3_x0
xsubckt_2273_nand3_x0 83 82 904 905 906 610 nand3_x0
xdiode_15 83 82 139 diode_w1
xfeed_656 83 82 tie
xspare_feed_111 83 82 decap_w0
xsubckt_998_and3_x1 83 82 2105 2107 2111 37 and3_x1
xsubckt_309_or21nand_x0 83 82 542 610 548 543 or21nand_x0
xsubckt_518_or21nand_x0 83 82 346 349 376 39 or21nand_x0
xsubckt_1357_nand2_x0 83 82 1755 1756 373 nand2_x0
xsubckt_2040_or21nand_x0 83 82 2438 1106 1103 1100 or21nand_x0
xfeed_659 83 82 tie
xsubckt_957_or21nand_x0 83 82 2145 2193 2194 2198 or21nand_x0
xsubckt_333_or21nand_x0 83 82 519 610 532 520 or21nand_x0
xsubckt_1352_and21nor_x0 83 82 1759 1763 1762 1760 and21nor_x0
xsubckt_2058_or21nand_x0 83 82 1085 643 159 2506 or21nand_x0
xfeed_658 83 82 tie
xsubckt_226_nand2_x0 83 82 144 621 622 nand2_x0
xsubckt_51_inv_x0 83 82 142 762 inv_x0
xsubckt_611_and3_x1 83 82 255 256 258 361 and3_x1
xsubckt_1667_and21nor_x0 83 82 1452 141 755 1453 and21nor_x0
xdiode_18 83 82 139 diode_w1
xsubckt_817_nexor2_x0 83 82 2317 735 2282 nexor2_x0
xsubckt_175_mux2_x1 83 82 106 77 669 655 mux2_x1
xsubckt_390_and2_x1 83 82 466 617 716 and2_x1
xdiode_19 83 82 139 diode_w1
xsubckt_1056_and3_x1 83 82 2048 2143 729 730 and3_x1
xsubckt_804_nand2_x0 83 82 2295 2296 2299 nand2_x0
xsubckt_220_nand2_x0 83 82 146 625 626 nand2_x0
xsubckt_457_nand2_x0 83 82 403 404 711 nand2_x0
xsubckt_615_nand2_x0 83 82 251 253 705 nand2_x0
xsubckt_1751_and21nor_x0 83 82 1370 278 1998 1371 and21nor_x0
xsubckt_1158_or21nand_x0 83 82 1948 285 1949 265 or21nand_x0
xsubckt_1449_and2_x1 83 82 2464 1665 1667 and2_x1
xsubckt_2212_nand2_x0 83 82 962 980 996 nand2_x0
xsubckt_848_or21nand_x0 83 82 2252 2258 2256 2253 or21nand_x0
xsubckt_195_and2_x1 83 82 642 160 2543 and2_x1
xsubckt_1403_or21nand_x0 83 82 1709 285 1711 1710 or21nand_x0
xsubckt_1673_and2_x1 83 82 1446 1449 77 and2_x1
xsubckt_1850_or21nand_x0 83 82 1276 162 671 762 or21nand_x0
xsubckt_2170_mux2_x1 83 82 791 788 605 1002 mux2_x1
xsubckt_2468_dff_x1 83 82 131 2580 109 dff_x1
xsubckt_2482_dff_x1 83 82 117 2595 95 dff_x1
xsubckt_1212_and2_x1 83 82 1896 1897 1899 and2_x1
xsubckt_315_mux2_x1 83 82 783 760 606 537 mux2_x1
xsubckt_268_nexor2_x0 83 82 595 761 581 nexor2_x0
xsubckt_191_or21nand_x0 83 82 645 767 745 85 or21nand_x0
xsubckt_321_nor3_x0 83 82 531 545 573 574 nor3_x0
xsubckt_570_nexor2_x0 83 82 301 38 295 nexor2_x0
xsubckt_577_and21nor_x0 83 82 288 295 293 289 and21nor_x0
xsubckt_1343_and21nor_x0 83 82 1768 1820 1825 1828 and21nor_x0
xsubckt_1556_and3_x1 83 82 1560 1563 539 66 and3_x1
xsubckt_1677_or21nand_x0 83 82 1442 1472 1461 1469 or21nand_x0
xsubckt_2161_nexor2_x0 83 82 1016 54 1010 nexor2_x0
xsubckt_2364_and21nor_x0 83 82 820 831 821 823 and21nor_x0
xsubckt_1074_and21nor_x0 83 82 2030 36 327 2031 and21nor_x0
xsubckt_1447_or3_x1 83 82 1666 93 162 69 or3_x1
xsubckt_2422_dff_x1 83 82 2453 2593 72 dff_x1
xfeed_1032 83 82 decap_w0
xfeed_538 83 82 tie
xfeed_314 83 82 tie
xspare_buffer_33 83 82 2597 2586 buf_x4
xsubckt_1092_nexor2_x0 83 82 2019 756 2013 nexor2_x0
xsubckt_219_nand3_x0 83 82 625 105 85 767 nand3_x0
xsubckt_12_inv_x0 83 82 158 800 inv_x0
xsubckt_1485_nexor2_x0 83 82 1631 1635 1629 nexor2_x0
xsubckt_2059_nand3_x0 83 82 1084 644 744 156 nand3_x0
xsubckt_2343_nexor2_x0 83 82 840 841 839 nexor2_x0
xfeed_1033 83 82 tie
xfeed_539 83 82 tie
xfeed_315 83 82 tie
xspare_buffer_32 83 82 2597 2587 buf_x4
xsubckt_1145_nexor2_x0 83 82 1999 710 1961 nexor2_x0
xsubckt_965_nand2_x0 83 82 2137 2138 335 nand2_x0
xsubckt_832_nexor2_x0 83 82 2269 2289 2267 nexor2_x0
xsubckt_200_nand2_x0 83 82 638 80 159 nand2_x0
xsubckt_1509_and2_x1 83 82 1606 1607 1608 and2_x1
xfeed_1030 83 82 decap_w0
xfeed_969 83 82 decap_w0
xfeed_316 83 82 tie
xfeed_107 83 82 tie
xspare_buffer_31 83 82 2544 2541 buf_x4
xsubckt_641_and21nor_x0 83 82 225 229 228 226 and21nor_x0
xsubckt_138_and2_x1 83 82 678 680 798 and2_x1
xsubckt_407_and21nor_x0 83 82 2492 450 451 466 and21nor_x0
xsubckt_607_mux2_x1 83 82 787 751 699 259 mux2_x1
xsubckt_630_or21nand_x0 83 82 236 293 295 296 or21nand_x0
xsubckt_1646_and3_x1 83 82 1472 1478 1489 64 and3_x1
xfeed_1031 83 82 decap_w0
xfeed_968 83 82 decap_w0
xfeed_106 83 82 tie
xspare_buffer_30 83 82 2597 2588 buf_x4
xsubckt_584_nand3_x0 83 82 281 282 343 811 nand3_x0
xsubckt_1584_nand4_x0 83 82 1533 754 808 140 139 nand4_x0
xsubckt_2390_dff_x1 83 82 2485 2582 8 dff_x1
xfeed_1168 83 82 tie
xfeed_1036 83 82 decap_w0
xfeed_310 83 82 tie
xfeed_101 83 82 decap_w0
xspare_buffer_37 83 82 2584 2582 buf_x4
xsubckt_41_inv_x0 83 82 2513 771 inv_x0
xsubckt_1583_nand2_x0 83 82 1534 372 760 nand2_x0
xsubckt_1914_and21nor_x0 83 82 1213 799 162 2522 and21nor_x0
xfeed_1169 83 82 tie
xfeed_1037 83 82 decap_w0
xfeed_311 83 82 tie
xfeed_100 83 82 tie
xspare_buffer_36 83 82 2584 2583 buf_x4
xsubckt_879_or21nand_x0 83 82 2221 2222 2224 285 or21nand_x0
xsubckt_1714_and2_x1 83 82 1406 1407 290 and2_x1
xsubckt_1916_nand3_x0 83 82 1211 162 2522 799 nand3_x0
xfeed_1034 83 82 tie
xfeed_312 83 82 tie
xfeed_103 83 82 tie
xspare_buffer_35 83 82 2544 2540 buf_x4
xsubckt_846_nand3_x0 83 82 2254 701 750 810 nand3_x0
xsubckt_732_nexor2_x0 83 82 2367 2368 2365 nexor2_x0
xsubckt_98_inv_x0 83 82 0 715 inv_x0
xsubckt_120_nor2_x0 83 82 133 696 763 nor2_x0
xsubckt_533_nand2_x0 83 82 331 336 338 nand2_x0
xsubckt_1444_nand2_x0 83 82 1669 1670 1672 nand2_x0
xsubckt_1504_nand3_x0 83 82 1611 1613 809 139 nand3_x0
xfeed_1035 83 82 decap_w0
xfeed_313 83 82 tie
xfeed_102 83 82 decap_w0
xspare_buffer_34 83 82 2597 2585 buf_x4
xsubckt_796_or21nand_x0 83 82 2302 2307 2320 265 or21nand_x0
xsubckt_669_nand3_x0 83 82 198 614 69 141 nand3_x0
xsubckt_438_and2_x1 83 82 420 421 618 and2_x1
xsubckt_1492_and21nor_x0 83 82 1622 1626 1625 1623 and21nor_x0
xsubckt_1569_and2_x1 83 82 1547 1548 289 and2_x1
xfeed_1164 83 82 decap_w0
xfeed_963 83 82 decap_w0
xfeed_530 83 82 decap_w0
xfeed_84 83 82 tie
xsubckt_1225_and2_x1 83 82 1884 1885 373 and2_x1
xsubckt_2009_nand4_x0 83 82 1127 670 762 771 777 nand4_x0
xsubckt_2111_or21nand_x0 83 82 1049 638 84 20 or21nand_x0
xsubckt_2292_and21nor_x0 83 82 2399 887 894 902 and21nor_x0
xfeed_1165 83 82 decap_w0
xfeed_962 83 82 decap_w0
xfeed_531 83 82 tie
xfeed_85 83 82 tie
xsubckt_1273_nand3_x0 83 82 1837 1838 140 810 nand3_x0
xsubckt_813_or21nand_x0 83 82 2286 2324 2325 2329 or21nand_x0
xsubckt_645_and2_x1 83 82 221 222 285 and2_x1
xsubckt_1881_nand2_x0 83 82 1246 1247 2513 nand2_x0
xsubckt_1980_mux2_x1 83 82 1153 1155 1161 1152 mux2_x1
xsubckt_2139_nexor2_x0 83 82 1033 812 1030 nexor2_x0
xfeed_1166 83 82 decap_w0
xfeed_1038 83 82 decap_w0
xfeed_961 83 82 tie
xfeed_532 83 82 decap_w0
xfeed_86 83 82 tie
xspare_buffer_39 83 82 2539 2538 buf_x4
xsubckt_1181_nand2_x0 83 82 1926 1927 332 nand2_x0
xsubckt_876_and21nor_x0 83 82 2224 2230 2227 2225 and21nor_x0
xsubckt_644_or2_x1 83 82 222 223 225 or2_x1
xsubckt_504_mux2_x1 83 82 615 809 810 360 mux2_x1
xsubckt_1750_or21nand_x0 83 82 1371 335 1372 332 or21nand_x0
xsubckt_1808_nand2_x0 83 82 1315 1316 290 nand2_x0
xsubckt_2236_or21nand_x0 83 82 939 610 946 940 or21nand_x0
xsubckt_2425_dff_x1 83 82 2450 2564 2522 dff_x1
xfeed_1167 83 82 tie
xfeed_1039 83 82 decap_w0
xfeed_960 83 82 tie
xfeed_533 83 82 decap_w0
xfeed_87 83 82 tie
xspare_buffer_38 83 82 2584 2581 buf_x4
xsubckt_250_and2_x1 83 82 598 602 15 and2_x1
xsubckt_66_inv_x0 83 82 74 747 inv_x0
xsubckt_441_and2_x1 83 82 418 617 712 and2_x1
xsubckt_466_mux2_x1 83 82 33 32 606 395 mux2_x1
xfeed_1160 83 82 decap_w0
xfeed_967 83 82 decap_w0
xfeed_534 83 82 tie
xfeed_318 83 82 tie
xfeed_109 83 82 tie
xfeed_80 83 82 tie
xsubckt_402_nexor2_x0 83 82 33 34 454 nexor2_x0
xsubckt_2107_nand3_x0 83 82 1052 644 159 156 nand3_x0
xsubckt_2201_nand2_x0 83 82 973 617 737 nand2_x0
xfeed_1161 83 82 decap_w0
xfeed_966 83 82 decap_w0
xfeed_535 83 82 tie
xfeed_319 83 82 tie
xfeed_108 83 82 tie
xsubckt_267_nexor2_x0 83 82 583 598 582 nexor2_x0
xsubckt_33_inv_x0 83 82 38 779 inv_x0
xsubckt_338_mux2_x1 83 82 27 24 606 515 mux2_x1
xsubckt_443_and2_x1 83 82 416 417 618 and2_x1
xsubckt_1678_and21nor_x0 83 82 1441 1471 1462 1470 and21nor_x0
xsubckt_1757_or21nand_x0 83 82 1364 1414 1404 1411 or21nand_x0
xsubckt_1813_nand3_x0 83 82 1310 1934 1935 335 nand3_x0
xsubckt_1978_nand3_x0 83 82 1154 670 762 162 nand3_x0
xfeed_1162 83 82 decap_w0
xfeed_965 83 82 decap_w0
xfeed_536 83 82 tie
xfeed_82 83 82 tie
xsubckt_297_nand3_x0 83 82 554 614 761 141 nand3_x0
xsubckt_564_and21nor_x0 83 82 301 303 306 324 and21nor_x0
xsubckt_1404_nor2_x0 83 82 2465 1709 1714 nor2_x0
xsubckt_1421_and2_x1 83 82 1692 1693 69 and2_x1
xsubckt_1876_and2_x1 83 82 1251 1252 2512 and2_x1
xsubckt_2116_nand3_x0 83 82 1046 644 159 153 nand3_x0
xsubckt_2183_and2_x1 83 82 2405 990 1005 and2_x1
xfeed_1163 83 82 decap_w0
xfeed_964 83 82 decap_w0
xfeed_537 83 82 tie
xfeed_83 83 82 tie
xsubckt_688_and3_x1 83 82 179 183 198 30 and3_x1
xsubckt_163_mux2_x1 83 82 96 35 669 661 mux2_x1
xsubckt_2431_dff_x1 83 82 2444 2588 2516 dff_x1
xfeed_1119 83 82 decap_w0
xfeed_978 83 82 tie
xfeed_361 83 82 decap_w0
xfeed_112 83 82 tie
xsubckt_496_nand2_x0 83 82 368 809 139 nand2_x0
xsubckt_625_and21nor_x0 83 82 241 245 260 780 and21nor_x0
xsubckt_1887_nand3_x0 83 82 1240 1243 1244 770 nand3_x0
xsubckt_1977_or2_x1 83 82 1155 162 2517 or2_x1
xspare_buffer_20 83 82 2597 2596 buf_x4
xfeed_1118 83 82 decap_w0
xfeed_979 83 82 tie
xfeed_360 83 82 decap_w0
xfeed_113 83 82 tie
xsubckt_1008_nexor2_x0 83 82 2143 730 2095 nexor2_x0
xsubckt_379_nexor2_x0 83 82 480 2 476 nexor2_x0
xsubckt_1496_nand2_x0 83 82 2463 1619 1664 nand2_x0
xsubckt_2118_and21nor_x0 83 82 2415 1045 1046 763 and21nor_x0
xsubckt_2169_or21nand_x0 83 82 1003 1024 1012 1013 or21nand_x0
xspare_buffer_21 83 82 2597 2595 buf_x4
xfeed_363 83 82 tie
xfeed_110 83 82 decap_w0
xsubckt_1093_or21nand_x0 83 82 2012 2060 2054 2057 or21nand_x0
xsubckt_414_nand2_x0 83 82 443 445 0 nand2_x0
xsubckt_1484_or21nand_x0 83 82 1630 1681 1687 1691 or21nand_x0
xsubckt_1896_nand3_x0 83 82 1231 1255 366 703 nand3_x0
xsubckt_1991_nexor2_x0 83 82 694 769 1143 nexor2_x0
xsubckt_2403_dff_x1 83 82 2472 2595 35 dff_x1
xspare_buffer_22 83 82 2597 2594 buf_x4
xfeed_362 83 82 tie
xfeed_111 83 82 tie
xsubckt_105_inv_x0 83 82 8 708 inv_x0
xsubckt_1988_and3_x1 83 82 2444 1146 1150 1151 and3_x1
xspare_buffer_23 83 82 2544 2543 buf_x4
xfeed_365 83 82 tie
xfeed_116 83 82 tie
xfeed_8 83 82 tie
xsubckt_1688_nand2_x0 83 82 1431 1432 777 nand2_x0
xsubckt_1846_and3_x1 83 82 2452 1280 1281 762 and3_x1
xsubckt_1877_or3_x1 83 82 1250 1254 1255 2512 or3_x1
xsubckt_2100_mux2_x1 83 82 1057 1058 1073 2421 mux2_x1
xsubckt_2474_dff_x1 83 82 125 2595 103 dff_x1
xspare_buffer_24 83 82 2597 2593 buf_x4
xfeed_364 83 82 tie
xfeed_117 83 82 tie
xfeed_9 83 82 tie
xspare_buffer_25 83 82 2597 2592 buf_x4
xsubckt_686_and21nor_x0 83 82 181 183 198 30 and21nor_x0
xsubckt_1553_nand2_x0 83 82 1563 1565 1567 nand2_x0
xsubckt_2329_mux2_x1 83 82 748 731 606 852 mux2_x1
xdiode_29 83 82 25 diode_w1
xfeed_648 83 82 decap_w0
xfeed_367 83 82 decap_w0
xfeed_114 83 82 tie
xspare_buffer_26 83 82 2597 2591 buf_x4
xsubckt_1026_nand2_x0 83 82 2077 142 20 nand2_x0
xsubckt_1515_and2_x1 83 82 1600 1602 1603 and2_x1
xdiode_28 83 82 327 diode_w1
xfeed_649 83 82 decap_w0
xfeed_366 83 82 tie
xspare_buffer_27 83 82 2544 2542 buf_x4
xsubckt_1711_and21nor_x0 83 82 1409 1438 1444 1448 and21nor_x0
xsubckt_1867_or21nand_x0 83 82 1260 2517 777 774 or21nand_x0
xsubckt_1883_nand2_x0 83 82 1244 2121 286 nand2_x0
xdiode_27 83 82 327 diode_w1
xfeed_1111 83 82 decap_w0
xfeed_970 83 82 tie
xfeed_646 83 82 decap_w0
xfeed_369 83 82 tie
xfeed_4 83 82 tie
xspare_buffer_28 83 82 2597 2590 buf_x4
xsubckt_1082_nand2_x0 83 82 2023 2211 731 nand2_x0
xsubckt_540_nand2_x0 83 82 325 327 38 nand2_x0
xsubckt_1374_nand2_x0 83 82 1738 1740 607 nand2_x0
xsubckt_1878_nexor2_x0 83 82 1253 772 1249 nexor2_x0
xsubckt_1917_nexor2_x0 83 82 286 794 1210 nexor2_x0
xsubckt_1969_nand2_x0 83 82 1162 1164 1175 nand2_x0
xsubckt_2133_nand2_x0 83 82 1034 1035 762 nand2_x0
xdiode_26 83 82 327 diode_w1
xfeed_1110 83 82 decap_w0
xfeed_971 83 82 decap_w0
xfeed_647 83 82 decap_w0
xfeed_368 83 82 decap_w0
xfeed_5 83 82 tie
xspare_buffer_29 83 82 2597 2589 buf_x4
xsubckt_810_nexor2_x0 83 82 2294 27 2289 nexor2_x0
xsubckt_1291_nand3_x0 83 82 1819 1863 1886 79 nand3_x0
xdiode_25 83 82 93 diode_w1
xfeed_1113 83 82 decap_w0
xfeed_972 83 82 decap_w0
xfeed_644 83 82 decap_w0
xfeed_118 83 82 tie
xfeed_6 83 82 tie
xsubckt_1109_nand2_x0 83 82 1996 1997 335 nand2_x0
xsubckt_911_and3_x1 83 82 2190 2284 733 734 and3_x1
xsubckt_94_inv_x0 83 82 4 719 inv_x0
xsubckt_448_and2_x1 83 82 411 412 712 and2_x1
xsubckt_532_nand3_x0 83 82 332 93 811 812 nand3_x0
xsubckt_1921_nand4_x0 83 82 1206 1207 676 677 110 nand4_x0
xsubckt_2287_nand2_x0 83 82 891 73 74 nand2_x0
xdiode_24 83 82 93 diode_w1
xfeed_1112 83 82 decap_w0
xfeed_973 83 82 decap_w0
xfeed_645 83 82 decap_w0
xfeed_7 83 82 tie
xsubckt_676_nand3_x0 83 82 191 616 66 139 nand3_x0
xsubckt_166_and2_x1 83 82 117 660 2543 and2_x1
xsubckt_426_nand2_x0 83 82 432 617 13 nand2_x0
xsubckt_587_and3_x1 83 82 278 93 91 812 and3_x1
xsubckt_1889_and3_x1 83 82 1238 2160 286 361 and3_x1
xsubckt_2245_nexor2_x0 83 82 932 937 931 nexor2_x0
xdiode_23 83 82 93 diode_w1
xfeed_1115 83 82 decap_w0
xfeed_974 83 82 decap_w0
xfeed_642 83 82 tie
xfeed_0 83 82 decap_w0
xsubckt_825_nand4_x0 83 82 2274 718 93 811 812 nand4_x0
xsubckt_768_and3_x1 83 82 2330 2332 2343 28 and3_x1
xsubckt_253_and2_x1 83 82 595 783 27 and2_x1
xsubckt_539_or3_x1 83 82 326 142 93 162 or3_x1
xsubckt_1716_or21nand_x0 83 82 1404 1442 1444 1445 or21nand_x0
xdiode_22 83 82 37 diode_w1
xfeed_1114 83 82 decap_w0
xfeed_975 83 82 decap_w0
xfeed_643 83 82 decap_w0
xfeed_1 83 82 decap_w0
xsubckt_91_inv_x0 83 82 7 722 inv_x0
xsubckt_516_or21nand_x0 83 82 348 363 357 351 or21nand_x0
xsubckt_1315_mux2_x1 83 82 31 24 699 1796 mux2_x1
xsubckt_2046_nor2_x0 83 82 1094 1095 142 nor2_x0
xsubckt_2097_mux2_x1 83 82 1059 1060 1073 2422 mux2_x1
xsubckt_2156_mux2_x1 83 82 68 71 605 1015 mux2_x1
xsubckt_2265_and2_x1 83 82 912 915 42 and2_x1
xsubckt_2301_or21nand_x0 83 82 878 880 885 609 or21nand_x0
xdiode_21 83 82 37 diode_w1
xfeed_1117 83 82 decap_w0
xfeed_976 83 82 decap_w0
xfeed_640 83 82 tie
xfeed_2 83 82 decap_w0
xsubckt_1258_nand3_x0 83 82 1852 614 780 141 nand3_x0
xsubckt_1103_nand4_x0 83 82 2002 2143 728 729 730 nand4_x0
xsubckt_821_and21nor_x0 83 82 2278 334 2282 278 and21nor_x0
xsubckt_805_mux2_x1 83 82 66 2295 607 2294 mux2_x1
xsubckt_713_nand2_x0 83 82 2384 77 808 nand2_x0
xsubckt_32_inv_x0 83 82 31 780 inv_x0
xsubckt_413_and2_x1 83 82 444 446 715 and2_x1
xsubckt_456_mux2_x1 83 82 755 714 606 404 mux2_x1
xsubckt_1502_and2_x1 83 82 1613 36 141 and2_x1
xsubckt_1967_or21nand_x0 83 82 1164 1189 1186 1177 or21nand_x0
xsubckt_2261_or21nand_x0 83 82 916 937 934 933 or21nand_x0
xsubckt_2454_dff_x1 83 82 2424 2596 59 dff_x1
xdiode_20 83 82 37 diode_w1
xfeed_1116 83 82 decap_w0
xfeed_977 83 82 decap_w0
xfeed_641 83 82 tie
xfeed_3 83 82 decap_w0
xsubckt_287_and2_x1 83 82 563 567 7 and2_x1
xsubckt_575_and2_x1 83 82 290 162 2517 and2_x1
xfeed_710 83 82 tie
xfeed_228 83 82 tie
xsubckt_63_inv_x0 83 82 77 750 inv_x0
xsubckt_423_nand2_x0 83 82 434 435 436 nand2_x0
xsubckt_535_or3_x1 83 82 329 93 162 39 or3_x1
xsubckt_1510_nand2_x0 83 82 1605 1607 1608 nand2_x0
xsubckt_1712_or21nand_x0 83 82 1408 1439 1443 1447 or21nand_x0
xsubckt_2228_nexor2_x0 83 82 951 736 947 nexor2_x0
xsubckt_2269_xor2_x0 83 82 74 75 908 xor2_x0
xsubckt_2463_dff_x1 83 82 2415 2594 18 dff_x1
xsubckt_2489_dff_x1 83 82 114 2595 92 dff_x1
xspare_feed_13 83 82 tie
xfeed_711 83 82 tie
xsubckt_1466_and2_x1 83 82 1648 1649 1650 and2_x1
xspare_feed_12 83 82 tie
xfeed_712 83 82 tie
xsubckt_772_nexor2_x0 83 82 2331 783 2326 nexor2_x0
xsubckt_726_and21nor_x0 83 82 2371 2375 2389 782 and21nor_x0
xsubckt_344_nand2_x0 83 82 509 522 526 nand2_x0
xsubckt_2184_nand2_x0 83 82 989 617 738 nand2_x0
xsubckt_2379_dff_x1 83 82 2496 2548 5 dff_x1
xsubckt_2461_dff_x1 83 82 2417 2594 20 dff_x1
xspare_feed_11 83 82 tie
xfeed_713 83 82 decap_w0
xsubckt_1107_nexor2_x0 83 82 2044 11 1998 nexor2_x0
xsubckt_246_mux2_x1 83 82 29 38 605 602 mux2_x1
xsubckt_237_or3_x1 83 82 611 141 140 139 or3_x1
xsubckt_121_nor2_x0 83 82 695 2524 2523 nor2_x0
xsubckt_350_nand2_x0 83 82 503 506 509 nand2_x0
xsubckt_391_nand3_x0 83 82 465 614 35 141 nand3_x0
xsubckt_1641_mux2_x1 83 82 37 1479 607 1477 mux2_x1
xspare_feed_10 83 82 tie
xfeed_714 83 82 decap_w0
xsubckt_96_inv_x0 83 82 2 717 inv_x0
xsubckt_1326_nand3_x0 83 82 1785 616 784 139 nand3_x0
xsubckt_2318_and2_x1 83 82 862 863 609 and2_x1
xspare_feed_17 83 82 tie
xfeed_715 83 82 decap_w0
xsubckt_555_nand3_x0 83 82 310 616 68 139 nand3_x0
xsubckt_1619_and2_x1 83 82 1498 142 62 and2_x1
xsubckt_2104_nand3_x0 83 82 1054 644 159 157 nand3_x0
xspare_feed_16 83 82 tie
xfeed_1009 83 82 decap_w0
xfeed_899 83 82 tie
xfeed_716 83 82 decap_w0
xsubckt_887_nand2_x0 83 82 2214 699 731 nand2_x0
xsubckt_142_nand2_x0 83 82 674 698 162 nand2_x0
xsubckt_1557_nand3_x0 83 82 1559 1563 539 66 nand3_x0
xsubckt_2443_dff_x1 83 82 2435 2588 2507 dff_x1
xfeed_1008 83 82 decap_w0
xfeed_898 83 82 decap_w0
xfeed_717 83 82 tie
xsubckt_1240_and2_x1 83 82 1869 1870 1872 and2_x1
xsubckt_1091_nexor2_x0 83 82 2019 35 2014 nexor2_x0
xsubckt_1051_and2_x1 83 82 2053 2054 2056 and2_x1
xsubckt_770_and21nor_x0 83 82 2328 2332 2343 783 and21nor_x0
xsubckt_299_mux2_x1 83 82 782 761 606 552 mux2_x1
xsubckt_140_nand3_x0 83 82 676 680 798 799 nand3_x0
xsubckt_365_nand2_x0 83 82 489 35 36 nand2_x0
xsubckt_2297_nand2_x0 83 82 882 884 732 nand2_x0
xspare_feed_14 83 82 tie
xfeed_1007 83 82 decap_w0
xfeed_897 83 82 decap_w0
xfeed_718 83 82 tie
xfeed_220 83 82 decap_w0
xsubckt_1027_and2_x1 83 82 2076 327 37 and2_x1
xsubckt_988_nand2_x0 83 82 2115 2116 361 nand2_x0
xsubckt_502_nand4_x0 83 82 362 364 365 366 370 nand4_x0
xsubckt_1666_or21nand_x0 83 82 1453 35 141 140 or21nand_x0
xsubckt_1742_nexor2_x0 83 82 1385 75 1379 nexor2_x0
xfeed_1006 83 82 decap_w0
xfeed_896 83 82 decap_w0
xfeed_719 83 82 tie
xfeed_221 83 82 tie
xsubckt_1186_and21nor_x0 83 82 1921 290 1937 1922 and21nor_x0
xsubckt_1072_or21nand_x0 83 82 2032 2052 2053 265 or21nand_x0
xsubckt_738_nand2_x0 83 82 2359 2360 334 nand2_x0
xsubckt_199_and2_x1 83 82 639 80 159 and2_x1
xsubckt_2276_and2_x1 83 82 902 617 733 and2_x1
xfeed_1005 83 82 decap_w0
xfeed_895 83 82 decap_w0
xfeed_222 83 82 tie
xsubckt_1068_nand4_x0 83 82 2036 712 93 811 812 nand4_x0
xsubckt_1066_nand2_x0 83 82 2038 2039 332 nand2_x0
xsubckt_895_nand3_x0 83 82 2206 616 748 139 nand3_x0
xsubckt_544_nand4_x0 83 82 321 67 141 809 139 nand4_x0
xsubckt_638_and21nor_x0 83 82 228 335 233 278 and21nor_x0
xsubckt_1392_mux2_x1 83 82 1721 210 335 1720 mux2_x1
xspare_feed_19 83 82 tie
xfeed_1004 83 82 tie
xfeed_894 83 82 decap_w0
xfeed_223 83 82 decap_w0
xsubckt_660_nand2_x0 83 82 207 208 212 nand2_x0
xsubckt_279_and21nor_x0 83 82 571 598 584 587 and21nor_x0
xsubckt_462_nand2_x0 83 82 398 399 609 nand2_x0
xsubckt_1687_nand4_x0 83 82 1432 53 93 811 812 nand4_x0
xsubckt_2349_mux2_x1 83 82 746 731 606 834 mux2_x1
xspare_feed_18 83 82 tie
xfeed_1003 83 82 tie
xfeed_893 83 82 decap_w0
xfeed_224 83 82 decap_w0
xsubckt_1279_nand2_x0 83 82 1831 1833 607 nand2_x0
xsubckt_1089_and2_x1 83 82 2016 2019 35 and2_x1
xsubckt_1633_mux2_x1 83 82 24 32 139 1485 mux2_x1
xsubckt_2038_nand4_x0 83 82 1101 670 762 2510 777 nand4_x0
xsubckt_2138_and2_x1 83 82 2409 1031 1032 and2_x1
xfeed_1002 83 82 tie
xfeed_892 83 82 decap_w0
xfeed_225 83 82 tie
xsubckt_1167_nexor2_x0 83 82 1944 754 1940 nexor2_x0
xsubckt_756_mux2_x1 83 82 790 748 699 2342 mux2_x1
xsubckt_82_inv_x0 83 82 72 731 inv_x0
xsubckt_576_nand2_x0 83 82 289 162 2517 nand2_x0
xsubckt_1340_or21nand_x0 83 82 1771 1861 1822 1823 or21nand_x0
xsubckt_1342_nand2_x0 83 82 1769 1770 286 nand2_x0
xsubckt_1375_and21nor_x0 83 82 1737 1745 1742 1738 and21nor_x0
xsubckt_1804_nexor2_x0 83 82 1323 746 1319 nexor2_x0
xsubckt_1857_and2_x1 83 82 1269 1270 368 and2_x1
xsubckt_2167_nand2_x0 83 82 1005 617 739 nand2_x0
xsubckt_2277_mux2_x1 83 82 64 75 606 901 mux2_x1
xfeed_1001 83 82 decap_w0
xfeed_891 83 82 decap_w0
xfeed_226 83 82 tie
xsubckt_1044_and3_x1 83 82 2060 2066 2069 36 and3_x1
xsubckt_2070_or21nand_x0 83 82 1077 643 159 2502 or21nand_x0
xsubckt_2253_nexor2_x0 83 82 75 76 923 nexor2_x0
xfeed_1000 83 82 tie
xfeed_890 83 82 decap_w0
xfeed_227 83 82 tie
xsubckt_1032_mux2_x1 83 82 76 72 139 2072 mux2_x1
xsubckt_1730_and2_x1 83 82 1391 2212 314 and2_x1
xsubckt_1894_mux2_x1 83 82 810 808 809 1233 mux2_x1
xsubckt_2105_or21nand_x0 83 82 1053 638 84 22 or21nand_x0
xfeed_927 83 82 decap_w0
xfeed_574 83 82 tie
xfeed_48 83 82 tie
xsubckt_1242_nand4_x0 83 82 1867 31 808 140 810 nand4_x0
xsubckt_791_or21nand_x0 83 82 2307 2308 2310 285 or21nand_x0
xsubckt_2260_and2_x1 83 82 917 617 734 and2_x1
xfeed_926 83 82 decap_w0
xfeed_575 83 82 decap_w0
xsubckt_962_and4_x1 83 82 2140 2281 715 716 717 and4_x1
xsubckt_217_nand2_x0 83 82 147 627 628 nand2_x0
xsubckt_59_inv_x0 83 82 33 754 inv_x0
xsubckt_640_nand2_x0 83 82 226 227 332 nand2_x0
xsubckt_1524_and21nor_x0 83 82 1591 1633 1635 1638 and21nor_x0
xsubckt_1531_nand2_x0 83 82 1584 277 718 nand2_x0
xsubckt_2309_and21nor_x0 83 82 2398 871 877 886 and21nor_x0
xfeed_925 83 82 decap_w0
xfeed_576 83 82 decap_w0
xsubckt_349_nand3_x0 83 82 504 505 522 526 nand3_x0
xsubckt_1920_nexor2_x0 83 82 685 2522 1207 nexor2_x0
xsubckt_2166_nor2_x0 83 82 2406 1006 1017 nor2_x0
xsubckt_2279_and2_x1 83 82 899 900 733 and2_x1
xfeed_924 83 82 decap_w0
xfeed_577 83 82 decap_w0
xsubckt_1128_nand2_x0 83 82 1978 1980 755 nand2_x0
xsubckt_994_and21nor_x0 83 82 2109 76 141 139 and21nor_x0
xsubckt_992_nand2_x0 83 82 2111 2112 2119 nand2_x0
xsubckt_855_and21nor_x0 83 82 2245 2252 2264 761 and21nor_x0
xsubckt_1517_or21nand_x0 83 82 1598 1601 1604 554 or21nand_x0
xsubckt_1841_or21nand_x0 83 82 2453 1289 1285 1284 or21nand_x0
xfeed_619 83 82 decap_w0
xfeed_570 83 82 decap_w0
xsubckt_1194_and21nor_x0 83 82 1913 33 327 1916 and21nor_x0
xsubckt_1132_nand2_x0 83 82 1974 1980 34 nand2_x0
xsubckt_996_or2_x1 83 82 2107 2108 2110 or2_x1
xsubckt_984_nand2_x0 83 82 2119 2120 2122 nand2_x0
xsubckt_52_inv_x0 83 82 26 761 inv_x0
xsubckt_430_nand2_x0 83 82 428 429 713 nand2_x0
xfeed_571 83 82 tie
xsubckt_872_nexor2_x0 83 82 2281 717 2228 nexor2_x0
xsubckt_403_or2_x1 83 82 453 454 456 or2_x1
xsubckt_446_mux2_x1 83 82 35 32 606 413 mux2_x1
xsubckt_1445_nand2_x0 83 82 1668 1669 777 nand2_x0
xsubckt_2446_dff_x1 83 82 2432 2589 2504 dff_x1
xfeed_572 83 82 tie
xsubckt_1302_or2_x1 83 82 1808 1809 286 or2_x1
xfeed_920 83 82 tie
xfeed_573 83 82 tie
xsubckt_1214_or21nand_x0 83 82 1894 1895 1896 1900 or21nand_x0
xsubckt_755_nand3_x0 83 82 2343 614 67 141 nand3_x0
xsubckt_679_nand4_x0 83 82 188 790 808 140 810 nand4_x0
xsubckt_356_or21nand_x0 83 82 498 517 513 512 or21nand_x0
xsubckt_489_nand3_x0 83 82 375 614 78 141 nand3_x0
xsubckt_1430_or21nand_x0 83 82 1683 1686 1688 286 or21nand_x0
xfeed_615 83 82 decap_w0
xfeed_40 83 82 tie
xsubckt_45_inv_x0 83 82 86 767 inv_x0
xsubckt_609_nand4_x0 83 82 257 752 808 140 139 nand4_x0
xsubckt_1293_or21nand_x0 83 82 1817 1824 1822 1820 or21nand_x0
xsubckt_1640_nand2_x0 83 82 1478 1479 607 nand2_x0
xsubckt_1781_or21nand_x0 83 82 1341 1377 1378 1382 or21nand_x0
xsubckt_1792_and21nor_x0 83 82 1330 1363 1378 1381 and21nor_x0
xsubckt_2016_nand4_x0 83 82 1121 1122 676 677 110 nand4_x0
xsubckt_2452_dff_x1 83 82 2426 2595 61 dff_x1
xfeed_614 83 82 decap_w0
xfeed_41 83 82 tie
xsubckt_1938_nand3_x0 83 82 1191 1192 162 799 nand3_x0
xfeed_617 83 82 tie
xfeed_42 83 82 decap_w0
xsubckt_1159_and2_x1 83 82 1947 142 17 and2_x1
xsubckt_982_nand2_x0 83 82 2121 615 810 nand2_x0
xsubckt_1550_nand4_x0 83 82 1566 24 808 140 810 nand4_x0
xsubckt_2348_mux2_x1 83 82 73 72 606 835 mux2_x1
xfeed_616 83 82 tie
xfeed_43 83 82 tie
xsubckt_824_and21nor_x0 83 82 2275 2279 2278 2276 and21nor_x0
xsubckt_367_nor2_x0 83 82 487 488 490 nor2_x0
xsubckt_1459_nand3_x0 83 82 1655 1657 809 139 nand3_x0
xsubckt_1765_and4_x1 83 82 1357 1358 1535 314 360 and4_x1
xsubckt_2313_and2_x1 83 82 867 869 730 and2_x1
xfeed_611 83 82 decap_w0
xfeed_578 83 82 decap_w0
xfeed_44 83 82 decap_w0
xsubckt_900_or21nand_x0 83 82 2201 2208 2205 2202 or21nand_x0
xsubckt_545_and4_x1 83 82 320 753 808 140 139 and4_x1
xsubckt_1594_nand2_x0 83 82 1523 1524 1526 nand2_x0
xsubckt_1787_nand4_x0 83 82 1335 727 93 811 812 nand4_x0
xsubckt_2021_and21nor_x0 83 82 2440 1123 1120 1117 and21nor_x0
xsubckt_2168_and21nor_x0 83 82 1004 1025 1011 1014 and21nor_x0
xfeed_610 83 82 decap_w0
xfeed_579 83 82 decap_w0
xfeed_45 83 82 decap_w0
xsubckt_620_and21nor_x0 83 82 246 254 252 247 and21nor_x0
xsubckt_2302_or2_x1 83 82 877 878 879 or2_x1
xfeed_929 83 82 decap_w0
xfeed_613 83 82 decap_w0
xsubckt_1180_nand3_x0 83 82 1927 49 93 812 nand3_x0
xsubckt_924_or21nand_x0 83 82 2177 289 2191 2178 or21nand_x0
xsubckt_83_inv_x0 83 82 53 730 inv_x0
xsubckt_475_and2_x1 83 82 387 9 32 and2_x1
xsubckt_605_and3_x1 83 82 261 614 70 141 and3_x1
xfeed_928 83 82 decap_w0
xfeed_612 83 82 decap_w0
xsubckt_360_and2_x1 83 82 494 497 3 and2_x1
xsubckt_437_or21nand_x0 83 82 421 453 437 422 or21nand_x0
xsubckt_1450_nand2_x0 83 82 1664 327 68 nand2_x0
xsubckt_2054_nor3_x0 83 82 2436 1088 1089 1090 nor3_x0
xsubckt_2376_dff_x1 83 82 2499 2551 14 dff_x1
xsubckt_2484_dff_x1 83 82 134 2596 142 dff_x1
xfeed_277 83 82 tie
xspare_feed_62 83 82 tie
xsubckt_1958_nand2_x0 83 82 1172 681 2519 nand2_x0
xsubckt_2174_nexor2_x0 83 82 1002 47 998 nexor2_x0
xfeed_276 83 82 tie
xspare_feed_63 83 82 tie
xsubckt_1025_and21nor_x0 83 82 2078 286 2079 264 and21nor_x0
xsubckt_604_nand2_x0 83 82 262 327 31 nand2_x0
xfeed_419 83 82 decap_w0
xfeed_275 83 82 tie
xspare_feed_60 83 82 tie
xsubckt_977_or21nand_x0 83 82 2125 285 2126 265 or21nand_x0
xsubckt_14_inv_x0 83 82 2518 798 inv_x0
xsubckt_136_and4_x1 83 82 680 683 685 796 797 and4_x1
xsubckt_1663_and2_x1 83 82 1456 1613 614 and2_x1
xsubckt_2319_or21nand_x0 83 82 861 74 72 73 or21nand_x0
xfeed_418 83 82 tie
xfeed_274 83 82 tie
xspare_feed_61 83 82 tie
xsubckt_1234_nand2_x0 83 82 1875 1877 2212 nand2_x0
xsubckt_260_mux2_x1 83 82 28 31 605 589 mux2_x1
xsubckt_194_nand4_x0 83 82 643 742 80 81 2541 nand4_x0
xsubckt_181_mux2_x1 83 82 103 74 669 652 mux2_x1
xsubckt_1482_nexor2_x0 83 82 1634 1636 1632 nexor2_x0
xsubckt_1760_or21nand_x0 83 82 1361 285 1362 265 or21nand_x0
xsubckt_1837_and2_x1 83 82 1287 1288 1898 and2_x1
xsubckt_1990_nexor2_x0 83 82 1145 1225 1144 nexor2_x0
xsubckt_2259_and21nor_x0 83 82 2401 918 919 938 and21nor_x0
xfeed_273 83 82 tie
xspare_feed_66 83 82 tie
xsubckt_1081_and2_x1 83 82 2024 2025 2026 and2_x1
xsubckt_823_nand2_x0 83 82 2276 2277 332 nand2_x0
xsubckt_78_inv_x0 83 82 43 735 inv_x0
xsubckt_1381_and3_x1 83 82 1731 1736 603 70 and3_x1
xsubckt_1593_and2_x1 83 82 1524 1525 607 and2_x1
xsubckt_1709_nand2_x0 83 82 1411 1419 749 nand2_x0
xsubckt_2225_mux2_x1 83 82 791 751 606 950 mux2_x1
xsubckt_2467_dff_x1 83 82 112 2596 85 dff_x1
xspare_feed_67 83 82 tie
xsubckt_951_nand3_x0 83 82 2151 2158 2161 24 nand3_x0
xsubckt_835_or21nand_x0 83 82 2478 2265 2266 2301 or21nand_x0
xsubckt_646_or21nand_x0 83 82 220 289 235 221 or21nand_x0
xsubckt_512_nand4_x0 83 82 352 787 808 140 810 nand4_x0
xsubckt_1418_or21nand_x0 83 82 1695 1696 1699 1708 or21nand_x0
xsubckt_1766_and21nor_x0 83 82 1356 314 360 714 and21nor_x0
xsubckt_1902_and21nor_x0 83 82 1225 1226 1228 1229 and21nor_x0
xsubckt_2385_dff_x1 83 82 2490 2577 13 dff_x1
xfeed_868 83 82 tie
xfeed_271 83 82 tie
xspare_buffer_79 83 82 2529 2526 buf_x4
xspare_feed_64 83 82 tie
xsubckt_1097_or21nand_x0 83 82 2008 2050 2062 2063 or21nand_x0
xsubckt_1473_mux2_x1 83 82 784 1646 607 1641 mux2_x1
xsubckt_2359_nand2_x0 83 82 825 49 72 nand2_x0
xfeed_869 83 82 tie
xfeed_270 83 82 tie
xspare_buffer_78 83 82 2558 2549 buf_x4
xspare_feed_65 83 82 tie
xsubckt_1055_nexor2_x0 83 82 2051 2056 2049 nexor2_x0
xsubckt_875_nand2_x0 83 82 2225 2226 332 nand2_x0
xsubckt_746_and2_x1 83 82 2351 2352 285 and2_x1
xsubckt_616_and4_x1 83 82 250 789 808 140 810 and4_x1
xsubckt_1577_nand2_x0 83 82 1539 1540 1541 nand2_x0
xfeed_866 83 82 tie
xfeed_413 83 82 tie
xspare_buffer_77 83 82 2558 2550 buf_x4
xsubckt_1271_or21nand_x0 83 82 1839 1850 1846 1842 or21nand_x0
xsubckt_1231_nand2_x0 83 82 1878 28 141 nand2_x0
xsubckt_30_inv_x0 83 82 29 782 inv_x0
xsubckt_521_and2_x1 83 82 343 93 90 and2_x1
xsubckt_1756_and21nor_x0 83 82 1365 1375 1374 1366 and21nor_x0
xsubckt_1868_and3_x1 83 82 1259 2510 162 799 and3_x1
xsubckt_1925_nand2_x0 83 82 1203 1209 1211 nand2_x0
xsubckt_2372_nexor2_x0 83 82 814 731 813 nexor2_x0
xfeed_867 83 82 tie
xspare_buffer_76 83 82 2558 2551 buf_x4
xsubckt_1227_nand4_x0 83 82 1882 784 808 140 139 nand4_x0
xsubckt_983_nand2_x0 83 82 2120 701 747 nand2_x0
xsubckt_585_nor2_x0 83 82 280 54 55 nor2_x0
xsubckt_1573_and21nor_x0 83 82 1543 1590 1592 1595 and21nor_x0
xsubckt_1853_nand3_x0 83 82 1273 2212 314 792 nand3_x0
xsubckt_2141_mux2_x1 83 82 789 786 605 1029 mux2_x1
xsubckt_2162_nexor2_x0 83 82 1010 1024 1009 nexor2_x0
xfeed_864 83 82 decap_w0
xfeed_411 83 82 decap_w0
xspare_buffer_75 83 82 2529 2527 buf_x4
xspare_feed_68 83 82 tie
xsubckt_801_mux2_x1 83 82 75 74 141 2298 mux2_x1
xsubckt_729_nexor2_x0 83 82 2374 29 2368 nexor2_x0
xsubckt_610_mux2_x1 83 82 66 257 366 256 mux2_x1
xsubckt_1538_and21nor_x0 83 82 1577 286 1589 1578 and21nor_x0
xsubckt_1588_nand3_x0 83 82 1529 616 756 139 nand3_x0
xsubckt_1601_nexor2_x0 83 82 1522 752 1516 nexor2_x0
xsubckt_1647_nand3_x0 83 82 1471 1478 1489 64 nand3_x0
xsubckt_2469_dff_x1 83 82 130 2579 108 dff_x1
xsubckt_2483_dff_x1 83 82 116 2593 94 dff_x1
xfeed_865 83 82 tie
xspare_buffer_74 83 82 2558 2552 buf_x4
xspare_feed_69 83 82 tie
xsubckt_1474_and3_x1 83 82 1640 1642 568 68 and3_x1
xsubckt_1694_or21nand_x0 83 82 2458 1436 1428 1426 or21nand_x0
xsubckt_1929_nexor2_x0 83 82 1200 1203 1199 nexor2_x0
xfeed_862 83 82 decap_w0
xfeed_417 83 82 decap_w0
xspare_buffer_73 83 82 2558 2553 buf_x4
xsubckt_1161_or21nand_x0 83 82 2471 1952 1948 1946 or21nand_x0
xsubckt_975_or21nand_x0 83 82 2127 2176 2195 2196 or21nand_x0
xsubckt_1477_or21nand_x0 83 82 1637 1643 569 68 or21nand_x0
xsubckt_2242_and2_x1 83 82 934 935 735 and2_x1
xfeed_863 83 82 decap_w0
xfeed_416 83 82 tie
xspare_buffer_72 83 82 2558 2554 buf_x4
xsubckt_1261_nand2_x0 83 82 1849 1851 373 nand2_x0
xsubckt_1030_nand2_x0 83 82 2074 701 746 nand2_x0
xsubckt_68_inv_x0 83 82 89 745 inv_x0
xsubckt_149_and3_x1 83 82 669 92 766 86 and3_x1
xsubckt_363_nand2_x0 83 82 491 508 522 nand2_x0
xsubckt_1328_nand2_x0 83 82 1783 1785 1786 nand2_x0
xsubckt_1560_and3_x1 83 82 1556 1563 539 753 and3_x1
xsubckt_1660_and2_x1 83 82 1458 142 61 and2_x1
xfeed_860 83 82 decap_w0
xfeed_415 83 82 tie
xfeed_279 83 82 tie
xspare_buffer_71 83 82 2529 2528 buf_x4
xsubckt_264_and2_x1 83 82 585 588 723 and2_x1
xsubckt_1387_and21nor_x0 83 82 1725 1767 1774 1778 and21nor_x0
xsubckt_1823_or2_x1 83 82 1300 1301 1302 or2_x1
xfeed_861 83 82 tie
xfeed_414 83 82 tie
xfeed_278 83 82 tie
xspare_buffer_70 83 82 2558 2555 buf_x4
xsubckt_1136_nexor2_x0 83 82 1980 755 1970 nexor2_x0
xsubckt_1090_nand2_x0 83 82 2015 2019 35 nand2_x0
xsubckt_873_and21nor_x0 83 82 2227 335 2228 278 and21nor_x0
xsubckt_434_nexor2_x0 83 82 425 426 424 nexor2_x0
xsubckt_1362_nand2_x0 83 82 1750 25 141 nand2_x0
xsubckt_1487_nand2_x0 83 82 1627 277 719 nand2_x0
xsubckt_1720_or21nand_x0 83 82 1400 335 1401 332 or21nand_x0
xsubckt_1995_nand2_x0 83 82 1139 142 802 nand2_x0
xsubckt_2493_dff_x1 83 82 2409 2561 91 dff_x1
.ends cordic_top_cts_r
