* Coriolis Structural SPICE Driver
* Generated on Feb 03, 2026, 17:31
* Cell/Subckt "cordic_cor_opt".
*
* INTERF wr_axy_p
* INTERF wok_axy_p
* INTERF vss
* INTERF vdd
* INTERF rok_nxy_p
* INTERF rd_nxy_p
* INTERF raz
* INTERF ny_p[7]
* INTERF ny_p[6]
* INTERF ny_p[5]
* INTERF ny_p[4]
* INTERF ny_p[3]
* INTERF ny_p[2]
* INTERF ny_p[1]
* INTERF ny_p[0]
* INTERF nx_p[7]
* INTERF nx_p[6]
* INTERF nx_p[5]
* INTERF nx_p[4]
* INTERF nx_p[3]
* INTERF nx_p[2]
* INTERF nx_p[1]
* INTERF nx_p[0]
* INTERF data_p[7]
* INTERF data_p[6]
* INTERF data_p[5]
* INTERF data_p[4]
* INTERF data_p[3]
* INTERF data_p[2]
* INTERF data_p[1]
* INTERF data_p[0]
* INTERF ck

* Terminal models (aka standard cells) used througout all the hierarchy.
.include and21nor_x0.spi
.include and2_x1.spi
.include nand2_x0.spi
.include nand3_x0.spi
.include and3_x1.spi
.include inv_x0.spi
.include or21nand_x0.spi
.include nor2_x0.spi
.include mux2_x1.spi
.include nexor2_x0.spi
.include or2_x1.spi
.include dff_x1.spi
.include xor2_x0.spi
.include and4_x1.spi
.include nand4_x0.spi
.include nor4_x0.spi
.include or4_x1.spi
.include or3_x1.spi
.include nor3_x0.spi
.include zero_x1.spi
.include one_x1.spi

* Non-terminal models (part of the user's design hierarchy).

.subckt cordic_cor_opt 50 51 52 53 54 55 56 61 62 63 64 65 66 67 68 69 70 71 72 73 74 75 76 177 178 179 180 181 182 183 184 185
* NET     0 = zero_2
* NET     1 = zero_1
* NET     2 = ykc[9]
* NET     3 = ykc[8]
* NET     4 = ykc[7]
* NET     5 = ykc[6]
* NET     6 = ykc[5]
* NET     7 = ykc[4]
* NET     8 = ykc[3]
* NET     9 = ykc[2]
* NET    10 = ykc[15]
* NET    11 = ykc[14]
* NET    12 = ykc[13]
* NET    13 = ykc[12]
* NET    14 = ykc[11]
* NET    15 = ykc[10]
* NET    16 = ykc[1]
* NET    17 = ykc[0]
* NET    18 = y[6]
* NET    19 = y[5]
* NET    20 = y[4]
* NET    21 = y[3]
* NET    22 = y[2]
* NET    23 = y[15]
* NET    24 = y[1]
* NET    25 = y[0]
* NET    26 = xkc[9]
* NET    27 = xkc[8]
* NET    28 = xkc[7]
* NET    29 = xkc[6]
* NET    30 = xkc[5]
* NET    31 = xkc[4]
* NET    32 = xkc[3]
* NET    33 = xkc[2]
* NET    34 = xkc[15]
* NET    35 = xkc[14]
* NET    36 = xkc[13]
* NET    37 = xkc[12]
* NET    38 = xkc[11]
* NET    39 = xkc[10]
* NET    40 = xkc[1]
* NET    41 = xkc[0]
* NET    42 = x[6]
* NET    43 = x[5]
* NET    44 = x[4]
* NET    45 = x[3]
* NET    46 = x[2]
* NET    47 = x[15]
* NET    48 = x[1]
* NET    49 = x[0]
* NET    50 = wr_axy_p
* NET    51 = wok_axy_p
* NET    52 = vss
* NET    53 = vdd
* NET    54 = rok_nxy_p
* NET    55 = rd_nxy_p
* NET    56 = raz
* NET    57 = quadrant[1]
* NET    58 = quadrant[0]
* NET    59 = place
* NET    60 = one_0
* NET    61 = ny_p[7]
* NET    62 = ny_p[6]
* NET    63 = ny_p[5]
* NET    64 = ny_p[4]
* NET    65 = ny_p[3]
* NET    66 = ny_p[2]
* NET    67 = ny_p[1]
* NET    68 = ny_p[0]
* NET    69 = nx_p[7]
* NET    70 = nx_p[6]
* NET    71 = nx_p[5]
* NET    72 = nx_p[4]
* NET    73 = nx_p[3]
* NET    74 = nx_p[2]
* NET    75 = nx_p[1]
* NET    76 = nx_p[0]
* NET    77 = norm
* NET    78 = n_ykc[9]
* NET    79 = n_ykc[8]
* NET    80 = n_ykc[7]
* NET    81 = n_ykc[6]
* NET    82 = n_ykc[5]
* NET    83 = n_ykc[4]
* NET    84 = n_ykc[3]
* NET    85 = n_ykc[2]
* NET    86 = n_ykc[15]
* NET    87 = n_ykc[14]
* NET    88 = n_ykc[13]
* NET    89 = n_ykc[12]
* NET    90 = n_ykc[11]
* NET    91 = n_ykc[10]
* NET    92 = n_ykc[1]
* NET    93 = n_ykc[0]
* NET    94 = n_y[9]
* NET    95 = n_y[8]
* NET    96 = n_y[7]
* NET    97 = n_y[6]
* NET    98 = n_y[5]
* NET    99 = n_y[4]
* NET   100 = n_y[3]
* NET   101 = n_y[2]
* NET   102 = n_y[15]
* NET   103 = n_y[14]
* NET   104 = n_y[13]
* NET   105 = n_y[12]
* NET   106 = n_y[11]
* NET   107 = n_y[10]
* NET   108 = n_y[1]
* NET   109 = n_y[0]
* NET   110 = n_xkc[9]
* NET   111 = n_xkc[8]
* NET   112 = n_xkc[7]
* NET   113 = n_xkc[6]
* NET   114 = n_xkc[5]
* NET   115 = n_xkc[4]
* NET   116 = n_xkc[3]
* NET   117 = n_xkc[2]
* NET   118 = n_xkc[15]
* NET   119 = n_xkc[14]
* NET   120 = n_xkc[13]
* NET   121 = n_xkc[12]
* NET   122 = n_xkc[11]
* NET   123 = n_xkc[10]
* NET   124 = n_xkc[1]
* NET   125 = n_xkc[0]
* NET   126 = n_x[9]
* NET   127 = n_x[8]
* NET   128 = n_x[7]
* NET   129 = n_x[6]
* NET   130 = n_x[5]
* NET   131 = n_x[4]
* NET   132 = n_x[3]
* NET   133 = n_x[2]
* NET   134 = n_x[15]
* NET   135 = n_x[14]
* NET   136 = n_x[13]
* NET   137 = n_x[12]
* NET   138 = n_x[11]
* NET   139 = n_x[10]
* NET   140 = n_x[1]
* NET   141 = n_x[0]
* NET   142 = n_quadrant[1]
* NET   143 = n_quadrant[0]
* NET   144 = n_i[2]
* NET   145 = n_i[1]
* NET   146 = n_i[0]
* NET   147 = n_a[9]
* NET   148 = n_a[8]
* NET   149 = n_a[7]
* NET   150 = n_a[6]
* NET   151 = n_a[5]
* NET   152 = n_a[4]
* NET   153 = n_a[3]
* NET   154 = n_a[2]
* NET   155 = n_a[15]
* NET   156 = n_a[14]
* NET   157 = n_a[13]
* NET   158 = n_a[12]
* NET   159 = n_a[11]
* NET   160 = n_a[10]
* NET   161 = n_a[1]
* NET   162 = n_a[0]
* NET   163 = n0_put_0_0
* NET   164 = n0_place_0_0
* NET   165 = n0_norm_0_0
* NET   166 = n0_mkc_0_0
* NET   167 = n0_get_0_0
* NET   168 = n0_calc_0_0
* NET   169 = mkc
* NET   170 = idx_in[2]
* NET   171 = idx_in[1]
* NET   172 = idx_in[0]
* NET   173 = i[2]
* NET   174 = i[1]
* NET   175 = i[0]
* NET   176 = get
* NET   177 = data_p[7]
* NET   178 = data_p[6]
* NET   179 = data_p[5]
* NET   180 = data_p[4]
* NET   181 = data_p[3]
* NET   182 = data_p[2]
* NET   183 = data_p[1]
* NET   184 = data_p[0]
* NET   185 = ck
* NET   186 = calc
* NET   187 = abc_6150_new_n999
* NET   188 = abc_6150_new_n998
* NET   189 = abc_6150_new_n997
* NET   190 = abc_6150_new_n995
* NET   191 = abc_6150_new_n994
* NET   192 = abc_6150_new_n993
* NET   193 = abc_6150_new_n992
* NET   194 = abc_6150_new_n991
* NET   195 = abc_6150_new_n990
* NET   196 = abc_6150_new_n989
* NET   197 = abc_6150_new_n988
* NET   198 = abc_6150_new_n987
* NET   199 = abc_6150_new_n986
* NET   200 = abc_6150_new_n985
* NET   201 = abc_6150_new_n984
* NET   202 = abc_6150_new_n983
* NET   203 = abc_6150_new_n982
* NET   204 = abc_6150_new_n981
* NET   205 = abc_6150_new_n980
* NET   206 = abc_6150_new_n979
* NET   207 = abc_6150_new_n978
* NET   208 = abc_6150_new_n977
* NET   209 = abc_6150_new_n976
* NET   210 = abc_6150_new_n975
* NET   211 = abc_6150_new_n974
* NET   212 = abc_6150_new_n973
* NET   213 = abc_6150_new_n972
* NET   214 = abc_6150_new_n970
* NET   215 = abc_6150_new_n969
* NET   216 = abc_6150_new_n968
* NET   217 = abc_6150_new_n967
* NET   218 = abc_6150_new_n966
* NET   219 = abc_6150_new_n965
* NET   220 = abc_6150_new_n964
* NET   221 = abc_6150_new_n963
* NET   222 = abc_6150_new_n962
* NET   223 = abc_6150_new_n961
* NET   224 = abc_6150_new_n960
* NET   225 = abc_6150_new_n959
* NET   226 = abc_6150_new_n958
* NET   227 = abc_6150_new_n957
* NET   228 = abc_6150_new_n956
* NET   229 = abc_6150_new_n955
* NET   230 = abc_6150_new_n954
* NET   231 = abc_6150_new_n953
* NET   232 = abc_6150_new_n952
* NET   233 = abc_6150_new_n951
* NET   234 = abc_6150_new_n949
* NET   235 = abc_6150_new_n948
* NET   236 = abc_6150_new_n947
* NET   237 = abc_6150_new_n946
* NET   238 = abc_6150_new_n945
* NET   239 = abc_6150_new_n944
* NET   240 = abc_6150_new_n943
* NET   241 = abc_6150_new_n942
* NET   242 = abc_6150_new_n941
* NET   243 = abc_6150_new_n940
* NET   244 = abc_6150_new_n939
* NET   245 = abc_6150_new_n938
* NET   246 = abc_6150_new_n937
* NET   247 = abc_6150_new_n936
* NET   248 = abc_6150_new_n935
* NET   249 = abc_6150_new_n934
* NET   250 = abc_6150_new_n933
* NET   251 = abc_6150_new_n932
* NET   252 = abc_6150_new_n931
* NET   253 = abc_6150_new_n929
* NET   254 = abc_6150_new_n928
* NET   255 = abc_6150_new_n927
* NET   256 = abc_6150_new_n926
* NET   257 = abc_6150_new_n925
* NET   258 = abc_6150_new_n924
* NET   259 = abc_6150_new_n923
* NET   260 = abc_6150_new_n922
* NET   261 = abc_6150_new_n921
* NET   262 = abc_6150_new_n920
* NET   263 = abc_6150_new_n919
* NET   264 = abc_6150_new_n918
* NET   265 = abc_6150_new_n917
* NET   266 = abc_6150_new_n916
* NET   267 = abc_6150_new_n915
* NET   268 = abc_6150_new_n914
* NET   269 = abc_6150_new_n913
* NET   270 = abc_6150_new_n912
* NET   271 = abc_6150_new_n911
* NET   272 = abc_6150_new_n910
* NET   273 = abc_6150_new_n908
* NET   274 = abc_6150_new_n907
* NET   275 = abc_6150_new_n906
* NET   276 = abc_6150_new_n905
* NET   277 = abc_6150_new_n904
* NET   278 = abc_6150_new_n902
* NET   279 = abc_6150_new_n901
* NET   280 = abc_6150_new_n900
* NET   281 = abc_6150_new_n899
* NET   282 = abc_6150_new_n898
* NET   283 = abc_6150_new_n897
* NET   284 = abc_6150_new_n896
* NET   285 = abc_6150_new_n895
* NET   286 = abc_6150_new_n894
* NET   287 = abc_6150_new_n893
* NET   288 = abc_6150_new_n892
* NET   289 = abc_6150_new_n890
* NET   290 = abc_6150_new_n889
* NET   291 = abc_6150_new_n888
* NET   292 = abc_6150_new_n887
* NET   293 = abc_6150_new_n886
* NET   294 = abc_6150_new_n885
* NET   295 = abc_6150_new_n884
* NET   296 = abc_6150_new_n883
* NET   297 = abc_6150_new_n882
* NET   298 = abc_6150_new_n881
* NET   299 = abc_6150_new_n880
* NET   300 = abc_6150_new_n879
* NET   301 = abc_6150_new_n878
* NET   302 = abc_6150_new_n877
* NET   303 = abc_6150_new_n876
* NET   304 = abc_6150_new_n875
* NET   305 = abc_6150_new_n873
* NET   306 = abc_6150_new_n872
* NET   307 = abc_6150_new_n871
* NET   308 = abc_6150_new_n870
* NET   309 = abc_6150_new_n869
* NET   310 = abc_6150_new_n868
* NET   311 = abc_6150_new_n867
* NET   312 = abc_6150_new_n866
* NET   313 = abc_6150_new_n865
* NET   314 = abc_6150_new_n864
* NET   315 = abc_6150_new_n863
* NET   316 = abc_6150_new_n862
* NET   317 = abc_6150_new_n861
* NET   318 = abc_6150_new_n860
* NET   319 = abc_6150_new_n859
* NET   320 = abc_6150_new_n857
* NET   321 = abc_6150_new_n856
* NET   322 = abc_6150_new_n855
* NET   323 = abc_6150_new_n854
* NET   324 = abc_6150_new_n853
* NET   325 = abc_6150_new_n852
* NET   326 = abc_6150_new_n851
* NET   327 = abc_6150_new_n850
* NET   328 = abc_6150_new_n849
* NET   329 = abc_6150_new_n848
* NET   330 = abc_6150_new_n847
* NET   331 = abc_6150_new_n846
* NET   332 = abc_6150_new_n845
* NET   333 = abc_6150_new_n844
* NET   334 = abc_6150_new_n843
* NET   335 = abc_6150_new_n842
* NET   336 = abc_6150_new_n841
* NET   337 = abc_6150_new_n839
* NET   338 = abc_6150_new_n838
* NET   339 = abc_6150_new_n837
* NET   340 = abc_6150_new_n836
* NET   341 = abc_6150_new_n835
* NET   342 = abc_6150_new_n834
* NET   343 = abc_6150_new_n833
* NET   344 = abc_6150_new_n832
* NET   345 = abc_6150_new_n831
* NET   346 = abc_6150_new_n830
* NET   347 = abc_6150_new_n829
* NET   348 = abc_6150_new_n828
* NET   349 = abc_6150_new_n827
* NET   350 = abc_6150_new_n826
* NET   351 = abc_6150_new_n825
* NET   352 = abc_6150_new_n824
* NET   353 = abc_6150_new_n822
* NET   354 = abc_6150_new_n821
* NET   355 = abc_6150_new_n820
* NET   356 = abc_6150_new_n819
* NET   357 = abc_6150_new_n818
* NET   358 = abc_6150_new_n817
* NET   359 = abc_6150_new_n816
* NET   360 = abc_6150_new_n815
* NET   361 = abc_6150_new_n814
* NET   362 = abc_6150_new_n813
* NET   363 = abc_6150_new_n812
* NET   364 = abc_6150_new_n811
* NET   365 = abc_6150_new_n810
* NET   366 = abc_6150_new_n809
* NET   367 = abc_6150_new_n808
* NET   368 = abc_6150_new_n807
* NET   369 = abc_6150_new_n806
* NET   370 = abc_6150_new_n804
* NET   371 = abc_6150_new_n803
* NET   372 = abc_6150_new_n802
* NET   373 = abc_6150_new_n801
* NET   374 = abc_6150_new_n800
* NET   375 = abc_6150_new_n799
* NET   376 = abc_6150_new_n798
* NET   377 = abc_6150_new_n797
* NET   378 = abc_6150_new_n796
* NET   379 = abc_6150_new_n795
* NET   380 = abc_6150_new_n794
* NET   381 = abc_6150_new_n793
* NET   382 = abc_6150_new_n792
* NET   383 = abc_6150_new_n791
* NET   384 = abc_6150_new_n790
* NET   385 = abc_6150_new_n789
* NET   386 = abc_6150_new_n788
* NET   387 = abc_6150_new_n787
* NET   388 = abc_6150_new_n785
* NET   389 = abc_6150_new_n784
* NET   390 = abc_6150_new_n783
* NET   391 = abc_6150_new_n782
* NET   392 = abc_6150_new_n781
* NET   393 = abc_6150_new_n780
* NET   394 = abc_6150_new_n779
* NET   395 = abc_6150_new_n778
* NET   396 = abc_6150_new_n777
* NET   397 = abc_6150_new_n776
* NET   398 = abc_6150_new_n775
* NET   399 = abc_6150_new_n774
* NET   400 = abc_6150_new_n773
* NET   401 = abc_6150_new_n772
* NET   402 = abc_6150_new_n771
* NET   403 = abc_6150_new_n770
* NET   404 = abc_6150_new_n769
* NET   405 = abc_6150_new_n768
* NET   406 = abc_6150_new_n767
* NET   407 = abc_6150_new_n766
* NET   408 = abc_6150_new_n765
* NET   409 = abc_6150_new_n764
* NET   410 = abc_6150_new_n763
* NET   411 = abc_6150_new_n762
* NET   412 = abc_6150_new_n761
* NET   413 = abc_6150_new_n759
* NET   414 = abc_6150_new_n758
* NET   415 = abc_6150_new_n757
* NET   416 = abc_6150_new_n756
* NET   417 = abc_6150_new_n755
* NET   418 = abc_6150_new_n754
* NET   419 = abc_6150_new_n753
* NET   420 = abc_6150_new_n752
* NET   421 = abc_6150_new_n751
* NET   422 = abc_6150_new_n750
* NET   423 = abc_6150_new_n749
* NET   424 = abc_6150_new_n748
* NET   425 = abc_6150_new_n747
* NET   426 = abc_6150_new_n746
* NET   427 = abc_6150_new_n745
* NET   428 = abc_6150_new_n744
* NET   429 = abc_6150_new_n743
* NET   430 = abc_6150_new_n742
* NET   431 = abc_6150_new_n741
* NET   432 = abc_6150_new_n739
* NET   433 = abc_6150_new_n738
* NET   434 = abc_6150_new_n737
* NET   435 = abc_6150_new_n736
* NET   436 = abc_6150_new_n735
* NET   437 = abc_6150_new_n734
* NET   438 = abc_6150_new_n733
* NET   439 = abc_6150_new_n732
* NET   440 = abc_6150_new_n731
* NET   441 = abc_6150_new_n730
* NET   442 = abc_6150_new_n729
* NET   443 = abc_6150_new_n728
* NET   444 = abc_6150_new_n727
* NET   445 = abc_6150_new_n726
* NET   446 = abc_6150_new_n725
* NET   447 = abc_6150_new_n724
* NET   448 = abc_6150_new_n723
* NET   449 = abc_6150_new_n722
* NET   450 = abc_6150_new_n721
* NET   451 = abc_6150_new_n720
* NET   452 = abc_6150_new_n719
* NET   453 = abc_6150_new_n718
* NET   454 = abc_6150_new_n717
* NET   455 = abc_6150_new_n716
* NET   456 = abc_6150_new_n714
* NET   457 = abc_6150_new_n713
* NET   458 = abc_6150_new_n712
* NET   459 = abc_6150_new_n711
* NET   460 = abc_6150_new_n710
* NET   461 = abc_6150_new_n709
* NET   462 = abc_6150_new_n708
* NET   463 = abc_6150_new_n707
* NET   464 = abc_6150_new_n706
* NET   465 = abc_6150_new_n705
* NET   466 = abc_6150_new_n704
* NET   467 = abc_6150_new_n703
* NET   468 = abc_6150_new_n702
* NET   469 = abc_6150_new_n701
* NET   470 = abc_6150_new_n700
* NET   471 = abc_6150_new_n699
* NET   472 = abc_6150_new_n698
* NET   473 = abc_6150_new_n697
* NET   474 = abc_6150_new_n695
* NET   475 = abc_6150_new_n694
* NET   476 = abc_6150_new_n693
* NET   477 = abc_6150_new_n692
* NET   478 = abc_6150_new_n691
* NET   479 = abc_6150_new_n690
* NET   480 = abc_6150_new_n689
* NET   481 = abc_6150_new_n688
* NET   482 = abc_6150_new_n687
* NET   483 = abc_6150_new_n686
* NET   484 = abc_6150_new_n685
* NET   485 = abc_6150_new_n684
* NET   486 = abc_6150_new_n683
* NET   487 = abc_6150_new_n682
* NET   488 = abc_6150_new_n681
* NET   489 = abc_6150_new_n680
* NET   490 = abc_6150_new_n679
* NET   491 = abc_6150_new_n678
* NET   492 = abc_6150_new_n677
* NET   493 = abc_6150_new_n676
* NET   494 = abc_6150_new_n675
* NET   495 = abc_6150_new_n674
* NET   496 = abc_6150_new_n673
* NET   497 = abc_6150_new_n672
* NET   498 = abc_6150_new_n670
* NET   499 = abc_6150_new_n669
* NET   500 = abc_6150_new_n668
* NET   501 = abc_6150_new_n667
* NET   502 = abc_6150_new_n666
* NET   503 = abc_6150_new_n665
* NET   504 = abc_6150_new_n664
* NET   505 = abc_6150_new_n663
* NET   506 = abc_6150_new_n662
* NET   507 = abc_6150_new_n661
* NET   508 = abc_6150_new_n660
* NET   509 = abc_6150_new_n659
* NET   510 = abc_6150_new_n658
* NET   511 = abc_6150_new_n657
* NET   512 = abc_6150_new_n656
* NET   513 = abc_6150_new_n655
* NET   514 = abc_6150_new_n654
* NET   515 = abc_6150_new_n653
* NET   516 = abc_6150_new_n652
* NET   517 = abc_6150_new_n651
* NET   518 = abc_6150_new_n649
* NET   519 = abc_6150_new_n648
* NET   520 = abc_6150_new_n647
* NET   521 = abc_6150_new_n646
* NET   522 = abc_6150_new_n645
* NET   523 = abc_6150_new_n644
* NET   524 = abc_6150_new_n643
* NET   525 = abc_6150_new_n642
* NET   526 = abc_6150_new_n641
* NET   527 = abc_6150_new_n640
* NET   528 = abc_6150_new_n639
* NET   529 = abc_6150_new_n638
* NET   530 = abc_6150_new_n637
* NET   531 = abc_6150_new_n636
* NET   532 = abc_6150_new_n635
* NET   533 = abc_6150_new_n634
* NET   534 = abc_6150_new_n633
* NET   535 = abc_6150_new_n632
* NET   536 = abc_6150_new_n631
* NET   537 = abc_6150_new_n629
* NET   538 = abc_6150_new_n628
* NET   539 = abc_6150_new_n627
* NET   540 = abc_6150_new_n626
* NET   541 = abc_6150_new_n625
* NET   542 = abc_6150_new_n624
* NET   543 = abc_6150_new_n623
* NET   544 = abc_6150_new_n622
* NET   545 = abc_6150_new_n621
* NET   546 = abc_6150_new_n620
* NET   547 = abc_6150_new_n619
* NET   548 = abc_6150_new_n618
* NET   549 = abc_6150_new_n617
* NET   550 = abc_6150_new_n616
* NET   551 = abc_6150_new_n615
* NET   552 = abc_6150_new_n613
* NET   553 = abc_6150_new_n612
* NET   554 = abc_6150_new_n611
* NET   555 = abc_6150_new_n610
* NET   556 = abc_6150_new_n609
* NET   557 = abc_6150_new_n608
* NET   558 = abc_6150_new_n607
* NET   559 = abc_6150_new_n606
* NET   560 = abc_6150_new_n605
* NET   561 = abc_6150_new_n604
* NET   562 = abc_6150_new_n603
* NET   563 = abc_6150_new_n602
* NET   564 = abc_6150_new_n601
* NET   565 = abc_6150_new_n600
* NET   566 = abc_6150_new_n599
* NET   567 = abc_6150_new_n598
* NET   568 = abc_6150_new_n597
* NET   569 = abc_6150_new_n595
* NET   570 = abc_6150_new_n594
* NET   571 = abc_6150_new_n592
* NET   572 = abc_6150_new_n591
* NET   573 = abc_6150_new_n589
* NET   574 = abc_6150_new_n588
* NET   575 = abc_6150_new_n587
* NET   576 = abc_6150_new_n585
* NET   577 = abc_6150_new_n584
* NET   578 = abc_6150_new_n583
* NET   579 = abc_6150_new_n582
* NET   580 = abc_6150_new_n581
* NET   581 = abc_6150_new_n579
* NET   582 = abc_6150_new_n578
* NET   583 = abc_6150_new_n577
* NET   584 = abc_6150_new_n576
* NET   585 = abc_6150_new_n575
* NET   586 = abc_6150_new_n574
* NET   587 = abc_6150_new_n573
* NET   588 = abc_6150_new_n572
* NET   589 = abc_6150_new_n571
* NET   590 = abc_6150_new_n570
* NET   591 = abc_6150_new_n569
* NET   592 = abc_6150_new_n568
* NET   593 = abc_6150_new_n567
* NET   594 = abc_6150_new_n566
* NET   595 = abc_6150_new_n564
* NET   596 = abc_6150_new_n563
* NET   597 = abc_6150_new_n562
* NET   598 = abc_6150_new_n561
* NET   599 = abc_6150_new_n560
* NET   600 = abc_6150_new_n559
* NET   601 = abc_6150_new_n557
* NET   602 = abc_6150_new_n556
* NET   603 = abc_6150_new_n555
* NET   604 = abc_6150_new_n554
* NET   605 = abc_6150_new_n553
* NET   606 = abc_6150_new_n552
* NET   607 = abc_6150_new_n551
* NET   608 = abc_6150_new_n550
* NET   609 = abc_6150_new_n549
* NET   610 = abc_6150_new_n548
* NET   611 = abc_6150_new_n546
* NET   612 = abc_6150_new_n545
* NET   613 = abc_6150_new_n544
* NET   614 = abc_6150_new_n543
* NET   615 = abc_6150_new_n542
* NET   616 = abc_6150_new_n540
* NET   617 = abc_6150_new_n539
* NET   618 = abc_6150_new_n538
* NET   619 = abc_6150_new_n537
* NET   620 = abc_6150_new_n536
* NET   621 = abc_6150_new_n535
* NET   622 = abc_6150_new_n534
* NET   623 = abc_6150_new_n533
* NET   624 = abc_6150_new_n532
* NET   625 = abc_6150_new_n531
* NET   626 = abc_6150_new_n530
* NET   627 = abc_6150_new_n529
* NET   628 = abc_6150_new_n528
* NET   629 = abc_6150_new_n526
* NET   630 = abc_6150_new_n525
* NET   631 = abc_6150_new_n524
* NET   632 = abc_6150_new_n523
* NET   633 = abc_6150_new_n522
* NET   634 = abc_6150_new_n521
* NET   635 = abc_6150_new_n520
* NET   636 = abc_6150_new_n519
* NET   637 = abc_6150_new_n518
* NET   638 = abc_6150_new_n517
* NET   639 = abc_6150_new_n516
* NET   640 = abc_6150_new_n515
* NET   641 = abc_6150_new_n513
* NET   642 = abc_6150_new_n512
* NET   643 = abc_6150_new_n511
* NET   644 = abc_6150_new_n510
* NET   645 = abc_6150_new_n509
* NET   646 = abc_6150_new_n508
* NET   647 = abc_6150_new_n507
* NET   648 = abc_6150_new_n506
* NET   649 = abc_6150_new_n505
* NET   650 = abc_6150_new_n504
* NET   651 = abc_6150_new_n503
* NET   652 = abc_6150_new_n501
* NET   653 = abc_6150_new_n500
* NET   654 = abc_6150_new_n499
* NET   655 = abc_6150_new_n498
* NET   656 = abc_6150_new_n497
* NET   657 = abc_6150_new_n496
* NET   658 = abc_6150_new_n495
* NET   659 = abc_6150_new_n494
* NET   660 = abc_6150_new_n493
* NET   661 = abc_6150_new_n492
* NET   662 = abc_6150_new_n491
* NET   663 = abc_6150_new_n489
* NET   664 = abc_6150_new_n488
* NET   665 = abc_6150_new_n487
* NET   666 = abc_6150_new_n486
* NET   667 = abc_6150_new_n485
* NET   668 = abc_6150_new_n484
* NET   669 = abc_6150_new_n483
* NET   670 = abc_6150_new_n482
* NET   671 = abc_6150_new_n481
* NET   672 = abc_6150_new_n480
* NET   673 = abc_6150_new_n479
* NET   674 = abc_6150_new_n478
* NET   675 = abc_6150_new_n477
* NET   676 = abc_6150_new_n476
* NET   677 = abc_6150_new_n475
* NET   678 = abc_6150_new_n474
* NET   679 = abc_6150_new_n473
* NET   680 = abc_6150_new_n472
* NET   681 = abc_6150_new_n471
* NET   682 = abc_6150_new_n470
* NET   683 = abc_6150_new_n469
* NET   684 = abc_6150_new_n468
* NET   685 = abc_6150_new_n467
* NET   686 = abc_6150_new_n466
* NET   687 = abc_6150_new_n465
* NET   688 = abc_6150_new_n463
* NET   689 = abc_6150_new_n462
* NET   690 = abc_6150_new_n461
* NET   691 = abc_6150_new_n460
* NET   692 = abc_6150_new_n459
* NET   693 = abc_6150_new_n458
* NET   694 = abc_6150_new_n457
* NET   695 = abc_6150_new_n456
* NET   696 = abc_6150_new_n455
* NET   697 = abc_6150_new_n454
* NET   698 = abc_6150_new_n453
* NET   699 = abc_6150_new_n452
* NET   700 = abc_6150_new_n451
* NET   701 = abc_6150_new_n450
* NET   702 = abc_6150_new_n449
* NET   703 = abc_6150_new_n448
* NET   704 = abc_6150_new_n447
* NET   705 = abc_6150_new_n446
* NET   706 = abc_6150_new_n445
* NET   707 = abc_6150_new_n444
* NET   708 = abc_6150_new_n442
* NET   709 = abc_6150_new_n441
* NET   710 = abc_6150_new_n440
* NET   711 = abc_6150_new_n439
* NET   712 = abc_6150_new_n438
* NET   713 = abc_6150_new_n437
* NET   714 = abc_6150_new_n436
* NET   715 = abc_6150_new_n435
* NET   716 = abc_6150_new_n434
* NET   717 = abc_6150_new_n433
* NET   718 = abc_6150_new_n432
* NET   719 = abc_6150_new_n431
* NET   720 = abc_6150_new_n430
* NET   721 = abc_6150_new_n429
* NET   722 = abc_6150_new_n428
* NET   723 = abc_6150_new_n427
* NET   724 = abc_6150_new_n426
* NET   725 = abc_6150_new_n425
* NET   726 = abc_6150_new_n424
* NET   727 = abc_6150_new_n423
* NET   728 = abc_6150_new_n422
* NET   729 = abc_6150_new_n421
* NET   730 = abc_6150_new_n419
* NET   731 = abc_6150_new_n418
* NET   732 = abc_6150_new_n417
* NET   733 = abc_6150_new_n416
* NET   734 = abc_6150_new_n415
* NET   735 = abc_6150_new_n414
* NET   736 = abc_6150_new_n413
* NET   737 = abc_6150_new_n412
* NET   738 = abc_6150_new_n411
* NET   739 = abc_6150_new_n410
* NET   740 = abc_6150_new_n409
* NET   741 = abc_6150_new_n408
* NET   742 = abc_6150_new_n407
* NET   743 = abc_6150_new_n406
* NET   744 = abc_6150_new_n405
* NET   745 = abc_6150_new_n404
* NET   746 = abc_6150_new_n403
* NET   747 = abc_6150_new_n402
* NET   748 = abc_6150_new_n401
* NET   749 = abc_6150_new_n400
* NET   750 = abc_6150_new_n399
* NET   751 = abc_6150_new_n398
* NET   752 = abc_6150_new_n397
* NET   753 = abc_6150_new_n396
* NET   754 = abc_6150_new_n394
* NET   755 = abc_6150_new_n393
* NET   756 = abc_6150_new_n392
* NET   757 = abc_6150_new_n391
* NET   758 = abc_6150_new_n390
* NET   759 = abc_6150_new_n389
* NET   760 = abc_6150_new_n388
* NET   761 = abc_6150_new_n387
* NET   762 = abc_6150_new_n386
* NET   763 = abc_6150_new_n385
* NET   764 = abc_6150_new_n384
* NET   765 = abc_6150_new_n383
* NET   766 = abc_6150_new_n382
* NET   767 = abc_6150_new_n381
* NET   768 = abc_6150_new_n380
* NET   769 = abc_6150_new_n379
* NET   770 = abc_6150_new_n378
* NET   771 = abc_6150_new_n377
* NET   772 = abc_6150_new_n376
* NET   773 = abc_6150_new_n375
* NET   774 = abc_6150_new_n374
* NET   775 = abc_6150_new_n373
* NET   776 = abc_6150_new_n372
* NET   777 = abc_6150_new_n371
* NET   778 = abc_6150_new_n370
* NET   779 = abc_6150_new_n368
* NET   780 = abc_6150_new_n367
* NET   781 = abc_6150_new_n366
* NET   782 = abc_6150_new_n365
* NET   783 = abc_6150_new_n364
* NET   784 = abc_6150_new_n363
* NET   785 = abc_6150_new_n362
* NET   786 = abc_6150_new_n361
* NET   787 = abc_6150_new_n360
* NET   788 = abc_6150_new_n359
* NET   789 = abc_6150_new_n358
* NET   790 = abc_6150_new_n357
* NET   791 = abc_6150_new_n356
* NET   792 = abc_6150_new_n355
* NET   793 = abc_6150_new_n354
* NET   794 = abc_6150_new_n353
* NET   795 = abc_6150_new_n352
* NET   796 = abc_6150_new_n351
* NET   797 = abc_6150_new_n350
* NET   798 = abc_6150_new_n349
* NET   799 = abc_6150_new_n348
* NET   800 = abc_6150_new_n347
* NET   801 = abc_6150_new_n346
* NET   802 = abc_6150_new_n345
* NET   803 = abc_6150_new_n344
* NET   804 = abc_6150_new_n342
* NET   805 = abc_6150_new_n341
* NET   806 = abc_6150_new_n340
* NET   807 = abc_6150_new_n339
* NET   808 = abc_6150_new_n338
* NET   809 = abc_6150_new_n337
* NET   810 = abc_6150_new_n336
* NET   811 = abc_6150_new_n335
* NET   812 = abc_6150_new_n334
* NET   813 = abc_6150_new_n333
* NET   814 = abc_6150_new_n332
* NET   815 = abc_6150_new_n331
* NET   816 = abc_6150_new_n329
* NET   817 = abc_6150_new_n327
* NET   818 = abc_6150_new_n326
* NET   819 = abc_6150_new_n325
* NET   820 = abc_6150_new_n324
* NET   821 = abc_6150_new_n323
* NET   822 = abc_6150_new_n322
* NET   823 = abc_6150_new_n321
* NET   824 = abc_6150_new_n320
* NET   825 = abc_6150_new_n319
* NET   826 = abc_6150_new_n318
* NET   827 = abc_6150_new_n317
* NET   828 = abc_6150_new_n316
* NET   829 = abc_6150_new_n315
* NET   830 = abc_6150_new_n314
* NET   831 = abc_6150_new_n313
* NET   832 = abc_6150_new_n312
* NET   833 = abc_6150_new_n311
* NET   834 = abc_6150_new_n310
* NET   835 = abc_6150_new_n309
* NET   836 = abc_6150_new_n308
* NET   837 = abc_6150_new_n307
* NET   838 = abc_6150_new_n306
* NET   839 = abc_6150_new_n305
* NET   840 = abc_6150_new_n304
* NET   841 = abc_6150_new_n303
* NET   842 = abc_6150_new_n302
* NET   843 = abc_6150_new_n301
* NET   844 = abc_6150_new_n300
* NET   845 = abc_6150_new_n299
* NET   846 = abc_6150_new_n298
* NET   847 = abc_6150_new_n297
* NET   848 = abc_6150_new_n296
* NET   849 = abc_6150_new_n295
* NET   850 = abc_6150_new_n294
* NET   851 = abc_6150_new_n293
* NET   852 = abc_6150_new_n292
* NET   853 = abc_6150_new_n291
* NET   854 = abc_6150_new_n290
* NET   855 = abc_6150_new_n289
* NET   856 = abc_6150_new_n288
* NET   857 = abc_6150_new_n287
* NET   858 = abc_6150_new_n286
* NET   859 = abc_6150_new_n285
* NET   860 = abc_6150_new_n284
* NET   861 = abc_6150_new_n283
* NET   862 = abc_6150_new_n282
* NET   863 = abc_6150_new_n281
* NET   864 = abc_6150_new_n280
* NET   865 = abc_6150_new_n279
* NET   866 = abc_6150_new_n278
* NET   867 = abc_6150_new_n277
* NET   868 = abc_6150_new_n276
* NET   869 = abc_6150_new_n275
* NET   870 = abc_6150_new_n274
* NET   871 = abc_6150_new_n273
* NET   872 = abc_6150_new_n272
* NET   873 = abc_6150_new_n271
* NET   874 = abc_6150_new_n270
* NET   875 = abc_6150_new_n269
* NET   876 = abc_6150_new_n268
* NET   877 = abc_6150_new_n267
* NET   878 = abc_6150_new_n266
* NET   879 = abc_6150_new_n265
* NET   880 = abc_6150_new_n264
* NET   881 = abc_6150_new_n263
* NET   882 = abc_6150_new_n262
* NET   883 = abc_6150_new_n261
* NET   884 = abc_6150_new_n260
* NET   885 = abc_6150_new_n259
* NET   886 = abc_6150_new_n258
* NET   887 = abc_6150_new_n2573
* NET   888 = abc_6150_new_n2572
* NET   889 = abc_6150_new_n2571
* NET   890 = abc_6150_new_n2570
* NET   891 = abc_6150_new_n257
* NET   892 = abc_6150_new_n2569
* NET   893 = abc_6150_new_n2568
* NET   894 = abc_6150_new_n2566
* NET   895 = abc_6150_new_n2565
* NET   896 = abc_6150_new_n2563
* NET   897 = abc_6150_new_n2562
* NET   898 = abc_6150_new_n2561
* NET   899 = abc_6150_new_n2560
* NET   900 = abc_6150_new_n256
* NET   901 = abc_6150_new_n2559
* NET   902 = abc_6150_new_n2558
* NET   903 = abc_6150_new_n2556
* NET   904 = abc_6150_new_n2555
* NET   905 = abc_6150_new_n2553
* NET   906 = abc_6150_new_n2552
* NET   907 = abc_6150_new_n2551
* NET   908 = abc_6150_new_n255
* NET   909 = abc_6150_new_n2548
* NET   910 = abc_6150_new_n2546
* NET   911 = abc_6150_new_n2545
* NET   912 = abc_6150_new_n2544
* NET   913 = abc_6150_new_n2543
* NET   914 = abc_6150_new_n2542
* NET   915 = abc_6150_new_n2541
* NET   916 = abc_6150_new_n2540
* NET   917 = abc_6150_new_n254
* NET   918 = abc_6150_new_n2539
* NET   919 = abc_6150_new_n2538
* NET   920 = abc_6150_new_n2537
* NET   921 = abc_6150_new_n2536
* NET   922 = abc_6150_new_n2535
* NET   923 = abc_6150_new_n2534
* NET   924 = abc_6150_new_n2533
* NET   925 = abc_6150_new_n2532
* NET   926 = abc_6150_new_n2530
* NET   927 = abc_6150_new_n253
* NET   928 = abc_6150_new_n2529
* NET   929 = abc_6150_new_n2528
* NET   930 = abc_6150_new_n2527
* NET   931 = abc_6150_new_n2526
* NET   932 = abc_6150_new_n2525
* NET   933 = abc_6150_new_n2524
* NET   934 = abc_6150_new_n2523
* NET   935 = abc_6150_new_n2522
* NET   936 = abc_6150_new_n2521
* NET   937 = abc_6150_new_n2520
* NET   938 = abc_6150_new_n252
* NET   939 = abc_6150_new_n2519
* NET   940 = abc_6150_new_n2518
* NET   941 = abc_6150_new_n2517
* NET   942 = abc_6150_new_n2516
* NET   943 = abc_6150_new_n2515
* NET   944 = abc_6150_new_n2514
* NET   945 = abc_6150_new_n2513
* NET   946 = abc_6150_new_n2512
* NET   947 = abc_6150_new_n2511
* NET   948 = abc_6150_new_n2510
* NET   949 = abc_6150_new_n251
* NET   950 = abc_6150_new_n2509
* NET   951 = abc_6150_new_n2508
* NET   952 = abc_6150_new_n2506
* NET   953 = abc_6150_new_n2505
* NET   954 = abc_6150_new_n2504
* NET   955 = abc_6150_new_n2503
* NET   956 = abc_6150_new_n2502
* NET   957 = abc_6150_new_n2501
* NET   958 = abc_6150_new_n2500
* NET   959 = abc_6150_new_n250
* NET   960 = abc_6150_new_n2499
* NET   961 = abc_6150_new_n2498
* NET   962 = abc_6150_new_n2497
* NET   963 = abc_6150_new_n2496
* NET   964 = abc_6150_new_n2495
* NET   965 = abc_6150_new_n2494
* NET   966 = abc_6150_new_n2493
* NET   967 = abc_6150_new_n2492
* NET   968 = abc_6150_new_n2491
* NET   969 = abc_6150_new_n2490
* NET   970 = abc_6150_new_n249
* NET   971 = abc_6150_new_n2489
* NET   972 = abc_6150_new_n2488
* NET   973 = abc_6150_new_n2487
* NET   974 = abc_6150_new_n2486
* NET   975 = abc_6150_new_n2485
* NET   976 = abc_6150_new_n2484
* NET   977 = abc_6150_new_n2483
* NET   978 = abc_6150_new_n2482
* NET   979 = abc_6150_new_n2481
* NET   980 = abc_6150_new_n2480
* NET   981 = abc_6150_new_n248
* NET   982 = abc_6150_new_n2479
* NET   983 = abc_6150_new_n2478
* NET   984 = abc_6150_new_n2477
* NET   985 = abc_6150_new_n2476
* NET   986 = abc_6150_new_n2475
* NET   987 = abc_6150_new_n2474
* NET   988 = abc_6150_new_n2472
* NET   989 = abc_6150_new_n2471
* NET   990 = abc_6150_new_n2470
* NET   991 = abc_6150_new_n247
* NET   992 = abc_6150_new_n2469
* NET   993 = abc_6150_new_n2468
* NET   994 = abc_6150_new_n2467
* NET   995 = abc_6150_new_n2466
* NET   996 = abc_6150_new_n2465
* NET   997 = abc_6150_new_n2464
* NET   998 = abc_6150_new_n2463
* NET   999 = abc_6150_new_n2462
* NET  1000 = abc_6150_new_n2461
* NET  1001 = abc_6150_new_n2460
* NET  1002 = abc_6150_new_n246
* NET  1003 = abc_6150_new_n2459
* NET  1004 = abc_6150_new_n2458
* NET  1005 = abc_6150_new_n2457
* NET  1006 = abc_6150_new_n2456
* NET  1007 = abc_6150_new_n2455
* NET  1008 = abc_6150_new_n2454
* NET  1009 = abc_6150_new_n2453
* NET  1010 = abc_6150_new_n2452
* NET  1011 = abc_6150_new_n2451
* NET  1012 = abc_6150_new_n2450
* NET  1013 = abc_6150_new_n245
* NET  1014 = abc_6150_new_n2449
* NET  1015 = abc_6150_new_n2448
* NET  1016 = abc_6150_new_n2447
* NET  1017 = abc_6150_new_n2446
* NET  1018 = abc_6150_new_n2445
* NET  1019 = abc_6150_new_n2444
* NET  1020 = abc_6150_new_n2443
* NET  1021 = abc_6150_new_n2442
* NET  1022 = abc_6150_new_n2441
* NET  1023 = abc_6150_new_n2440
* NET  1024 = abc_6150_new_n244
* NET  1025 = abc_6150_new_n2438
* NET  1026 = abc_6150_new_n2437
* NET  1027 = abc_6150_new_n2436
* NET  1028 = abc_6150_new_n2435
* NET  1029 = abc_6150_new_n2434
* NET  1030 = abc_6150_new_n2433
* NET  1031 = abc_6150_new_n2432
* NET  1032 = abc_6150_new_n2431
* NET  1033 = abc_6150_new_n2430
* NET  1034 = abc_6150_new_n243
* NET  1035 = abc_6150_new_n2429
* NET  1036 = abc_6150_new_n2428
* NET  1037 = abc_6150_new_n2427
* NET  1038 = abc_6150_new_n2426
* NET  1039 = abc_6150_new_n2425
* NET  1040 = abc_6150_new_n2424
* NET  1041 = abc_6150_new_n2423
* NET  1042 = abc_6150_new_n2422
* NET  1043 = abc_6150_new_n2421
* NET  1044 = abc_6150_new_n2420
* NET  1045 = abc_6150_new_n242
* NET  1046 = abc_6150_new_n2419
* NET  1047 = abc_6150_new_n2418
* NET  1048 = abc_6150_new_n2417
* NET  1049 = abc_6150_new_n2416
* NET  1050 = abc_6150_new_n2415
* NET  1051 = abc_6150_new_n2414
* NET  1052 = abc_6150_new_n2413
* NET  1053 = abc_6150_new_n2412
* NET  1054 = abc_6150_new_n2411
* NET  1055 = abc_6150_new_n2410
* NET  1056 = abc_6150_new_n241
* NET  1057 = abc_6150_new_n2409
* NET  1058 = abc_6150_new_n2408
* NET  1059 = abc_6150_new_n2407
* NET  1060 = abc_6150_new_n2406
* NET  1061 = abc_6150_new_n2405
* NET  1062 = abc_6150_new_n2404
* NET  1063 = abc_6150_new_n2403
* NET  1064 = abc_6150_new_n2402
* NET  1065 = abc_6150_new_n2401
* NET  1066 = abc_6150_new_n240
* NET  1067 = abc_6150_new_n2399
* NET  1068 = abc_6150_new_n2398
* NET  1069 = abc_6150_new_n2397
* NET  1070 = abc_6150_new_n2396
* NET  1071 = abc_6150_new_n2395
* NET  1072 = abc_6150_new_n2394
* NET  1073 = abc_6150_new_n2393
* NET  1074 = abc_6150_new_n2392
* NET  1075 = abc_6150_new_n2391
* NET  1076 = abc_6150_new_n2390
* NET  1077 = abc_6150_new_n239
* NET  1078 = abc_6150_new_n2389
* NET  1079 = abc_6150_new_n2388
* NET  1080 = abc_6150_new_n2387
* NET  1081 = abc_6150_new_n2386
* NET  1082 = abc_6150_new_n2385
* NET  1083 = abc_6150_new_n2384
* NET  1084 = abc_6150_new_n2383
* NET  1085 = abc_6150_new_n2382
* NET  1086 = abc_6150_new_n2381
* NET  1087 = abc_6150_new_n2380
* NET  1088 = abc_6150_new_n238
* NET  1089 = abc_6150_new_n2379
* NET  1090 = abc_6150_new_n2378
* NET  1091 = abc_6150_new_n2377
* NET  1092 = abc_6150_new_n2376
* NET  1093 = abc_6150_new_n2375
* NET  1094 = abc_6150_new_n2374
* NET  1095 = abc_6150_new_n2373
* NET  1096 = abc_6150_new_n2372
* NET  1097 = abc_6150_new_n2371
* NET  1098 = abc_6150_new_n2370
* NET  1099 = abc_6150_new_n237
* NET  1100 = abc_6150_new_n2369
* NET  1101 = abc_6150_new_n2368
* NET  1102 = abc_6150_new_n2367
* NET  1103 = abc_6150_new_n2366
* NET  1104 = abc_6150_new_n2365
* NET  1105 = abc_6150_new_n2364
* NET  1106 = abc_6150_new_n2363
* NET  1107 = abc_6150_new_n2362
* NET  1108 = abc_6150_new_n2361
* NET  1109 = abc_6150_new_n2360
* NET  1110 = abc_6150_new_n236
* NET  1111 = abc_6150_new_n2359
* NET  1112 = abc_6150_new_n2357
* NET  1113 = abc_6150_new_n2356
* NET  1114 = abc_6150_new_n2355
* NET  1115 = abc_6150_new_n2354
* NET  1116 = abc_6150_new_n2353
* NET  1117 = abc_6150_new_n2352
* NET  1118 = abc_6150_new_n2351
* NET  1119 = abc_6150_new_n2350
* NET  1120 = abc_6150_new_n235
* NET  1121 = abc_6150_new_n2349
* NET  1122 = abc_6150_new_n2348
* NET  1123 = abc_6150_new_n2347
* NET  1124 = abc_6150_new_n2346
* NET  1125 = abc_6150_new_n2345
* NET  1126 = abc_6150_new_n2344
* NET  1127 = abc_6150_new_n2343
* NET  1128 = abc_6150_new_n2342
* NET  1129 = abc_6150_new_n2341
* NET  1130 = abc_6150_new_n2340
* NET  1131 = abc_6150_new_n234
* NET  1132 = abc_6150_new_n2339
* NET  1133 = abc_6150_new_n2338
* NET  1134 = abc_6150_new_n2337
* NET  1135 = abc_6150_new_n2336
* NET  1136 = abc_6150_new_n2335
* NET  1137 = abc_6150_new_n2334
* NET  1138 = abc_6150_new_n2333
* NET  1139 = abc_6150_new_n2332
* NET  1140 = abc_6150_new_n2331
* NET  1141 = abc_6150_new_n2330
* NET  1142 = abc_6150_new_n233
* NET  1143 = abc_6150_new_n2329
* NET  1144 = abc_6150_new_n2328
* NET  1145 = abc_6150_new_n2327
* NET  1146 = abc_6150_new_n2326
* NET  1147 = abc_6150_new_n2325
* NET  1148 = abc_6150_new_n2324
* NET  1149 = abc_6150_new_n2323
* NET  1150 = abc_6150_new_n2322
* NET  1151 = abc_6150_new_n2321
* NET  1152 = abc_6150_new_n2320
* NET  1153 = abc_6150_new_n232
* NET  1154 = abc_6150_new_n2319
* NET  1155 = abc_6150_new_n2318
* NET  1156 = abc_6150_new_n2317
* NET  1157 = abc_6150_new_n2316
* NET  1158 = abc_6150_new_n2314
* NET  1159 = abc_6150_new_n2313
* NET  1160 = abc_6150_new_n2312
* NET  1161 = abc_6150_new_n2311
* NET  1162 = abc_6150_new_n2310
* NET  1163 = abc_6150_new_n231
* NET  1164 = abc_6150_new_n2309
* NET  1165 = abc_6150_new_n2308
* NET  1166 = abc_6150_new_n2307
* NET  1167 = abc_6150_new_n2306
* NET  1168 = abc_6150_new_n2305
* NET  1169 = abc_6150_new_n2304
* NET  1170 = abc_6150_new_n2303
* NET  1171 = abc_6150_new_n2302
* NET  1172 = abc_6150_new_n2301
* NET  1173 = abc_6150_new_n2300
* NET  1174 = abc_6150_new_n230
* NET  1175 = abc_6150_new_n2299
* NET  1176 = abc_6150_new_n2298
* NET  1177 = abc_6150_new_n2297
* NET  1178 = abc_6150_new_n2296
* NET  1179 = abc_6150_new_n2295
* NET  1180 = abc_6150_new_n2294
* NET  1181 = abc_6150_new_n2293
* NET  1182 = abc_6150_new_n2292
* NET  1183 = abc_6150_new_n2291
* NET  1184 = abc_6150_new_n2290
* NET  1185 = abc_6150_new_n229
* NET  1186 = abc_6150_new_n2289
* NET  1187 = abc_6150_new_n2288
* NET  1188 = abc_6150_new_n2287
* NET  1189 = abc_6150_new_n2286
* NET  1190 = abc_6150_new_n2285
* NET  1191 = abc_6150_new_n2284
* NET  1192 = abc_6150_new_n2283
* NET  1193 = abc_6150_new_n2282
* NET  1194 = abc_6150_new_n2281
* NET  1195 = abc_6150_new_n2280
* NET  1196 = abc_6150_new_n228
* NET  1197 = abc_6150_new_n2279
* NET  1198 = abc_6150_new_n2277
* NET  1199 = abc_6150_new_n2276
* NET  1200 = abc_6150_new_n2275
* NET  1201 = abc_6150_new_n2274
* NET  1202 = abc_6150_new_n2273
* NET  1203 = abc_6150_new_n2272
* NET  1204 = abc_6150_new_n2271
* NET  1205 = abc_6150_new_n2270
* NET  1206 = abc_6150_new_n227
* NET  1207 = abc_6150_new_n2269
* NET  1208 = abc_6150_new_n2268
* NET  1209 = abc_6150_new_n2267
* NET  1210 = abc_6150_new_n2266
* NET  1211 = abc_6150_new_n2265
* NET  1212 = abc_6150_new_n2264
* NET  1213 = abc_6150_new_n2263
* NET  1214 = abc_6150_new_n2262
* NET  1215 = abc_6150_new_n2261
* NET  1216 = abc_6150_new_n2260
* NET  1217 = abc_6150_new_n226
* NET  1218 = abc_6150_new_n2259
* NET  1219 = abc_6150_new_n2258
* NET  1220 = abc_6150_new_n2257
* NET  1221 = abc_6150_new_n2256
* NET  1222 = abc_6150_new_n2255
* NET  1223 = abc_6150_new_n2254
* NET  1224 = abc_6150_new_n2253
* NET  1225 = abc_6150_new_n2252
* NET  1226 = abc_6150_new_n2251
* NET  1227 = abc_6150_new_n2250
* NET  1228 = abc_6150_new_n225
* NET  1229 = abc_6150_new_n2249
* NET  1230 = abc_6150_new_n2248
* NET  1231 = abc_6150_new_n2247
* NET  1232 = abc_6150_new_n2246
* NET  1233 = abc_6150_new_n2245
* NET  1234 = abc_6150_new_n2244
* NET  1235 = abc_6150_new_n2243
* NET  1236 = abc_6150_new_n2242
* NET  1237 = abc_6150_new_n2241
* NET  1238 = abc_6150_new_n2240
* NET  1239 = abc_6150_new_n224
* NET  1240 = abc_6150_new_n2239
* NET  1241 = abc_6150_new_n2238
* NET  1242 = abc_6150_new_n2237
* NET  1243 = abc_6150_new_n2236
* NET  1244 = abc_6150_new_n2235
* NET  1245 = abc_6150_new_n2234
* NET  1246 = abc_6150_new_n2232
* NET  1247 = abc_6150_new_n2231
* NET  1248 = abc_6150_new_n2230
* NET  1249 = abc_6150_new_n223
* NET  1250 = abc_6150_new_n2229
* NET  1251 = abc_6150_new_n2228
* NET  1252 = abc_6150_new_n2227
* NET  1253 = abc_6150_new_n2226
* NET  1254 = abc_6150_new_n2225
* NET  1255 = abc_6150_new_n2224
* NET  1256 = abc_6150_new_n2223
* NET  1257 = abc_6150_new_n2222
* NET  1258 = abc_6150_new_n2221
* NET  1259 = abc_6150_new_n2220
* NET  1260 = abc_6150_new_n222
* NET  1261 = abc_6150_new_n2219
* NET  1262 = abc_6150_new_n2218
* NET  1263 = abc_6150_new_n2217
* NET  1264 = abc_6150_new_n2216
* NET  1265 = abc_6150_new_n2215
* NET  1266 = abc_6150_new_n2214
* NET  1267 = abc_6150_new_n2213
* NET  1268 = abc_6150_new_n2212
* NET  1269 = abc_6150_new_n2211
* NET  1270 = abc_6150_new_n2210
* NET  1271 = abc_6150_new_n221
* NET  1272 = abc_6150_new_n2209
* NET  1273 = abc_6150_new_n2208
* NET  1274 = abc_6150_new_n2207
* NET  1275 = abc_6150_new_n2206
* NET  1276 = abc_6150_new_n2205
* NET  1277 = abc_6150_new_n2204
* NET  1278 = abc_6150_new_n2203
* NET  1279 = abc_6150_new_n2202
* NET  1280 = abc_6150_new_n2201
* NET  1281 = abc_6150_new_n2200
* NET  1282 = abc_6150_new_n220
* NET  1283 = abc_6150_new_n2199
* NET  1284 = abc_6150_new_n2198
* NET  1285 = abc_6150_new_n2197
* NET  1286 = abc_6150_new_n2196
* NET  1287 = abc_6150_new_n2195
* NET  1288 = abc_6150_new_n2193
* NET  1289 = abc_6150_new_n2192
* NET  1290 = abc_6150_new_n2191
* NET  1291 = abc_6150_new_n2190
* NET  1292 = abc_6150_new_n219
* NET  1293 = abc_6150_new_n2189
* NET  1294 = abc_6150_new_n2188
* NET  1295 = abc_6150_new_n2187
* NET  1296 = abc_6150_new_n2186
* NET  1297 = abc_6150_new_n2185
* NET  1298 = abc_6150_new_n2184
* NET  1299 = abc_6150_new_n2183
* NET  1300 = abc_6150_new_n2182
* NET  1301 = abc_6150_new_n2181
* NET  1302 = abc_6150_new_n2180
* NET  1303 = abc_6150_new_n218
* NET  1304 = abc_6150_new_n2179
* NET  1305 = abc_6150_new_n2178
* NET  1306 = abc_6150_new_n2177
* NET  1307 = abc_6150_new_n2176
* NET  1308 = abc_6150_new_n2175
* NET  1309 = abc_6150_new_n2174
* NET  1310 = abc_6150_new_n2173
* NET  1311 = abc_6150_new_n2172
* NET  1312 = abc_6150_new_n2171
* NET  1313 = abc_6150_new_n2170
* NET  1314 = abc_6150_new_n217
* NET  1315 = abc_6150_new_n2169
* NET  1316 = abc_6150_new_n2168
* NET  1317 = abc_6150_new_n2167
* NET  1318 = abc_6150_new_n2166
* NET  1319 = abc_6150_new_n2165
* NET  1320 = abc_6150_new_n2164
* NET  1321 = abc_6150_new_n2163
* NET  1322 = abc_6150_new_n2162
* NET  1323 = abc_6150_new_n2161
* NET  1324 = abc_6150_new_n2160
* NET  1325 = abc_6150_new_n216
* NET  1326 = abc_6150_new_n2159
* NET  1327 = abc_6150_new_n2158
* NET  1328 = abc_6150_new_n2157
* NET  1329 = abc_6150_new_n2156
* NET  1330 = abc_6150_new_n2155
* NET  1331 = abc_6150_new_n2154
* NET  1332 = abc_6150_new_n2153
* NET  1333 = abc_6150_new_n2152
* NET  1334 = abc_6150_new_n2151
* NET  1335 = abc_6150_new_n2150
* NET  1336 = abc_6150_new_n215
* NET  1337 = abc_6150_new_n2148
* NET  1338 = abc_6150_new_n2147
* NET  1339 = abc_6150_new_n2146
* NET  1340 = abc_6150_new_n2145
* NET  1341 = abc_6150_new_n2144
* NET  1342 = abc_6150_new_n2143
* NET  1343 = abc_6150_new_n2142
* NET  1344 = abc_6150_new_n2141
* NET  1345 = abc_6150_new_n2140
* NET  1346 = abc_6150_new_n214
* NET  1347 = abc_6150_new_n2139
* NET  1348 = abc_6150_new_n2138
* NET  1349 = abc_6150_new_n2137
* NET  1350 = abc_6150_new_n2136
* NET  1351 = abc_6150_new_n2135
* NET  1352 = abc_6150_new_n2134
* NET  1353 = abc_6150_new_n2133
* NET  1354 = abc_6150_new_n2132
* NET  1355 = abc_6150_new_n2131
* NET  1356 = abc_6150_new_n2130
* NET  1357 = abc_6150_new_n213
* NET  1358 = abc_6150_new_n2129
* NET  1359 = abc_6150_new_n2128
* NET  1360 = abc_6150_new_n2127
* NET  1361 = abc_6150_new_n2126
* NET  1362 = abc_6150_new_n2125
* NET  1363 = abc_6150_new_n2124
* NET  1364 = abc_6150_new_n2123
* NET  1365 = abc_6150_new_n2122
* NET  1366 = abc_6150_new_n2121
* NET  1367 = abc_6150_new_n2120
* NET  1368 = abc_6150_new_n212
* NET  1369 = abc_6150_new_n2119
* NET  1370 = abc_6150_new_n2118
* NET  1371 = abc_6150_new_n2117
* NET  1372 = abc_6150_new_n2116
* NET  1373 = abc_6150_new_n2115
* NET  1374 = abc_6150_new_n2114
* NET  1375 = abc_6150_new_n2113
* NET  1376 = abc_6150_new_n2112
* NET  1377 = abc_6150_new_n2111
* NET  1378 = abc_6150_new_n2110
* NET  1379 = abc_6150_new_n211
* NET  1380 = abc_6150_new_n2108
* NET  1381 = abc_6150_new_n2107
* NET  1382 = abc_6150_new_n2106
* NET  1383 = abc_6150_new_n2105
* NET  1384 = abc_6150_new_n2104
* NET  1385 = abc_6150_new_n2103
* NET  1386 = abc_6150_new_n2102
* NET  1387 = abc_6150_new_n2101
* NET  1388 = abc_6150_new_n2100
* NET  1389 = abc_6150_new_n210
* NET  1390 = abc_6150_new_n2099
* NET  1391 = abc_6150_new_n2098
* NET  1392 = abc_6150_new_n2097
* NET  1393 = abc_6150_new_n2096
* NET  1394 = abc_6150_new_n2095
* NET  1395 = abc_6150_new_n2094
* NET  1396 = abc_6150_new_n2093
* NET  1397 = abc_6150_new_n2092
* NET  1398 = abc_6150_new_n2091
* NET  1399 = abc_6150_new_n2090
* NET  1400 = abc_6150_new_n209
* NET  1401 = abc_6150_new_n2089
* NET  1402 = abc_6150_new_n2088
* NET  1403 = abc_6150_new_n2087
* NET  1404 = abc_6150_new_n2086
* NET  1405 = abc_6150_new_n2085
* NET  1406 = abc_6150_new_n2084
* NET  1407 = abc_6150_new_n2083
* NET  1408 = abc_6150_new_n2082
* NET  1409 = abc_6150_new_n2081
* NET  1410 = abc_6150_new_n2080
* NET  1411 = abc_6150_new_n208
* NET  1412 = abc_6150_new_n2079
* NET  1413 = abc_6150_new_n2078
* NET  1414 = abc_6150_new_n2077
* NET  1415 = abc_6150_new_n2076
* NET  1416 = abc_6150_new_n2075
* NET  1417 = abc_6150_new_n2074
* NET  1418 = abc_6150_new_n2073
* NET  1419 = abc_6150_new_n2072
* NET  1420 = abc_6150_new_n2071
* NET  1421 = abc_6150_new_n2070
* NET  1422 = abc_6150_new_n207
* NET  1423 = abc_6150_new_n2069
* NET  1424 = abc_6150_new_n2068
* NET  1425 = abc_6150_new_n2067
* NET  1426 = abc_6150_new_n2066
* NET  1427 = abc_6150_new_n2065
* NET  1428 = abc_6150_new_n2064
* NET  1429 = abc_6150_new_n2063
* NET  1430 = abc_6150_new_n2062
* NET  1431 = abc_6150_new_n2060
* NET  1432 = abc_6150_new_n206
* NET  1433 = abc_6150_new_n2059
* NET  1434 = abc_6150_new_n2058
* NET  1435 = abc_6150_new_n2057
* NET  1436 = abc_6150_new_n2056
* NET  1437 = abc_6150_new_n2055
* NET  1438 = abc_6150_new_n2054
* NET  1439 = abc_6150_new_n2053
* NET  1440 = abc_6150_new_n2052
* NET  1441 = abc_6150_new_n2051
* NET  1442 = abc_6150_new_n2050
* NET  1443 = abc_6150_new_n205
* NET  1444 = abc_6150_new_n2049
* NET  1445 = abc_6150_new_n2048
* NET  1446 = abc_6150_new_n2047
* NET  1447 = abc_6150_new_n2046
* NET  1448 = abc_6150_new_n2045
* NET  1449 = abc_6150_new_n2044
* NET  1450 = abc_6150_new_n2043
* NET  1451 = abc_6150_new_n2042
* NET  1452 = abc_6150_new_n2041
* NET  1453 = abc_6150_new_n2040
* NET  1454 = abc_6150_new_n204
* NET  1455 = abc_6150_new_n2039
* NET  1456 = abc_6150_new_n2038
* NET  1457 = abc_6150_new_n2037
* NET  1458 = abc_6150_new_n2036
* NET  1459 = abc_6150_new_n2035
* NET  1460 = abc_6150_new_n2034
* NET  1461 = abc_6150_new_n2033
* NET  1462 = abc_6150_new_n2032
* NET  1463 = abc_6150_new_n2031
* NET  1464 = abc_6150_new_n2030
* NET  1465 = abc_6150_new_n203
* NET  1466 = abc_6150_new_n2029
* NET  1467 = abc_6150_new_n2028
* NET  1468 = abc_6150_new_n2027
* NET  1469 = abc_6150_new_n2026
* NET  1470 = abc_6150_new_n2025
* NET  1471 = abc_6150_new_n2024
* NET  1472 = abc_6150_new_n2023
* NET  1473 = abc_6150_new_n2022
* NET  1474 = abc_6150_new_n2021
* NET  1475 = abc_6150_new_n2020
* NET  1476 = abc_6150_new_n2019
* NET  1477 = abc_6150_new_n2018
* NET  1478 = abc_6150_new_n2017
* NET  1479 = abc_6150_new_n2016
* NET  1480 = abc_6150_new_n2014
* NET  1481 = abc_6150_new_n2013
* NET  1482 = abc_6150_new_n2012
* NET  1483 = abc_6150_new_n2011
* NET  1484 = abc_6150_new_n2010
* NET  1485 = abc_6150_new_n2009
* NET  1486 = abc_6150_new_n2008
* NET  1487 = abc_6150_new_n2007
* NET  1488 = abc_6150_new_n2006
* NET  1489 = abc_6150_new_n2005
* NET  1490 = abc_6150_new_n2004
* NET  1491 = abc_6150_new_n2003
* NET  1492 = abc_6150_new_n2002
* NET  1493 = abc_6150_new_n2001
* NET  1494 = abc_6150_new_n2000
* NET  1495 = abc_6150_new_n1999
* NET  1496 = abc_6150_new_n1998
* NET  1497 = abc_6150_new_n1997
* NET  1498 = abc_6150_new_n1996
* NET  1499 = abc_6150_new_n1995
* NET  1500 = abc_6150_new_n1994
* NET  1501 = abc_6150_new_n1993
* NET  1502 = abc_6150_new_n1992
* NET  1503 = abc_6150_new_n1991
* NET  1504 = abc_6150_new_n1990
* NET  1505 = abc_6150_new_n1989
* NET  1506 = abc_6150_new_n1988
* NET  1507 = abc_6150_new_n1987
* NET  1508 = abc_6150_new_n1986
* NET  1509 = abc_6150_new_n1985
* NET  1510 = abc_6150_new_n1984
* NET  1511 = abc_6150_new_n1983
* NET  1512 = abc_6150_new_n1982
* NET  1513 = abc_6150_new_n1981
* NET  1514 = abc_6150_new_n1980
* NET  1515 = abc_6150_new_n1979
* NET  1516 = abc_6150_new_n1978
* NET  1517 = abc_6150_new_n1977
* NET  1518 = abc_6150_new_n1976
* NET  1519 = abc_6150_new_n1975
* NET  1520 = abc_6150_new_n1974
* NET  1521 = abc_6150_new_n1973
* NET  1522 = abc_6150_new_n1972
* NET  1523 = abc_6150_new_n1970
* NET  1524 = abc_6150_new_n1969
* NET  1525 = abc_6150_new_n1968
* NET  1526 = abc_6150_new_n1967
* NET  1527 = abc_6150_new_n1966
* NET  1528 = abc_6150_new_n1965
* NET  1529 = abc_6150_new_n1964
* NET  1530 = abc_6150_new_n1963
* NET  1531 = abc_6150_new_n1962
* NET  1532 = abc_6150_new_n1961
* NET  1533 = abc_6150_new_n1960
* NET  1534 = abc_6150_new_n1959
* NET  1535 = abc_6150_new_n1958
* NET  1536 = abc_6150_new_n1957
* NET  1537 = abc_6150_new_n1956
* NET  1538 = abc_6150_new_n1955
* NET  1539 = abc_6150_new_n1954
* NET  1540 = abc_6150_new_n1953
* NET  1541 = abc_6150_new_n1952
* NET  1542 = abc_6150_new_n1951
* NET  1543 = abc_6150_new_n1950
* NET  1544 = abc_6150_new_n1949
* NET  1545 = abc_6150_new_n1948
* NET  1546 = abc_6150_new_n1947
* NET  1547 = abc_6150_new_n1946
* NET  1548 = abc_6150_new_n1945
* NET  1549 = abc_6150_new_n1944
* NET  1550 = abc_6150_new_n1943
* NET  1551 = abc_6150_new_n1942
* NET  1552 = abc_6150_new_n1941
* NET  1553 = abc_6150_new_n1939
* NET  1554 = abc_6150_new_n1938
* NET  1555 = abc_6150_new_n1937
* NET  1556 = abc_6150_new_n1936
* NET  1557 = abc_6150_new_n1935
* NET  1558 = abc_6150_new_n1934
* NET  1559 = abc_6150_new_n1933
* NET  1560 = abc_6150_new_n1932
* NET  1561 = abc_6150_new_n1931
* NET  1562 = abc_6150_new_n1930
* NET  1563 = abc_6150_new_n1929
* NET  1564 = abc_6150_new_n1928
* NET  1565 = abc_6150_new_n1927
* NET  1566 = abc_6150_new_n1926
* NET  1567 = abc_6150_new_n1925
* NET  1568 = abc_6150_new_n1924
* NET  1569 = abc_6150_new_n1923
* NET  1570 = abc_6150_new_n1922
* NET  1571 = abc_6150_new_n1921
* NET  1572 = abc_6150_new_n1920
* NET  1573 = abc_6150_new_n1919
* NET  1574 = abc_6150_new_n1918
* NET  1575 = abc_6150_new_n1917
* NET  1576 = abc_6150_new_n1916
* NET  1577 = abc_6150_new_n1914
* NET  1578 = abc_6150_new_n1913
* NET  1579 = abc_6150_new_n1912
* NET  1580 = abc_6150_new_n1911
* NET  1581 = abc_6150_new_n1910
* NET  1582 = abc_6150_new_n1909
* NET  1583 = abc_6150_new_n1908
* NET  1584 = abc_6150_new_n1907
* NET  1585 = abc_6150_new_n1906
* NET  1586 = abc_6150_new_n1905
* NET  1587 = abc_6150_new_n1904
* NET  1588 = abc_6150_new_n1903
* NET  1589 = abc_6150_new_n1902
* NET  1590 = abc_6150_new_n1901
* NET  1591 = abc_6150_new_n1900
* NET  1592 = abc_6150_new_n1899
* NET  1593 = abc_6150_new_n1898
* NET  1594 = abc_6150_new_n1897
* NET  1595 = abc_6150_new_n1896
* NET  1596 = abc_6150_new_n1895
* NET  1597 = abc_6150_new_n1894
* NET  1598 = abc_6150_new_n1893
* NET  1599 = abc_6150_new_n1892
* NET  1600 = abc_6150_new_n1891
* NET  1601 = abc_6150_new_n1890
* NET  1602 = abc_6150_new_n1889
* NET  1603 = abc_6150_new_n1888
* NET  1604 = abc_6150_new_n1887
* NET  1605 = abc_6150_new_n1886
* NET  1606 = abc_6150_new_n1885
* NET  1607 = abc_6150_new_n1884
* NET  1608 = abc_6150_new_n1883
* NET  1609 = abc_6150_new_n1882
* NET  1610 = abc_6150_new_n1881
* NET  1611 = abc_6150_new_n1880
* NET  1612 = abc_6150_new_n1878
* NET  1613 = abc_6150_new_n1877
* NET  1614 = abc_6150_new_n1876
* NET  1615 = abc_6150_new_n1875
* NET  1616 = abc_6150_new_n1874
* NET  1617 = abc_6150_new_n1873
* NET  1618 = abc_6150_new_n1872
* NET  1619 = abc_6150_new_n1871
* NET  1620 = abc_6150_new_n1870
* NET  1621 = abc_6150_new_n1869
* NET  1622 = abc_6150_new_n1868
* NET  1623 = abc_6150_new_n1867
* NET  1624 = abc_6150_new_n1866
* NET  1625 = abc_6150_new_n1865
* NET  1626 = abc_6150_new_n1864
* NET  1627 = abc_6150_new_n1863
* NET  1628 = abc_6150_new_n1862
* NET  1629 = abc_6150_new_n1861
* NET  1630 = abc_6150_new_n1860
* NET  1631 = abc_6150_new_n1859
* NET  1632 = abc_6150_new_n1858
* NET  1633 = abc_6150_new_n1857
* NET  1634 = abc_6150_new_n1856
* NET  1635 = abc_6150_new_n1855
* NET  1636 = abc_6150_new_n1854
* NET  1637 = abc_6150_new_n1853
* NET  1638 = abc_6150_new_n1852
* NET  1639 = abc_6150_new_n1851
* NET  1640 = abc_6150_new_n1850
* NET  1641 = abc_6150_new_n1849
* NET  1642 = abc_6150_new_n1848
* NET  1643 = abc_6150_new_n1847
* NET  1644 = abc_6150_new_n1846
* NET  1645 = abc_6150_new_n1845
* NET  1646 = abc_6150_new_n1844
* NET  1647 = abc_6150_new_n1843
* NET  1648 = abc_6150_new_n1842
* NET  1649 = abc_6150_new_n1841
* NET  1650 = abc_6150_new_n1840
* NET  1651 = abc_6150_new_n1839
* NET  1652 = abc_6150_new_n1837
* NET  1653 = abc_6150_new_n1836
* NET  1654 = abc_6150_new_n1835
* NET  1655 = abc_6150_new_n1834
* NET  1656 = abc_6150_new_n1833
* NET  1657 = abc_6150_new_n1832
* NET  1658 = abc_6150_new_n1831
* NET  1659 = abc_6150_new_n1830
* NET  1660 = abc_6150_new_n1829
* NET  1661 = abc_6150_new_n1828
* NET  1662 = abc_6150_new_n1827
* NET  1663 = abc_6150_new_n1826
* NET  1664 = abc_6150_new_n1825
* NET  1665 = abc_6150_new_n1824
* NET  1666 = abc_6150_new_n1823
* NET  1667 = abc_6150_new_n1822
* NET  1668 = abc_6150_new_n1821
* NET  1669 = abc_6150_new_n1820
* NET  1670 = abc_6150_new_n1819
* NET  1671 = abc_6150_new_n1818
* NET  1672 = abc_6150_new_n1817
* NET  1673 = abc_6150_new_n1816
* NET  1674 = abc_6150_new_n1815
* NET  1675 = abc_6150_new_n1814
* NET  1676 = abc_6150_new_n1813
* NET  1677 = abc_6150_new_n1812
* NET  1678 = abc_6150_new_n1811
* NET  1679 = abc_6150_new_n1810
* NET  1680 = abc_6150_new_n1809
* NET  1681 = abc_6150_new_n1808
* NET  1682 = abc_6150_new_n1807
* NET  1683 = abc_6150_new_n1806
* NET  1684 = abc_6150_new_n1805
* NET  1685 = abc_6150_new_n1804
* NET  1686 = abc_6150_new_n1803
* NET  1687 = abc_6150_new_n1802
* NET  1688 = abc_6150_new_n1801
* NET  1689 = abc_6150_new_n1800
* NET  1690 = abc_6150_new_n1799
* NET  1691 = abc_6150_new_n1798
* NET  1692 = abc_6150_new_n1796
* NET  1693 = abc_6150_new_n1795
* NET  1694 = abc_6150_new_n1794
* NET  1695 = abc_6150_new_n1793
* NET  1696 = abc_6150_new_n1792
* NET  1697 = abc_6150_new_n1791
* NET  1698 = abc_6150_new_n1790
* NET  1699 = abc_6150_new_n1789
* NET  1700 = abc_6150_new_n1788
* NET  1701 = abc_6150_new_n1787
* NET  1702 = abc_6150_new_n1786
* NET  1703 = abc_6150_new_n1785
* NET  1704 = abc_6150_new_n1784
* NET  1705 = abc_6150_new_n1783
* NET  1706 = abc_6150_new_n1782
* NET  1707 = abc_6150_new_n1781
* NET  1708 = abc_6150_new_n1780
* NET  1709 = abc_6150_new_n1779
* NET  1710 = abc_6150_new_n1778
* NET  1711 = abc_6150_new_n1777
* NET  1712 = abc_6150_new_n1776
* NET  1713 = abc_6150_new_n1775
* NET  1714 = abc_6150_new_n1774
* NET  1715 = abc_6150_new_n1773
* NET  1716 = abc_6150_new_n1772
* NET  1717 = abc_6150_new_n1771
* NET  1718 = abc_6150_new_n1770
* NET  1719 = abc_6150_new_n1769
* NET  1720 = abc_6150_new_n1768
* NET  1721 = abc_6150_new_n1767
* NET  1722 = abc_6150_new_n1766
* NET  1723 = abc_6150_new_n1765
* NET  1724 = abc_6150_new_n1764
* NET  1725 = abc_6150_new_n1763
* NET  1726 = abc_6150_new_n1762
* NET  1727 = abc_6150_new_n1761
* NET  1728 = abc_6150_new_n1760
* NET  1729 = abc_6150_new_n1759
* NET  1730 = abc_6150_new_n1758
* NET  1731 = abc_6150_new_n1757
* NET  1732 = abc_6150_new_n1756
* NET  1733 = abc_6150_new_n1755
* NET  1734 = abc_6150_new_n1753
* NET  1735 = abc_6150_new_n1752
* NET  1736 = abc_6150_new_n1751
* NET  1737 = abc_6150_new_n1750
* NET  1738 = abc_6150_new_n1749
* NET  1739 = abc_6150_new_n1748
* NET  1740 = abc_6150_new_n1747
* NET  1741 = abc_6150_new_n1746
* NET  1742 = abc_6150_new_n1745
* NET  1743 = abc_6150_new_n1744
* NET  1744 = abc_6150_new_n1743
* NET  1745 = abc_6150_new_n1742
* NET  1746 = abc_6150_new_n1741
* NET  1747 = abc_6150_new_n1740
* NET  1748 = abc_6150_new_n1739
* NET  1749 = abc_6150_new_n1738
* NET  1750 = abc_6150_new_n1737
* NET  1751 = abc_6150_new_n1736
* NET  1752 = abc_6150_new_n1735
* NET  1753 = abc_6150_new_n1734
* NET  1754 = abc_6150_new_n1733
* NET  1755 = abc_6150_new_n1732
* NET  1756 = abc_6150_new_n1731
* NET  1757 = abc_6150_new_n1730
* NET  1758 = abc_6150_new_n1729
* NET  1759 = abc_6150_new_n1728
* NET  1760 = abc_6150_new_n1727
* NET  1761 = abc_6150_new_n1726
* NET  1762 = abc_6150_new_n1725
* NET  1763 = abc_6150_new_n1724
* NET  1764 = abc_6150_new_n1723
* NET  1765 = abc_6150_new_n1722
* NET  1766 = abc_6150_new_n1721
* NET  1767 = abc_6150_new_n1720
* NET  1768 = abc_6150_new_n1719
* NET  1769 = abc_6150_new_n1718
* NET  1770 = abc_6150_new_n1717
* NET  1771 = abc_6150_new_n1716
* NET  1772 = abc_6150_new_n1715
* NET  1773 = abc_6150_new_n1714
* NET  1774 = abc_6150_new_n1713
* NET  1775 = abc_6150_new_n1712
* NET  1776 = abc_6150_new_n1711
* NET  1777 = abc_6150_new_n1710
* NET  1778 = abc_6150_new_n1709
* NET  1779 = abc_6150_new_n1707
* NET  1780 = abc_6150_new_n1706
* NET  1781 = abc_6150_new_n1705
* NET  1782 = abc_6150_new_n1704
* NET  1783 = abc_6150_new_n1703
* NET  1784 = abc_6150_new_n1702
* NET  1785 = abc_6150_new_n1701
* NET  1786 = abc_6150_new_n1700
* NET  1787 = abc_6150_new_n1699
* NET  1788 = abc_6150_new_n1698
* NET  1789 = abc_6150_new_n1697
* NET  1790 = abc_6150_new_n1696
* NET  1791 = abc_6150_new_n1695
* NET  1792 = abc_6150_new_n1694
* NET  1793 = abc_6150_new_n1693
* NET  1794 = abc_6150_new_n1692
* NET  1795 = abc_6150_new_n1691
* NET  1796 = abc_6150_new_n1690
* NET  1797 = abc_6150_new_n1689
* NET  1798 = abc_6150_new_n1688
* NET  1799 = abc_6150_new_n1687
* NET  1800 = abc_6150_new_n1686
* NET  1801 = abc_6150_new_n1685
* NET  1802 = abc_6150_new_n1684
* NET  1803 = abc_6150_new_n1683
* NET  1804 = abc_6150_new_n1682
* NET  1805 = abc_6150_new_n1681
* NET  1806 = abc_6150_new_n1680
* NET  1807 = abc_6150_new_n1679
* NET  1808 = abc_6150_new_n1678
* NET  1809 = abc_6150_new_n1677
* NET  1810 = abc_6150_new_n1676
* NET  1811 = abc_6150_new_n1675
* NET  1812 = abc_6150_new_n1674
* NET  1813 = abc_6150_new_n1673
* NET  1814 = abc_6150_new_n1672
* NET  1815 = abc_6150_new_n1671
* NET  1816 = abc_6150_new_n1670
* NET  1817 = abc_6150_new_n1669
* NET  1818 = abc_6150_new_n1668
* NET  1819 = abc_6150_new_n1667
* NET  1820 = abc_6150_new_n1666
* NET  1821 = abc_6150_new_n1665
* NET  1822 = abc_6150_new_n1664
* NET  1823 = abc_6150_new_n1663
* NET  1824 = abc_6150_new_n1661
* NET  1825 = abc_6150_new_n1660
* NET  1826 = abc_6150_new_n1659
* NET  1827 = abc_6150_new_n1658
* NET  1828 = abc_6150_new_n1657
* NET  1829 = abc_6150_new_n1656
* NET  1830 = abc_6150_new_n1655
* NET  1831 = abc_6150_new_n1654
* NET  1832 = abc_6150_new_n1653
* NET  1833 = abc_6150_new_n1652
* NET  1834 = abc_6150_new_n1651
* NET  1835 = abc_6150_new_n1650
* NET  1836 = abc_6150_new_n1649
* NET  1837 = abc_6150_new_n1648
* NET  1838 = abc_6150_new_n1647
* NET  1839 = abc_6150_new_n1646
* NET  1840 = abc_6150_new_n1645
* NET  1841 = abc_6150_new_n1644
* NET  1842 = abc_6150_new_n1643
* NET  1843 = abc_6150_new_n1642
* NET  1844 = abc_6150_new_n1641
* NET  1845 = abc_6150_new_n1640
* NET  1846 = abc_6150_new_n1639
* NET  1847 = abc_6150_new_n1638
* NET  1848 = abc_6150_new_n1637
* NET  1849 = abc_6150_new_n1636
* NET  1850 = abc_6150_new_n1635
* NET  1851 = abc_6150_new_n1634
* NET  1852 = abc_6150_new_n1633
* NET  1853 = abc_6150_new_n1632
* NET  1854 = abc_6150_new_n1631
* NET  1855 = abc_6150_new_n1630
* NET  1856 = abc_6150_new_n1629
* NET  1857 = abc_6150_new_n1628
* NET  1858 = abc_6150_new_n1627
* NET  1859 = abc_6150_new_n1626
* NET  1860 = abc_6150_new_n1625
* NET  1861 = abc_6150_new_n1624
* NET  1862 = abc_6150_new_n1623
* NET  1863 = abc_6150_new_n1622
* NET  1864 = abc_6150_new_n1621
* NET  1865 = abc_6150_new_n1620
* NET  1866 = abc_6150_new_n1619
* NET  1867 = abc_6150_new_n1618
* NET  1868 = abc_6150_new_n1617
* NET  1869 = abc_6150_new_n1616
* NET  1870 = abc_6150_new_n1615
* NET  1871 = abc_6150_new_n1614
* NET  1872 = abc_6150_new_n1613
* NET  1873 = abc_6150_new_n1611
* NET  1874 = abc_6150_new_n1610
* NET  1875 = abc_6150_new_n1609
* NET  1876 = abc_6150_new_n1608
* NET  1877 = abc_6150_new_n1607
* NET  1878 = abc_6150_new_n1606
* NET  1879 = abc_6150_new_n1605
* NET  1880 = abc_6150_new_n1604
* NET  1881 = abc_6150_new_n1603
* NET  1882 = abc_6150_new_n1602
* NET  1883 = abc_6150_new_n1601
* NET  1884 = abc_6150_new_n1600
* NET  1885 = abc_6150_new_n1599
* NET  1886 = abc_6150_new_n1598
* NET  1887 = abc_6150_new_n1597
* NET  1888 = abc_6150_new_n1596
* NET  1889 = abc_6150_new_n1595
* NET  1890 = abc_6150_new_n1594
* NET  1891 = abc_6150_new_n1593
* NET  1892 = abc_6150_new_n1592
* NET  1893 = abc_6150_new_n1591
* NET  1894 = abc_6150_new_n1590
* NET  1895 = abc_6150_new_n1589
* NET  1896 = abc_6150_new_n1588
* NET  1897 = abc_6150_new_n1587
* NET  1898 = abc_6150_new_n1586
* NET  1899 = abc_6150_new_n1585
* NET  1900 = abc_6150_new_n1584
* NET  1901 = abc_6150_new_n1583
* NET  1902 = abc_6150_new_n1582
* NET  1903 = abc_6150_new_n1581
* NET  1904 = abc_6150_new_n1580
* NET  1905 = abc_6150_new_n1579
* NET  1906 = abc_6150_new_n1578
* NET  1907 = abc_6150_new_n1577
* NET  1908 = abc_6150_new_n1576
* NET  1909 = abc_6150_new_n1575
* NET  1910 = abc_6150_new_n1574
* NET  1911 = abc_6150_new_n1573
* NET  1912 = abc_6150_new_n1572
* NET  1913 = abc_6150_new_n1571
* NET  1914 = abc_6150_new_n1570
* NET  1915 = abc_6150_new_n1569
* NET  1916 = abc_6150_new_n1568
* NET  1917 = abc_6150_new_n1567
* NET  1918 = abc_6150_new_n1566
* NET  1919 = abc_6150_new_n1565
* NET  1920 = abc_6150_new_n1564
* NET  1921 = abc_6150_new_n1563
* NET  1922 = abc_6150_new_n1562
* NET  1923 = abc_6150_new_n1561
* NET  1924 = abc_6150_new_n1560
* NET  1925 = abc_6150_new_n1558
* NET  1926 = abc_6150_new_n1557
* NET  1927 = abc_6150_new_n1556
* NET  1928 = abc_6150_new_n1555
* NET  1929 = abc_6150_new_n1554
* NET  1930 = abc_6150_new_n1553
* NET  1931 = abc_6150_new_n1552
* NET  1932 = abc_6150_new_n1551
* NET  1933 = abc_6150_new_n1550
* NET  1934 = abc_6150_new_n1549
* NET  1935 = abc_6150_new_n1548
* NET  1936 = abc_6150_new_n1547
* NET  1937 = abc_6150_new_n1546
* NET  1938 = abc_6150_new_n1545
* NET  1939 = abc_6150_new_n1544
* NET  1940 = abc_6150_new_n1543
* NET  1941 = abc_6150_new_n1542
* NET  1942 = abc_6150_new_n1541
* NET  1943 = abc_6150_new_n1540
* NET  1944 = abc_6150_new_n1539
* NET  1945 = abc_6150_new_n1538
* NET  1946 = abc_6150_new_n1537
* NET  1947 = abc_6150_new_n1536
* NET  1948 = abc_6150_new_n1535
* NET  1949 = abc_6150_new_n1534
* NET  1950 = abc_6150_new_n1533
* NET  1951 = abc_6150_new_n1532
* NET  1952 = abc_6150_new_n1531
* NET  1953 = abc_6150_new_n1530
* NET  1954 = abc_6150_new_n1529
* NET  1955 = abc_6150_new_n1528
* NET  1956 = abc_6150_new_n1527
* NET  1957 = abc_6150_new_n1526
* NET  1958 = abc_6150_new_n1525
* NET  1959 = abc_6150_new_n1524
* NET  1960 = abc_6150_new_n1523
* NET  1961 = abc_6150_new_n1522
* NET  1962 = abc_6150_new_n1521
* NET  1963 = abc_6150_new_n1520
* NET  1964 = abc_6150_new_n1519
* NET  1965 = abc_6150_new_n1518
* NET  1966 = abc_6150_new_n1517
* NET  1967 = abc_6150_new_n1516
* NET  1968 = abc_6150_new_n1514
* NET  1969 = abc_6150_new_n1513
* NET  1970 = abc_6150_new_n1512
* NET  1971 = abc_6150_new_n1511
* NET  1972 = abc_6150_new_n1510
* NET  1973 = abc_6150_new_n1509
* NET  1974 = abc_6150_new_n1508
* NET  1975 = abc_6150_new_n1507
* NET  1976 = abc_6150_new_n1506
* NET  1977 = abc_6150_new_n1505
* NET  1978 = abc_6150_new_n1504
* NET  1979 = abc_6150_new_n1503
* NET  1980 = abc_6150_new_n1502
* NET  1981 = abc_6150_new_n1501
* NET  1982 = abc_6150_new_n1500
* NET  1983 = abc_6150_new_n1499
* NET  1984 = abc_6150_new_n1498
* NET  1985 = abc_6150_new_n1497
* NET  1986 = abc_6150_new_n1496
* NET  1987 = abc_6150_new_n1495
* NET  1988 = abc_6150_new_n1494
* NET  1989 = abc_6150_new_n1493
* NET  1990 = abc_6150_new_n1492
* NET  1991 = abc_6150_new_n1491
* NET  1992 = abc_6150_new_n1490
* NET  1993 = abc_6150_new_n1489
* NET  1994 = abc_6150_new_n1488
* NET  1995 = abc_6150_new_n1487
* NET  1996 = abc_6150_new_n1486
* NET  1997 = abc_6150_new_n1485
* NET  1998 = abc_6150_new_n1484
* NET  1999 = abc_6150_new_n1483
* NET  2000 = abc_6150_new_n1482
* NET  2001 = abc_6150_new_n1481
* NET  2002 = abc_6150_new_n1480
* NET  2003 = abc_6150_new_n1479
* NET  2004 = abc_6150_new_n1478
* NET  2005 = abc_6150_new_n1477
* NET  2006 = abc_6150_new_n1476
* NET  2007 = abc_6150_new_n1475
* NET  2008 = abc_6150_new_n1474
* NET  2009 = abc_6150_new_n1473
* NET  2010 = abc_6150_new_n1472
* NET  2011 = abc_6150_new_n1471
* NET  2012 = abc_6150_new_n1470
* NET  2013 = abc_6150_new_n1469
* NET  2014 = abc_6150_new_n1468
* NET  2015 = abc_6150_new_n1467
* NET  2016 = abc_6150_new_n1466
* NET  2017 = abc_6150_new_n1465
* NET  2018 = abc_6150_new_n1464
* NET  2019 = abc_6150_new_n1462
* NET  2020 = abc_6150_new_n1461
* NET  2021 = abc_6150_new_n1460
* NET  2022 = abc_6150_new_n1459
* NET  2023 = abc_6150_new_n1458
* NET  2024 = abc_6150_new_n1457
* NET  2025 = abc_6150_new_n1456
* NET  2026 = abc_6150_new_n1455
* NET  2027 = abc_6150_new_n1454
* NET  2028 = abc_6150_new_n1453
* NET  2029 = abc_6150_new_n1452
* NET  2030 = abc_6150_new_n1451
* NET  2031 = abc_6150_new_n1450
* NET  2032 = abc_6150_new_n1449
* NET  2033 = abc_6150_new_n1448
* NET  2034 = abc_6150_new_n1447
* NET  2035 = abc_6150_new_n1446
* NET  2036 = abc_6150_new_n1445
* NET  2037 = abc_6150_new_n1444
* NET  2038 = abc_6150_new_n1443
* NET  2039 = abc_6150_new_n1442
* NET  2040 = abc_6150_new_n1441
* NET  2041 = abc_6150_new_n1440
* NET  2042 = abc_6150_new_n1439
* NET  2043 = abc_6150_new_n1438
* NET  2044 = abc_6150_new_n1437
* NET  2045 = abc_6150_new_n1436
* NET  2046 = abc_6150_new_n1435
* NET  2047 = abc_6150_new_n1434
* NET  2048 = abc_6150_new_n1433
* NET  2049 = abc_6150_new_n1432
* NET  2050 = abc_6150_new_n1431
* NET  2051 = abc_6150_new_n1430
* NET  2052 = abc_6150_new_n1429
* NET  2053 = abc_6150_new_n1428
* NET  2054 = abc_6150_new_n1427
* NET  2055 = abc_6150_new_n1426
* NET  2056 = abc_6150_new_n1425
* NET  2057 = abc_6150_new_n1424
* NET  2058 = abc_6150_new_n1423
* NET  2059 = abc_6150_new_n1422
* NET  2060 = abc_6150_new_n1421
* NET  2061 = abc_6150_new_n1420
* NET  2062 = abc_6150_new_n1419
* NET  2063 = abc_6150_new_n1418
* NET  2064 = abc_6150_new_n1417
* NET  2065 = abc_6150_new_n1416
* NET  2066 = abc_6150_new_n1415
* NET  2067 = abc_6150_new_n1413
* NET  2068 = abc_6150_new_n1412
* NET  2069 = abc_6150_new_n1411
* NET  2070 = abc_6150_new_n1410
* NET  2071 = abc_6150_new_n1409
* NET  2072 = abc_6150_new_n1408
* NET  2073 = abc_6150_new_n1407
* NET  2074 = abc_6150_new_n1406
* NET  2075 = abc_6150_new_n1405
* NET  2076 = abc_6150_new_n1404
* NET  2077 = abc_6150_new_n1403
* NET  2078 = abc_6150_new_n1402
* NET  2079 = abc_6150_new_n1401
* NET  2080 = abc_6150_new_n1400
* NET  2081 = abc_6150_new_n1399
* NET  2082 = abc_6150_new_n1398
* NET  2083 = abc_6150_new_n1397
* NET  2084 = abc_6150_new_n1396
* NET  2085 = abc_6150_new_n1395
* NET  2086 = abc_6150_new_n1394
* NET  2087 = abc_6150_new_n1393
* NET  2088 = abc_6150_new_n1392
* NET  2089 = abc_6150_new_n1391
* NET  2090 = abc_6150_new_n1390
* NET  2091 = abc_6150_new_n1389
* NET  2092 = abc_6150_new_n1388
* NET  2093 = abc_6150_new_n1387
* NET  2094 = abc_6150_new_n1386
* NET  2095 = abc_6150_new_n1385
* NET  2096 = abc_6150_new_n1384
* NET  2097 = abc_6150_new_n1383
* NET  2098 = abc_6150_new_n1382
* NET  2099 = abc_6150_new_n1381
* NET  2100 = abc_6150_new_n1380
* NET  2101 = abc_6150_new_n1379
* NET  2102 = abc_6150_new_n1378
* NET  2103 = abc_6150_new_n1377
* NET  2104 = abc_6150_new_n1376
* NET  2105 = abc_6150_new_n1375
* NET  2106 = abc_6150_new_n1374
* NET  2107 = abc_6150_new_n1373
* NET  2108 = abc_6150_new_n1372
* NET  2109 = abc_6150_new_n1371
* NET  2110 = abc_6150_new_n1370
* NET  2111 = abc_6150_new_n1369
* NET  2112 = abc_6150_new_n1368
* NET  2113 = abc_6150_new_n1367
* NET  2114 = abc_6150_new_n1366
* NET  2115 = abc_6150_new_n1365
* NET  2116 = abc_6150_new_n1364
* NET  2117 = abc_6150_new_n1363
* NET  2118 = abc_6150_new_n1362
* NET  2119 = abc_6150_new_n1361
* NET  2120 = abc_6150_new_n1360
* NET  2121 = abc_6150_new_n1359
* NET  2122 = abc_6150_new_n1358
* NET  2123 = abc_6150_new_n1356
* NET  2124 = abc_6150_new_n1355
* NET  2125 = abc_6150_new_n1354
* NET  2126 = abc_6150_new_n1353
* NET  2127 = abc_6150_new_n1352
* NET  2128 = abc_6150_new_n1351
* NET  2129 = abc_6150_new_n1350
* NET  2130 = abc_6150_new_n1349
* NET  2131 = abc_6150_new_n1348
* NET  2132 = abc_6150_new_n1347
* NET  2133 = abc_6150_new_n1346
* NET  2134 = abc_6150_new_n1345
* NET  2135 = abc_6150_new_n1344
* NET  2136 = abc_6150_new_n1343
* NET  2137 = abc_6150_new_n1342
* NET  2138 = abc_6150_new_n1341
* NET  2139 = abc_6150_new_n1340
* NET  2140 = abc_6150_new_n1339
* NET  2141 = abc_6150_new_n1338
* NET  2142 = abc_6150_new_n1337
* NET  2143 = abc_6150_new_n1336
* NET  2144 = abc_6150_new_n1335
* NET  2145 = abc_6150_new_n1334
* NET  2146 = abc_6150_new_n1333
* NET  2147 = abc_6150_new_n1332
* NET  2148 = abc_6150_new_n1331
* NET  2149 = abc_6150_new_n1330
* NET  2150 = abc_6150_new_n1329
* NET  2151 = abc_6150_new_n1328
* NET  2152 = abc_6150_new_n1327
* NET  2153 = abc_6150_new_n1326
* NET  2154 = abc_6150_new_n1325
* NET  2155 = abc_6150_new_n1324
* NET  2156 = abc_6150_new_n1323
* NET  2157 = abc_6150_new_n1322
* NET  2158 = abc_6150_new_n1321
* NET  2159 = abc_6150_new_n1320
* NET  2160 = abc_6150_new_n1319
* NET  2161 = abc_6150_new_n1318
* NET  2162 = abc_6150_new_n1317
* NET  2163 = abc_6150_new_n1316
* NET  2164 = abc_6150_new_n1315
* NET  2165 = abc_6150_new_n1314
* NET  2166 = abc_6150_new_n1313
* NET  2167 = abc_6150_new_n1312
* NET  2168 = abc_6150_new_n1311
* NET  2169 = abc_6150_new_n1310
* NET  2170 = abc_6150_new_n1309
* NET  2171 = abc_6150_new_n1308
* NET  2172 = abc_6150_new_n1307
* NET  2173 = abc_6150_new_n1306
* NET  2174 = abc_6150_new_n1305
* NET  2175 = abc_6150_new_n1304
* NET  2176 = abc_6150_new_n1303
* NET  2177 = abc_6150_new_n1302
* NET  2178 = abc_6150_new_n1301
* NET  2179 = abc_6150_new_n1300
* NET  2180 = abc_6150_new_n1298
* NET  2181 = abc_6150_new_n1297
* NET  2182 = abc_6150_new_n1296
* NET  2183 = abc_6150_new_n1295
* NET  2184 = abc_6150_new_n1294
* NET  2185 = abc_6150_new_n1293
* NET  2186 = abc_6150_new_n1292
* NET  2187 = abc_6150_new_n1291
* NET  2188 = abc_6150_new_n1290
* NET  2189 = abc_6150_new_n1289
* NET  2190 = abc_6150_new_n1288
* NET  2191 = abc_6150_new_n1287
* NET  2192 = abc_6150_new_n1286
* NET  2193 = abc_6150_new_n1285
* NET  2194 = abc_6150_new_n1284
* NET  2195 = abc_6150_new_n1283
* NET  2196 = abc_6150_new_n1282
* NET  2197 = abc_6150_new_n1281
* NET  2198 = abc_6150_new_n1280
* NET  2199 = abc_6150_new_n1279
* NET  2200 = abc_6150_new_n1278
* NET  2201 = abc_6150_new_n1277
* NET  2202 = abc_6150_new_n1276
* NET  2203 = abc_6150_new_n1275
* NET  2204 = abc_6150_new_n1274
* NET  2205 = abc_6150_new_n1273
* NET  2206 = abc_6150_new_n1272
* NET  2207 = abc_6150_new_n1271
* NET  2208 = abc_6150_new_n1270
* NET  2209 = abc_6150_new_n1269
* NET  2210 = abc_6150_new_n1268
* NET  2211 = abc_6150_new_n1267
* NET  2212 = abc_6150_new_n1266
* NET  2213 = abc_6150_new_n1265
* NET  2214 = abc_6150_new_n1264
* NET  2215 = abc_6150_new_n1263
* NET  2216 = abc_6150_new_n1262
* NET  2217 = abc_6150_new_n1261
* NET  2218 = abc_6150_new_n1260
* NET  2219 = abc_6150_new_n1259
* NET  2220 = abc_6150_new_n1258
* NET  2221 = abc_6150_new_n1257
* NET  2222 = abc_6150_new_n1256
* NET  2223 = abc_6150_new_n1255
* NET  2224 = abc_6150_new_n1254
* NET  2225 = abc_6150_new_n1253
* NET  2226 = abc_6150_new_n1252
* NET  2227 = abc_6150_new_n1251
* NET  2228 = abc_6150_new_n1250
* NET  2229 = abc_6150_new_n1248
* NET  2230 = abc_6150_new_n1247
* NET  2231 = abc_6150_new_n1246
* NET  2232 = abc_6150_new_n1245
* NET  2233 = abc_6150_new_n1244
* NET  2234 = abc_6150_new_n1243
* NET  2235 = abc_6150_new_n1242
* NET  2236 = abc_6150_new_n1241
* NET  2237 = abc_6150_new_n1240
* NET  2238 = abc_6150_new_n1239
* NET  2239 = abc_6150_new_n1238
* NET  2240 = abc_6150_new_n1237
* NET  2241 = abc_6150_new_n1236
* NET  2242 = abc_6150_new_n1235
* NET  2243 = abc_6150_new_n1234
* NET  2244 = abc_6150_new_n1233
* NET  2245 = abc_6150_new_n1232
* NET  2246 = abc_6150_new_n1231
* NET  2247 = abc_6150_new_n1230
* NET  2248 = abc_6150_new_n1229
* NET  2249 = abc_6150_new_n1228
* NET  2250 = abc_6150_new_n1227
* NET  2251 = abc_6150_new_n1226
* NET  2252 = abc_6150_new_n1225
* NET  2253 = abc_6150_new_n1224
* NET  2254 = abc_6150_new_n1223
* NET  2255 = abc_6150_new_n1222
* NET  2256 = abc_6150_new_n1221
* NET  2257 = abc_6150_new_n1220
* NET  2258 = abc_6150_new_n1219
* NET  2259 = abc_6150_new_n1218
* NET  2260 = abc_6150_new_n1217
* NET  2261 = abc_6150_new_n1216
* NET  2262 = abc_6150_new_n1215
* NET  2263 = abc_6150_new_n1214
* NET  2264 = abc_6150_new_n1213
* NET  2265 = abc_6150_new_n1212
* NET  2266 = abc_6150_new_n1211
* NET  2267 = abc_6150_new_n1210
* NET  2268 = abc_6150_new_n1209
* NET  2269 = abc_6150_new_n1208
* NET  2270 = abc_6150_new_n1207
* NET  2271 = abc_6150_new_n1206
* NET  2272 = abc_6150_new_n1205
* NET  2273 = abc_6150_new_n1204
* NET  2274 = abc_6150_new_n1202
* NET  2275 = abc_6150_new_n1201
* NET  2276 = abc_6150_new_n1200
* NET  2277 = abc_6150_new_n1199
* NET  2278 = abc_6150_new_n1198
* NET  2279 = abc_6150_new_n1197
* NET  2280 = abc_6150_new_n1196
* NET  2281 = abc_6150_new_n1195
* NET  2282 = abc_6150_new_n1194
* NET  2283 = abc_6150_new_n1193
* NET  2284 = abc_6150_new_n1192
* NET  2285 = abc_6150_new_n1190
* NET  2286 = abc_6150_new_n1189
* NET  2287 = abc_6150_new_n1188
* NET  2288 = abc_6150_new_n1187
* NET  2289 = abc_6150_new_n1186
* NET  2290 = abc_6150_new_n1185
* NET  2291 = abc_6150_new_n1184
* NET  2292 = abc_6150_new_n1183
* NET  2293 = abc_6150_new_n1182
* NET  2294 = abc_6150_new_n1181
* NET  2295 = abc_6150_new_n1180
* NET  2296 = abc_6150_new_n1179
* NET  2297 = abc_6150_new_n1178
* NET  2298 = abc_6150_new_n1177
* NET  2299 = abc_6150_new_n1176
* NET  2300 = abc_6150_new_n1175
* NET  2301 = abc_6150_new_n1173
* NET  2302 = abc_6150_new_n1172
* NET  2303 = abc_6150_new_n1171
* NET  2304 = abc_6150_new_n1170
* NET  2305 = abc_6150_new_n1169
* NET  2306 = abc_6150_new_n1168
* NET  2307 = abc_6150_new_n1167
* NET  2308 = abc_6150_new_n1166
* NET  2309 = abc_6150_new_n1165
* NET  2310 = abc_6150_new_n1164
* NET  2311 = abc_6150_new_n1163
* NET  2312 = abc_6150_new_n1162
* NET  2313 = abc_6150_new_n1161
* NET  2314 = abc_6150_new_n1160
* NET  2315 = abc_6150_new_n1159
* NET  2316 = abc_6150_new_n1157
* NET  2317 = abc_6150_new_n1156
* NET  2318 = abc_6150_new_n1155
* NET  2319 = abc_6150_new_n1154
* NET  2320 = abc_6150_new_n1153
* NET  2321 = abc_6150_new_n1152
* NET  2322 = abc_6150_new_n1151
* NET  2323 = abc_6150_new_n1150
* NET  2324 = abc_6150_new_n1149
* NET  2325 = abc_6150_new_n1148
* NET  2326 = abc_6150_new_n1147
* NET  2327 = abc_6150_new_n1146
* NET  2328 = abc_6150_new_n1145
* NET  2329 = abc_6150_new_n1144
* NET  2330 = abc_6150_new_n1143
* NET  2331 = abc_6150_new_n1142
* NET  2332 = abc_6150_new_n1141
* NET  2333 = abc_6150_new_n1139
* NET  2334 = abc_6150_new_n1138
* NET  2335 = abc_6150_new_n1137
* NET  2336 = abc_6150_new_n1136
* NET  2337 = abc_6150_new_n1135
* NET  2338 = abc_6150_new_n1134
* NET  2339 = abc_6150_new_n1133
* NET  2340 = abc_6150_new_n1132
* NET  2341 = abc_6150_new_n1131
* NET  2342 = abc_6150_new_n1130
* NET  2343 = abc_6150_new_n1129
* NET  2344 = abc_6150_new_n1128
* NET  2345 = abc_6150_new_n1127
* NET  2346 = abc_6150_new_n1126
* NET  2347 = abc_6150_new_n1125
* NET  2348 = abc_6150_new_n1124
* NET  2349 = abc_6150_new_n1122
* NET  2350 = abc_6150_new_n1121
* NET  2351 = abc_6150_new_n1120
* NET  2352 = abc_6150_new_n1119
* NET  2353 = abc_6150_new_n1118
* NET  2354 = abc_6150_new_n1117
* NET  2355 = abc_6150_new_n1116
* NET  2356 = abc_6150_new_n1115
* NET  2357 = abc_6150_new_n1114
* NET  2358 = abc_6150_new_n1113
* NET  2359 = abc_6150_new_n1112
* NET  2360 = abc_6150_new_n1111
* NET  2361 = abc_6150_new_n1110
* NET  2362 = abc_6150_new_n1109
* NET  2363 = abc_6150_new_n1108
* NET  2364 = abc_6150_new_n1107
* NET  2365 = abc_6150_new_n1106
* NET  2366 = abc_6150_new_n1104
* NET  2367 = abc_6150_new_n1103
* NET  2368 = abc_6150_new_n1102
* NET  2369 = abc_6150_new_n1101
* NET  2370 = abc_6150_new_n1100
* NET  2371 = abc_6150_new_n1099
* NET  2372 = abc_6150_new_n1098
* NET  2373 = abc_6150_new_n1097
* NET  2374 = abc_6150_new_n1096
* NET  2375 = abc_6150_new_n1095
* NET  2376 = abc_6150_new_n1094
* NET  2377 = abc_6150_new_n1093
* NET  2378 = abc_6150_new_n1092
* NET  2379 = abc_6150_new_n1091
* NET  2380 = abc_6150_new_n1090
* NET  2381 = abc_6150_new_n1089
* NET  2382 = abc_6150_new_n1088
* NET  2383 = abc_6150_new_n1087
* NET  2384 = abc_6150_new_n1085
* NET  2385 = abc_6150_new_n1084
* NET  2386 = abc_6150_new_n1083
* NET  2387 = abc_6150_new_n1082
* NET  2388 = abc_6150_new_n1081
* NET  2389 = abc_6150_new_n1080
* NET  2390 = abc_6150_new_n1079
* NET  2391 = abc_6150_new_n1078
* NET  2392 = abc_6150_new_n1077
* NET  2393 = abc_6150_new_n1076
* NET  2394 = abc_6150_new_n1075
* NET  2395 = abc_6150_new_n1074
* NET  2396 = abc_6150_new_n1073
* NET  2397 = abc_6150_new_n1072
* NET  2398 = abc_6150_new_n1071
* NET  2399 = abc_6150_new_n1070
* NET  2400 = abc_6150_new_n1069
* NET  2401 = abc_6150_new_n1068
* NET  2402 = abc_6150_new_n1067
* NET  2403 = abc_6150_new_n1066
* NET  2404 = abc_6150_new_n1065
* NET  2405 = abc_6150_new_n1064
* NET  2406 = abc_6150_new_n1063
* NET  2407 = abc_6150_new_n1062
* NET  2408 = abc_6150_new_n1061
* NET  2409 = abc_6150_new_n1059
* NET  2410 = abc_6150_new_n1058
* NET  2411 = abc_6150_new_n1057
* NET  2412 = abc_6150_new_n1056
* NET  2413 = abc_6150_new_n1055
* NET  2414 = abc_6150_new_n1054
* NET  2415 = abc_6150_new_n1053
* NET  2416 = abc_6150_new_n1052
* NET  2417 = abc_6150_new_n1051
* NET  2418 = abc_6150_new_n1050
* NET  2419 = abc_6150_new_n1049
* NET  2420 = abc_6150_new_n1048
* NET  2421 = abc_6150_new_n1047
* NET  2422 = abc_6150_new_n1046
* NET  2423 = abc_6150_new_n1045
* NET  2424 = abc_6150_new_n1044
* NET  2425 = abc_6150_new_n1043
* NET  2426 = abc_6150_new_n1042
* NET  2427 = abc_6150_new_n1041
* NET  2428 = abc_6150_new_n1039
* NET  2429 = abc_6150_new_n1038
* NET  2430 = abc_6150_new_n1037
* NET  2431 = abc_6150_new_n1036
* NET  2432 = abc_6150_new_n1035
* NET  2433 = abc_6150_new_n1034
* NET  2434 = abc_6150_new_n1033
* NET  2435 = abc_6150_new_n1032
* NET  2436 = abc_6150_new_n1031
* NET  2437 = abc_6150_new_n1030
* NET  2438 = abc_6150_new_n1029
* NET  2439 = abc_6150_new_n1028
* NET  2440 = abc_6150_new_n1027
* NET  2441 = abc_6150_new_n1026
* NET  2442 = abc_6150_new_n1025
* NET  2443 = abc_6150_new_n1024
* NET  2444 = abc_6150_new_n1023
* NET  2445 = abc_6150_new_n1022
* NET  2446 = abc_6150_new_n1021
* NET  2447 = abc_6150_new_n1020
* NET  2448 = abc_6150_new_n1019
* NET  2449 = abc_6150_new_n1018
* NET  2450 = abc_6150_new_n1017
* NET  2451 = abc_6150_new_n1016
* NET  2452 = abc_6150_new_n1014
* NET  2453 = abc_6150_new_n1013
* NET  2454 = abc_6150_new_n1012
* NET  2455 = abc_6150_new_n1011
* NET  2456 = abc_6150_new_n1010
* NET  2457 = abc_6150_new_n1009
* NET  2458 = abc_6150_new_n1008
* NET  2459 = abc_6150_new_n1007
* NET  2460 = abc_6150_new_n1006
* NET  2461 = abc_6150_new_n1005
* NET  2462 = abc_6150_new_n1004
* NET  2463 = abc_6150_new_n1003
* NET  2464 = abc_6150_new_n1002
* NET  2465 = abc_6150_new_n1001
* NET  2466 = abc_6150_new_n1000
* NET  2467 = a[9]
* NET  2468 = a[8]
* NET  2469 = a[7]
* NET  2470 = a[6]
* NET  2471 = a[5]
* NET  2472 = a[4]
* NET  2473 = a[3]
* NET  2474 = a[2]
* NET  2475 = a[15]
* NET  2476 = a[14]
* NET  2477 = a[13]
* NET  2478 = a[12]
* NET  2479 = a[11]
* NET  2480 = a[10]
* NET  2481 = a[1]
* NET  2482 = a[0]

xsubckt_2289_and21nor_x0 53 52 967 971 973 802 and21nor_x0
xsubckt_2246_and2_x1 53 52 1014 1015 1020 and2_x1
xsubckt_1767_nand2_x0 53 52 1523 1524 1271 nand2_x0
xsubckt_1560_nand3_x0 53 52 1725 801 864 175 nand3_x0
xsubckt_1473_and3_x1 53 52 1810 1812 1821 1034 and3_x1
xsubckt_74_inv_x0 53 52 6 867 inv_x0
xsubckt_1042_or21nand_x0 53 52 2232 49 2233 2234 or21nand_x0
xsubckt_1279_and21nor_x0 53 52 2000 2015 2003 2002 and21nor_x0
xsubckt_2323_and21nor_x0 53 52 931 788 941 932 and21nor_x0
xsubckt_1599_nor2_x0 53 52 1687 2176 23 nor2_x0
xsubckt_381_nand2_x0 53 52 577 578 715 nand2_x0
xsubckt_738_mux2_x1 53 52 9 243 558 242 mux2_x1
xsubckt_847_nexor2_x0 53 52 2419 2422 2418 nexor2_x0
xsubckt_905_and21nor_x0 53 52 2363 2386 2383 2364 and21nor_x0
xsubckt_2207_or21nand_x0 53 52 1055 1057 1059 1063 or21nand_x0
xsubckt_2101_nand3_x0 53 52 1169 1843 1844 2236 nand3_x0
xsubckt_1769_and3_x1 53 52 1522 801 1099 175 and3_x1
xsubckt_1619_and21nor_x0 53 52 1667 57 59 71 and21nor_x0
xsubckt_1524_nexor2_x0 53 52 1765 1013 1760 nexor2_x0
xsubckt_248_nand3_x0 53 52 700 701 702 803 nand3_x0
xsubckt_800_and2_x1 53 52 2463 6 18 and2_x1
xsubckt_875_and2_x1 53 52 2391 61 62 and2_x1
xsubckt_998_nand3_x0 53 52 2275 2276 2277 563 nand3_x0
xsubckt_1097_and3_x1 53 52 2179 801 873 175 and3_x1
xsubckt_1122_nand3_x0 53 52 2154 2156 2178 46 nand3_x0
xsubckt_2219_or21nand_x0 53 52 1042 1071 1086 1087 or21nand_x0
xsubckt_2021_and2_x1 53 52 1255 1256 2244 and2_x1
xsubckt_1809_and3_x1 53 52 1482 1483 1484 1260 and3_x1
xsubckt_1650_or21nand_x0 53 52 1637 1646 1651 949 or21nand_x0
xsubckt_456_or2_x1 53 52 509 32 44 or2_x1
xsubckt_126_nexor2_x0 53 52 819 1282 816 nexor2_x0
xsubckt_53_inv_x0 53 52 39 900 inv_x0
xsubckt_778_or21nand_x0 53 52 204 226 224 225 or21nand_x0
xsubckt_799_or2_x1 53 52 2464 6 18 or2_x1
xsubckt_878_nexor2_x0 53 52 61 62 2388 nexor2_x0
xsubckt_1114_nand3_x0 53 52 2162 752 18 173 nand3_x0
xsubckt_2314_nexor2_x0 53 52 942 943 941 nexor2_x0
xsubckt_1929_nand2_x0 53 52 1354 1358 1359 nand2_x0
xsubckt_1778_and21nor_x0 53 52 1513 48 2270 1515 and21nor_x0
xsubckt_1677_mux2_x1 53 52 177 76 1923 1611 mux2_x1
xsubckt_1288_or21nand_x0 53 52 1991 1995 1999 43 or21nand_x0
xsubckt_485_or21nand_x0 53 52 481 76 74 75 or21nand_x0
xsubckt_100_or21nand_x0 53 52 841 845 1325 1368 or21nand_x0
xsubckt_34_inv_x0 53 52 46 1099 inv_x0
xsubckt_764_nand2_x0 53 52 217 8 68 nand2_x0
xsubckt_819_and2_x1 53 52 2445 2446 2450 and2_x1
xsubckt_2460_dff_x1 53 52 91 185 15 dff_x1
xsubckt_2415_dff_x1 53 52 136 185 70 dff_x1
xsubckt_2378_dff_x1 53 52 166 185 169 dff_x1
xsubckt_2112_mux2_x1 53 52 1158 1159 1271 95 mux2_x1
xsubckt_2088_nand2_x0 53 52 1183 1188 67 nand2_x0
xsubckt_1814_or21nand_x0 53 52 1478 1531 1492 1496 or21nand_x0
xsubckt_1471_or2_x1 53 52 1812 1813 799 or2_x1
xsubckt_530_or21nand_x0 53 52 438 462 461 460 or21nand_x0
xsubckt_505_and21nor_x0 53 52 462 495 496 497 and21nor_x0
xsubckt_384_or2_x1 53 52 575 169 186 or2_x1
xsubckt_120_and2_x1 53 52 821 823 77 and2_x1
xsubckt_24_inv_x0 53 52 170 1206 inv_x0
xsubckt_189_and21nor_x0 53 52 756 803 758 757 and21nor_x0
xsubckt_268_and21nor_x0 53 52 681 697 706 707 and21nor_x0
xsubckt_952_and21nor_x0 53 52 2318 2322 2323 562 and21nor_x0
xsubckt_1071_nand3_x0 53 52 2204 2210 2227 48 nand3_x0
xsubckt_1956_or21nand_x0 53 52 1326 771 1329 1331 or21nand_x0
xsubckt_1596_nand2_x0 53 52 1690 1691 176 nand2_x0
xsubckt_1585_and3_x1 53 52 1700 1792 856 857 and3_x1
xsubckt_1422_nand2_x0 53 52 1860 1861 811 nand2_x0
xsubckt_592_nexor2_x0 53 52 26 73 379 nexor2_x0
xsubckt_584_xor2_x0 53 52 47 69 387 xor2_x0
xsubckt_470_xor2_x0 53 52 31 75 496 xor2_x0
xsubckt_406_and4_x1 53 52 556 769 48 169 174 and4_x1
xsubckt_691_nexor2_x0 53 52 34 47 286 nexor2_x0
xsubckt_771_and21nor_x0 53 52 211 219 217 218 and21nor_x0
xsubckt_1026_or21nand_x0 53 52 2248 2250 2251 186 or21nand_x0
xsubckt_1127_and3_x1 53 52 2149 2156 2178 1099 and3_x1
xsubckt_2413_dff_x1 53 52 138 185 72 dff_x1
xsubckt_2332_nand4_x0 53 52 922 59 852 1282 1292 nand4_x0
xsubckt_2330_mux2_x1 53 52 57 858 850 924 mux2_x1
xsubckt_2228_or21nand_x0 53 52 1032 2240 1699 1033 or21nand_x0
xsubckt_1926_or21nand_x0 53 52 1358 1382 1402 1403 or21nand_x0
xsubckt_1632_and21nor_x0 53 52 1654 1715 1721 1724 and21nor_x0
xsubckt_1595_mux2_x1 53 52 179 43 1923 1691 mux2_x1
xsubckt_1536_and2_x1 53 52 1748 1799 900 and2_x1
xsubckt_501_xor2_x0 53 52 30 42 466 xor2_x0
xsubckt_435_nand2_x0 53 52 529 45 33 nand2_x0
xsubckt_138_nand2_x0 53 52 805 807 1346 nand2_x0
xsubckt_136_and21nor_x0 53 52 807 77 823 809 and21nor_x0
xsubckt_105_nor4_x0 53 52 836 2468 2467 2480 2479 nor4_x0
xsubckt_44_inv_x0 53 52 72 991 inv_x0
xsubckt_791_nand3_x0 53 52 191 193 197 198 nand3_x0
xsubckt_981_nand2_x0 53 52 2291 2292 563 nand2_x0
xsubckt_1603_or4_x1 53 52 1683 1687 1688 1689 799 or4_x1
xsubckt_1600_and3_x1 53 52 1686 801 62 175 and3_x1
xsubckt_445_and21nor_x0 53 52 519 521 563 568 and21nor_x0
xsubckt_2279_or21nand_x0 53 52 978 983 984 862 or21nand_x0
xsubckt_2157_and2_x1 53 52 1109 1111 176 and2_x1
xsubckt_533_and2_x1 53 52 435 436 438 and2_x1
xsubckt_486_nand2_x0 53 52 480 516 536 nand2_x0
xsubckt_103_nand2_x0 53 52 838 840 2469 nand2_x0
xsubckt_824_nand2_x0 53 52 2440 5 68 nand2_x0
xsubckt_1036_and3_x1 53 52 2238 59 1282 58 and3_x1
xsubckt_2436_dff_x1 53 52 117 185 33 dff_x1
xsubckt_1887_nexor2_x0 53 52 1410 873 1399 nexor2_x0
xsubckt_1448_and21nor_x0 53 52 1834 58 1835 2246 and21nor_x0
xsubckt_1354_nand2_x0 53 52 1926 1927 1271 nand2_x0
xsubckt_1335_nexor2_x0 53 52 1947 1949 1945 nexor2_x0
xsubckt_748_or21nand_x0 53 52 233 252 249 251 or21nand_x0
xsubckt_784_or3_x1 53 52 198 230 249 252 or3_x1
xsubckt_946_nand2_x0 53 52 2324 13 23 nand2_x0
xsubckt_1152_nand2_x0 53 52 2124 2125 1260 nand2_x0
xsubckt_2321_or21nand_x0 53 52 933 940 937 934 or21nand_x0
xsubckt_1752_nand3_x0 53 52 1538 801 1153 175 nand3_x0
xsubckt_1674_nand2_x0 53 52 1613 1614 1628 nand2_x0
xsubckt_1636_and3_x1 53 52 1651 801 860 175 and3_x1
xsubckt_548_and2_x1 53 52 421 422 558 and2_x1
xsubckt_226_and21nor_x0 53 52 721 742 744 746 and21nor_x0
xsubckt_673_nand2_x0 53 52 303 35 47 nand2_x0
xsubckt_729_nand2_x0 53 52 251 67 68 nand2_x0
xsubckt_2238_nand2_x0 53 52 1022 1023 176 nand2_x0
xsubckt_2160_nor2_x0 53 52 1106 1776 47 nor2_x0
xsubckt_1740_nand3_x0 53 52 1550 1551 1239 173 nand3_x0
xsubckt_1635_or21nand_x0 53 52 137 1652 1656 1690 or21nand_x0
xsubckt_1597_nor3_x0 53 52 1689 63 174 173 nor3_x0
xsubckt_1286_mux2_x1 53 52 879 2000 798 1993 mux2_x1
xsubckt_382_and21nor_x0 53 52 576 803 589 577 and21nor_x0
xsubckt_324_nand2_x0 53 52 147 629 639 nand2_x0
xsubckt_49_inv_x0 53 52 27 938 inv_x0
xsubckt_188_nor2_x0 53 52 757 186 2474 nor2_x0
xsubckt_719_nand2_x0 53 52 260 16 19 nand2_x0
xsubckt_881_or21nand_x0 53 52 2385 2394 2393 2389 or21nand_x0
xsubckt_1236_nexor2_x0 53 52 2049 44 2042 nexor2_x0
xsubckt_1243_nexor2_x0 53 52 2037 2043 2035 nexor2_x0
xsubckt_2224_nand2_x0 53 52 1037 1038 1044 nand2_x0
xsubckt_1780_and3_x1 53 52 1511 2271 76 1228 and3_x1
xsubckt_1733_nand2_x0 53 52 1556 1557 1260 nand2_x0
xsubckt_1417_and2_x1 53 52 1865 23 173 and2_x1
xsubckt_1359_mux2_x1 53 52 184 49 1923 1922 mux2_x1
xsubckt_375_or2_x1 53 52 582 583 176 or2_x1
xsubckt_358_or21nand_x0 53 52 598 599 600 820 or21nand_x0
xsubckt_1014_and3_x1 53 52 2260 2261 2262 814 and3_x1
xsubckt_2388_dff_x1 53 52 154 185 2474 dff_x1
xsubckt_1962_nand3_x0 53 52 1319 1321 1322 798 nand3_x0
xsubckt_1586_nexor2_x0 53 52 1741 856 1699 nexor2_x0
xsubckt_1581_and21nor_x0 53 52 1704 57 59 72 and21nor_x0
xsubckt_506_nor2_x0 53 52 461 30 74 nor2_x0
xsubckt_69_inv_x0 53 52 67 872 inv_x0
xsubckt_1012_nand3_x0 53 52 2262 752 20 173 nand3_x0
xsubckt_1123_and21nor_x0 53 52 2153 2156 2178 46 and21nor_x0
xsubckt_1781_nand3_x0 53 52 1510 2271 76 1228 nand3_x0
xsubckt_1614_and21nor_x0 53 52 1672 1675 1677 787 and21nor_x0
xsubckt_1572_and2_x1 53 52 1713 1714 1716 and2_x1
xsubckt_1297_nexor2_x0 53 52 1984 1988 1982 nexor2_x0
xsubckt_561_or21nand_x0 53 52 409 426 424 425 or21nand_x0
xsubckt_297_or21nand_x0 53 52 653 656 668 1400 or21nand_x0
xsubckt_1015_nand3_x0 53 52 2259 2261 2262 814 nand3_x0
xsubckt_1153_or21nand_x0 53 52 2123 2124 2126 1271 or21nand_x0
xsubckt_1249_mux2_x1 53 52 1282 1142 850 2029 mux2_x1
xsubckt_2163_nor3_x0 53 52 1103 1104 1105 1106 nor3_x0
xsubckt_1985_nand4_x0 53 52 1294 59 30 1282 58 nand4_x0
xsubckt_1885_and2_x1 53 52 1402 1409 21 and2_x1
xsubckt_1843_nand3_x0 53 52 1447 1448 1449 803 nand3_x0
xsubckt_1671_nand2_x0 53 52 1616 1617 1260 nand2_x0
xsubckt_1631_or21nand_x0 53 52 1655 1714 1722 1723 or21nand_x0
xsubckt_1604_nand2_x0 53 52 1682 1683 1685 nand2_x0
xsubckt_1515_nand3_x0 53 52 1769 769 864 174 nand3_x0
xsubckt_1437_and3_x1 53 52 1845 1940 938 959 and3_x1
xsubckt_603_or21nand_x0 53 52 369 70 47 69 or21nand_x0
xsubckt_197_nand2_x0 53 52 749 751 1249 nand2_x0
xsubckt_1129_and21nor_x0 53 52 2147 2200 2202 2205 and21nor_x0
xsubckt_1744_nand4_x0 53 52 1546 76 175 174 173 nand4_x0
xsubckt_442_xor2_x0 53 52 33 42 522 xor2_x0
xsubckt_414_or2_x1 53 52 549 46 40 or2_x1
xsubckt_270_or2_x1 53 52 679 681 683 or2_x1
xsubckt_860_xor2_x0 53 52 3 66 2406 xor2_x0
xsubckt_914_xor2_x0 53 52 15 61 2354 xor2_x0
xsubckt_1232_nand2_x0 53 52 2046 2049 44 nand2_x0
xsubckt_1247_nand2_x0 53 52 2031 2032 2241 nand2_x0
xsubckt_2368_nand2_x0 53 52 889 890 902 nand2_x0
xsubckt_2136_nexor2_x0 53 52 1134 1135 1132 nexor2_x0
xsubckt_1453_or21nand_x0 53 52 1829 787 1846 1830 or21nand_x0
xsubckt_1426_or21nand_x0 53 52 1856 1869 1859 1857 or21nand_x0
xsubckt_1372_and3_x1 53 52 1909 801 872 175 and3_x1
xsubckt_630_and21nor_x0 53 52 343 357 358 359 and21nor_x0
xsubckt_65_inv_x0 53 52 22 876 inv_x0
xsubckt_216_nand2_x0 53 52 730 731 176 nand2_x0
xsubckt_289_nand2_x0 53 52 661 662 176 nand2_x0
xsubckt_1003_and2_x1 53 52 2271 174 173 and2_x1
xsubckt_1084_and3_x1 53 52 2191 2193 2243 1292 and3_x1
xsubckt_1157_nand3_x0 53 52 2120 2122 174 1249 nand3_x0
xsubckt_2271_mux2_x1 53 52 178 18 1200 987 mux2_x1
xsubckt_2172_nand2_x0 53 52 1093 1095 798 nand2_x0
xsubckt_1852_or21nand_x0 53 52 1437 1292 1077 2247 or21nand_x0
xsubckt_1684_and2_x1 53 52 1604 1608 69 and2_x1
xsubckt_1508_or21nand_x0 53 52 1776 175 174 173 or21nand_x0
xsubckt_1507_nand3_x0 53 52 1777 801 866 175 nand3_x0
xsubckt_633_xor2_x0 53 52 38 47 340 xor2_x0
xsubckt_412_nexor2_x0 53 52 566 1088 551 nexor2_x0
xsubckt_117_and2_x1 53 52 824 825 1314 and2_x1
xsubckt_774_nor2_x0 53 52 208 209 210 nor2_x0
xsubckt_936_or21nand_x0 53 52 2333 2334 2340 567 or21nand_x0
xsubckt_1250_nor2_x0 53 52 2028 2029 2030 nor2_x0
xsubckt_2229_nand4_x0 53 52 1031 59 891 1282 58 nand4_x0
xsubckt_1760_nor3_x0 53 52 1530 1534 1535 1260 nor3_x0
xsubckt_1327_nor2_x0 53 52 1953 1954 1131 nor2_x0
xsubckt_844_or2_x1 53 52 2421 4 67 or2_x1
xsubckt_996_nand3_x0 53 52 2277 2282 2293 2299 nand3_x0
xsubckt_1060_nand2_x0 53 52 2215 20 174 nand2_x0
xsubckt_2222_and21nor_x0 53 52 1039 1083 1086 1091 and21nor_x0
xsubckt_2147_or21nand_x0 53 52 1119 1126 1123 1121 or21nand_x0
xsubckt_1735_and21nor_x0 53 52 1554 1572 1571 1555 and21nor_x0
xsubckt_1606_nand3_x0 53 52 1680 1683 1685 71 nand3_x0
xsubckt_1472_or21nand_x0 53 52 1811 799 1813 1821 or21nand_x0
xsubckt_432_nexor2_x0 53 52 533 535 532 nexor2_x0
xsubckt_256_nexor2_x0 53 52 842 1379 692 nexor2_x0
xsubckt_723_nand2_x0 53 52 256 259 262 nand2_x0
xsubckt_761_and21nor_x0 53 52 220 558 222 221 and21nor_x0
xsubckt_1233_and2_x1 53 52 2045 2048 44 and2_x1
xsubckt_1238_and21nor_x0 53 52 2040 2095 2089 2094 and21nor_x0
xsubckt_2397_dff_x1 53 52 159 185 2479 dff_x1
xsubckt_2122_and21nor_x0 53 52 1147 74 801 1148 and21nor_x0
xsubckt_2085_and3_x1 53 52 1187 1190 1193 67 and3_x1
xsubckt_1501_or21nand_x0 53 52 1782 787 1783 1786 or21nand_x0
xsubckt_1444_and21nor_x0 53 52 1838 2241 1842 1839 and21nor_x0
xsubckt_604_nand3_x0 53 52 368 369 687 169 nand3_x0
xsubckt_516_and2_x1 53 52 452 71 72 and2_x1
xsubckt_743_nexor2_x0 53 52 238 241 237 nexor2_x0
xsubckt_843_or21nand_x0 53 52 2422 2442 2441 2440 or21nand_x0
xsubckt_1681_mux2_x1 53 52 860 858 686 1607 mux2_x1
xsubckt_531_and2_x1 53 52 437 29 73 and2_x1
xsubckt_422_nand2_x0 53 52 541 40 43 nand2_x0
xsubckt_203_nexor2_x0 53 52 747 2473 743 nexor2_x0
xsubckt_734_nor2_x0 53 52 246 21 9 nor2_x0
xsubckt_765_xor2_x0 53 52 8 68 216 xor2_x0
xsubckt_966_nexor2_x0 53 52 12 23 2305 nexor2_x0
xsubckt_1188_or21nand_x0 53 52 2089 2147 2149 2150 or21nand_x0
xsubckt_2095_nand3_x0 53 52 1176 1177 1178 803 nand3_x0
xsubckt_1861_nand3_x0 53 52 1428 1520 174 1249 nand3_x0
xsubckt_1653_and21nor_x0 53 52 1634 1654 1677 1681 and21nor_x0
xsubckt_1373_and2_x1 53 52 1908 1910 798 and2_x1
xsubckt_597_nor2_x0 53 52 374 26 70 nor2_x0
xsubckt_1077_and3_x1 53 52 2198 2200 2202 2204 and3_x1
xsubckt_1278_nand3_x0 53 52 2001 769 68 174 nand3_x0
xsubckt_1742_nand2_x0 53 52 1548 2270 49 nand2_x0
xsubckt_1498_and21nor_x0 53 52 1785 1847 1850 1854 and21nor_x0
xsubckt_1466_nand3_x0 53 52 1817 752 862 173 nand3_x0
xsubckt_28_inv_x0 53 52 41 1163 inv_x0
xsubckt_968_nand3_x0 53 52 2303 2305 2319 2324 nand3_x0
xsubckt_1450_and2_x1 53 52 1832 1833 787 and2_x1
xsubckt_1425_and2_x1 53 52 1857 1858 798 and2_x1
xsubckt_1419_nand4_x0 53 52 1863 1864 1866 1867 770 nand4_x0
xsubckt_1390_and21nor_x0 53 52 1891 1942 1949 1953 and21nor_x0
xsubckt_1375_and2_x1 53 52 1906 1907 1088 and2_x1
xsubckt_573_nand2_x0 53 52 397 429 451 nand2_x0
xsubckt_557_mux2_x1 53 52 413 427 568 112 mux2_x1
xsubckt_366_and21nor_x0 53 52 591 593 658 803 and21nor_x0
xsubckt_50_inv_x0 53 52 69 927 inv_x0
xsubckt_220_nexor2_x0 53 52 749 1368 727 nexor2_x0
xsubckt_951_nand2_x0 53 52 2319 2322 2323 nand2_x0
xsubckt_1143_nand4_x0 53 52 2133 59 9 57 58 nand4_x0
xsubckt_2305_mux2_x1 53 52 177 68 1200 951 mux2_x1
xsubckt_2286_and21nor_x0 53 52 971 990 1008 1012 and21nor_x0
xsubckt_2109_or21nand_x0 53 52 1160 2247 1165 1161 or21nand_x0
xsubckt_1928_nand2_x0 53 52 1355 1356 1360 nand2_x0
xsubckt_1796_and2_x1 53 52 1495 1498 24 and2_x1
xsubckt_512_mux2_x1 53 52 456 470 568 114 mux2_x1
xsubckt_17_inv_x0 53 52 57 1282 inv_x0
xsubckt_1960_nand3_x0 53 52 1321 813 1056 1249 nand3_x0
xsubckt_1693_or21nand_x0 53 52 1595 36 1670 35 or21nand_x0
xsubckt_1492_nexor2_x0 53 52 1837 2 1791 nexor2_x0
xsubckt_618_or21nand_x0 53 52 354 355 356 567 or21nand_x0
xsubckt_560_xor2_x0 53 52 27 74 410 xor2_x0
xsubckt_67_inv_x0 53 52 9 874 inv_x0
xsubckt_933_xor2_x0 53 52 14 23 2336 xor2_x0
xsubckt_950_and2_x1 53 52 2320 2322 2323 and2_x1
xsubckt_2451_dff_x1 53 52 92 185 16 dff_x1
xsubckt_2338_or21nand_x0 53 52 915 918 1576 788 or21nand_x0
xsubckt_1964_or21nand_x0 53 52 1317 1327 1323 1320 or21nand_x0
xsubckt_1820_and4_x1 53 52 1472 1473 1474 1475 770 and4_x1
xsubckt_1629_nand2_x0 53 52 1657 1658 802 nand2_x0
xsubckt_1556_nand3_x0 53 52 1729 813 61 1249 nand3_x0
xsubckt_634_nexor2_x0 53 52 340 343 339 nexor2_x0
xsubckt_586_nand3_x0 53 52 385 387 389 394 nand3_x0
xsubckt_523_nor2_x0 53 52 445 29 76 nor2_x0
xsubckt_283_and4_x1 53 52 666 669 823 839 77 and4_x1
xsubckt_308_nand3_x0 53 52 643 645 646 1411 nand3_x0
xsubckt_873_nand2_x0 53 52 2393 2425 2447 nand2_x0
xsubckt_991_nexor2_x0 53 52 10 23 2282 nexor2_x0
xsubckt_1021_and21nor_x0 53 52 2253 2263 2260 2254 and21nor_x0
xsubckt_2418_dff_x1 53 52 109 185 25 dff_x1
xsubckt_2375_dff_x1 53 52 167 185 176 dff_x1
xsubckt_2111_mux2_x1 53 52 183 24 1200 1158 mux2_x1
xsubckt_1853_nand2_x0 53 52 1436 1437 1438 nand2_x0
xsubckt_1566_nand3_x0 53 52 1719 1725 1727 72 nand3_x0
xsubckt_1563_and21nor_x0 53 52 1722 1725 1727 991 and21nor_x0
xsubckt_1350_nand2_x0 53 52 1930 1931 1934 nand2_x0
xsubckt_1331_nexor2_x0 53 52 1954 42 1949 nexor2_x0
xsubckt_564_or21nand_x0 53 52 406 938 558 562 or21nand_x0
xsubckt_479_nexor2_x0 53 52 488 489 487 nexor2_x0
xsubckt_292_or21nand_x0 53 52 658 681 683 684 or21nand_x0
xsubckt_937_nand2_x0 53 52 90 2333 2347 nand2_x0
xsubckt_1868_and2_x1 53 52 1420 1421 811 and2_x1
xsubckt_1755_and21nor_x0 53 52 1535 1536 1538 849 and21nor_x0
xsubckt_1391_or21nand_x0 53 52 1890 1943 1948 1952 or21nand_x0
xsubckt_377_and2_x1 53 52 156 581 584 and2_x1
xsubckt_367_or21nand_x0 53 52 590 592 659 802 or21nand_x0
xsubckt_359_nand3_x0 53 52 597 823 829 77 nand3_x0
xsubckt_75_inv_x0 53 52 64 866 inv_x0
xsubckt_1038_and3_x1 53 52 2236 59 57 58 and3_x1
xsubckt_1239_nexor2_x0 53 52 2041 2043 2039 nexor2_x0
xsubckt_2110_nand3_x0 53 52 1159 1160 1170 1176 nand3_x0
xsubckt_2025_or21nand_x0 53 52 1251 787 1263 1252 or21nand_x0
xsubckt_1980_nexor2_x0 53 52 1301 1308 1299 nexor2_x0
xsubckt_1862_nand4_x0 53 52 1427 73 175 174 173 nand4_x0
xsubckt_1349_or21nand_x0 53 52 1931 1292 1932 2247 or21nand_x0
xsubckt_834_or21nand_x0 53 52 2430 2432 2434 563 or21nand_x0
xsubckt_2364_and2_x1 53 52 165 894 56 and2_x1
xsubckt_1888_nexor2_x0 53 52 1410 21 1398 nexor2_x0
xsubckt_121_nand2_x0 53 52 820 823 77 nand2_x0
xsubckt_15_inv_x0 53 52 77 1303 inv_x0
xsubckt_1909_and21nor_x0 53 52 1376 1228 1378 1377 and21nor_x0
xsubckt_1753_and2_x1 53 52 1537 1539 798 and2_x1
xsubckt_1447_nexor2_x0 53 52 1882 861 1835 nexor2_x0
xsubckt_1431_nand2_x0 53 52 1851 1855 75 nand2_x0
xsubckt_1412_nand3_x0 53 52 1870 801 870 175 nand3_x0
xsubckt_815_or2_x1 53 52 2449 63 64 or2_x1
xsubckt_1786_and3_x1 53 52 1505 769 45 174 and3_x1
xsubckt_1424_nand3_x0 53 52 1858 769 65 174 nand3_x0
xsubckt_35_inv_x0 53 52 76 1088 inv_x0
xsubckt_754_nand2_x0 53 52 227 228 229 nand2_x0
xsubckt_1117_and21nor_x0 53 52 2159 2168 2163 2160 and21nor_x0
xsubckt_1961_and3_x1 53 52 1320 1321 1322 798 and3_x1
xsubckt_1785_or21nand_x0 53 52 1506 1509 1518 814 or21nand_x0
xsubckt_1598_and3_x1 53 52 1688 769 860 174 and3_x1
xsubckt_407_nand4_x0 53 52 555 769 48 169 174 nand4_x0
xsubckt_85_inv_x0 53 52 14 856 inv_x0
xsubckt_1099_and21nor_x0 53 52 2177 174 20 175 and21nor_x0
xsubckt_1145_nand4_x0 53 52 2131 2132 2133 2134 2237 nand4_x0
xsubckt_2392_dff_x1 53 52 150 185 2470 dff_x1
xsubckt_2358_nand2_x0 53 52 898 1924 848 nand2_x0
xsubckt_2355_nand3_x0 53 52 902 848 170 1217 nand3_x0
xsubckt_2035_nand2_x0 53 52 1241 1242 1244 nand2_x0
xsubckt_1946_and21nor_x0 53 52 99 1337 1353 176 and21nor_x0
xsubckt_1934_and2_x1 53 52 1349 2033 2236 and2_x1
xsubckt_1651_nexor2_x0 53 52 1645 70 1636 nexor2_x0
xsubckt_1568_or21nand_x0 53 52 1717 1726 1728 991 or21nand_x0
xsubckt_439_or21nand_x0 53 52 525 543 542 541 or21nand_x0
xsubckt_296_nand3_x0 53 52 654 655 667 2469 nand3_x0
xsubckt_653_nand2_x0 53 52 321 322 325 nand2_x0
xsubckt_779_nexor2_x0 53 52 204 205 203 nexor2_x0
xsubckt_1220_and2_x1 53 52 2058 2059 811 and2_x1
xsubckt_2407_dff_x1 53 52 130 185 43 dff_x1
xsubckt_2380_dff_x1 53 52 163 185 54 dff_x1
xsubckt_2283_or3_x1 53 52 974 983 984 62 or3_x1
xsubckt_2001_nand2_x0 53 52 1277 74 174 nand2_x0
xsubckt_1911_and2_x1 53 52 1374 1552 801 and2_x1
xsubckt_1822_and3_x1 53 52 1470 1547 1239 173 and3_x1
xsubckt_1474_nand3_x0 53 52 1809 1812 1821 1034 nand3_x0
xsubckt_1379_and2_x1 53 52 1902 1907 76 and2_x1
xsubckt_1324_nand3_x0 53 52 1956 801 875 175 nand3_x0
xsubckt_1300_nexor2_x0 53 52 2034 1002 1979 nexor2_x0
xsubckt_559_nand2_x0 53 52 411 27 74 nand2_x0
xsubckt_155_nand2_x0 53 52 789 790 803 nand2_x0
xsubckt_61_inv_x0 53 52 20 880 inv_x0
xsubckt_281_and3_x1 53 52 668 823 839 77 and3_x1
xsubckt_976_nand3_x0 53 52 2296 2308 2322 2323 nand3_x0
xsubckt_1051_mux2_x1 53 52 24 174 173 2224 mux2_x1
xsubckt_1083_nexor2_x0 53 52 40 41 2192 nexor2_x0
xsubckt_1162_nand3_x0 53 52 2115 2117 2118 770 nand3_x0
xsubckt_2216_nexor2_x0 53 52 1055 866 1046 nexor2_x0
xsubckt_2146_and2_x1 53 52 1121 1122 2244 and2_x1
xsubckt_1669_or21nand_x0 53 52 1618 1292 1620 2247 or21nand_x0
xsubckt_93_inv_x0 53 52 56 848 inv_x0
xsubckt_777_nexor2_x0 53 52 7 19 205 nexor2_x0
xsubckt_1226_nand3_x0 53 52 2052 801 878 175 nand3_x0
xsubckt_1253_nexor2_x0 53 52 2074 7 2025 nexor2_x0
xsubckt_2409_dff_x1 53 52 128 185 76 dff_x1
xsubckt_2046_or2_x1 53 52 1229 1231 68 or2_x1
xsubckt_1679_nand2_x0 53 52 1609 1611 176 nand2_x0
xsubckt_411_and2_x1 53 52 125 552 564 and2_x1
xsubckt_400_nand3_x0 53 52 562 801 169 175 nand3_x0
xsubckt_108_nand2_x0 53 52 833 836 1443 nand2_x0
xsubckt_206_or2_x1 53 52 740 742 744 or2_x1
xsubckt_211_nand3_x0 53 52 735 736 737 788 nand3_x0
xsubckt_675_nexor2_x0 53 52 35 47 301 nexor2_x0
xsubckt_963_or2_x1 53 52 2308 12 23 or2_x1
xsubckt_2428_dff_x1 53 52 107 185 65 dff_x1
xsubckt_2264_nand2_x0 53 52 994 995 802 nand2_x0
xsubckt_2064_or21nand_x0 53 52 1209 1215 1213 1210 or21nand_x0
xsubckt_1332_nexor2_x0 53 52 1954 1131 1948 nexor2_x0
xsubckt_1294_nand2_x0 53 52 1985 1986 803 nand2_x0
xsubckt_611_or21nand_x0 53 52 361 39 558 562 or21nand_x0
xsubckt_686_or21nand_x0 53 52 290 557 292 291 or21nand_x0
xsubckt_1010_and3_x1 53 52 2264 2265 2266 2267 and3_x1
xsubckt_1191_and21nor_x0 53 52 2086 2141 2152 2155 and21nor_x0
xsubckt_1199_nand4_x0 53 52 2078 59 8 57 58 nand4_x0
xsubckt_1201_and3_x1 53 52 2076 2077 2078 2237 and3_x1
xsubckt_2260_and4_x1 53 52 998 59 886 1282 58 and4_x1
xsubckt_2012_and21nor_x0 53 52 1265 1300 1307 1310 and21nor_x0
xsubckt_1830_nand3_x0 53 52 1461 769 44 174 nand3_x0
xsubckt_1611_or21nand_x0 53 52 1675 1720 1710 1717 or21nand_x0
xsubckt_1567_and21nor_x0 53 52 1718 1725 1727 72 and21nor_x0
xsubckt_1384_nexor2_x0 53 52 1907 1088 1897 nexor2_x0
xsubckt_667_or21nand_x0 53 52 308 329 324 310 or21nand_x0
xsubckt_739_or21nand_x0 53 52 241 261 258 260 or21nand_x0
xsubckt_915_and21nor_x0 53 52 2353 2371 2369 2370 and21nor_x0
xsubckt_1134_and21nor_x0 53 52 2142 2250 2206 2209 and21nor_x0
xsubckt_2453_dff_x1 53 52 84 185 8 dff_x1
xsubckt_2362_nand3_x0 53 52 895 902 1202 176 nand3_x0
xsubckt_2192_or21nand_x0 53 52 1071 1133 1141 1143 or21nand_x0
xsubckt_1584_and21nor_x0 53 52 1701 2241 1705 1702 and21nor_x0
xsubckt_1434_or21nand_x0 53 52 1848 1902 1890 1899 or21nand_x0
xsubckt_1415_nand3_x0 53 52 1867 2271 61 1228 nand3_x0
xsubckt_1293_nexor2_x0 53 52 1988 2017 1986 nexor2_x0
xsubckt_544_or2_x1 53 52 425 28 75 or2_x1
xsubckt_1204_nexor2_x0 53 52 2130 8 2073 nexor2_x0
xsubckt_2430_dff_x1 53 52 105 185 63 dff_x1
xsubckt_2370_nand3_x0 53 52 887 898 899 1185 nand3_x0
xsubckt_1374_and21nor_x0 53 52 1907 1911 1908 1909 and21nor_x0
xsubckt_477_nexor2_x0 53 52 31 43 489 nexor2_x0
xsubckt_265_nand2_x0 53 52 684 687 2470 nand2_x0
xsubckt_674_xor2_x0 53 52 35 47 302 xor2_x0
xsubckt_768_or21nand_x0 53 52 84 214 220 227 or21nand_x0
xsubckt_811_and2_x1 53 52 2452 2453 2459 and2_x1
xsubckt_825_xor2_x0 53 52 5 68 2439 xor2_x0
xsubckt_2294_and2_x1 53 52 962 963 788 and2_x1
xsubckt_2125_and21nor_x0 53 52 1144 1145 1156 66 and21nor_x0
xsubckt_2089_nexor2_x0 53 52 1189 872 1182 nexor2_x0
xsubckt_1838_nand2_x0 53 52 1452 1457 22 nand2_x0
xsubckt_1810_and21nor_x0 53 52 1481 1482 1485 803 and21nor_x0
xsubckt_1731_or21nand_x0 53 52 1558 1292 1559 2247 or21nand_x0
xsubckt_1633_nexor2_x0 53 52 1655 1677 1653 nexor2_x0
xsubckt_1388_and21nor_x0 53 52 1893 1895 1897 802 and21nor_x0
xsubckt_1362_nand4_x0 53 52 1919 61 175 174 173 nand4_x0
xsubckt_390_and21nor_x0 53 52 145 571 572 176 and21nor_x0
xsubckt_380_nand3_x0 53 52 578 186 2476 1465 nand3_x0
xsubckt_865_or2_x1 53 52 2401 3 63 or2_x1
xsubckt_901_and21nor_x0 53 52 2366 2367 563 568 and21nor_x0
xsubckt_977_nand3_x0 53 52 2295 2307 2319 2324 nand3_x0
xsubckt_1090_nand4_x0 53 52 2185 2186 59 1282 58 nand4_x0
xsubckt_1181_and2_x1 53 52 2096 2101 1066 and2_x1
xsubckt_1193_nand2_x0 53 52 2084 2086 2092 nand2_x0
xsubckt_2432_dff_x1 53 52 103 185 61 dff_x1
xsubckt_2218_and21nor_x0 53 52 1043 1070 1085 1089 and21nor_x0
xsubckt_1941_or21nand_x0 53 52 1341 1349 1344 1342 or21nand_x0
xsubckt_1725_and21nor_x0 53 52 1564 57 59 47 and21nor_x0
xsubckt_1675_mux2_x1 53 52 178 42 1923 1612 mux2_x1
xsubckt_1539_and4_x1 53 52 1745 59 15 57 58 and4_x1
xsubckt_528_or21nand_x0 53 52 440 442 557 562 or21nand_x0
xsubckt_141_and2_x1 53 52 803 186 1465 and2_x1
xsubckt_134_and2_x1 53 52 809 810 186 and2_x1
xsubckt_1017_nand2_x0 53 52 2257 21 174 nand2_x0
xsubckt_1533_nand2_x0 53 52 1751 1753 1759 nand2_x0
xsubckt_433_and21nor_x0 53 52 531 550 549 548 and21nor_x0
xsubckt_39_inv_x0 53 52 32 1045 inv_x0
xsubckt_0_inv_x0 53 52 2475 1465 inv_x0
xsubckt_208_or21nand_x0 53 52 738 762 763 766 or21nand_x0
xsubckt_260_nand2_x0 53 52 688 689 176 nand2_x0
xsubckt_680_nand4_x0 53 52 296 300 301 311 328 nand4_x0
xsubckt_987_and21nor_x0 53 52 2285 2286 2290 568 and21nor_x0
xsubckt_2445_dff_x1 53 52 122 185 38 dff_x1
xsubckt_2329_and2_x1 53 52 925 1565 2236 and2_x1
xsubckt_2282_and2_x1 53 52 975 980 62 and2_x1
xsubckt_2119_and3_x1 53 52 1150 72 174 1249 and3_x1
xsubckt_1914_nand2_x0 53 52 1371 73 174 nand2_x0
xsubckt_300_mux2_x1 53 52 2470 178 777 651 mux2_x1
xsubckt_1200_nand2_x0 53 52 2077 2242 45 nand2_x0
xsubckt_1255_nand4_x0 53 52 2023 59 31 1282 1292 nand4_x0
xsubckt_2420_dff_x1 53 52 101 185 22 dff_x1
xsubckt_2206_nand2_x0 53 52 1057 1058 798 nand2_x0
xsubckt_1992_nand3_x0 53 52 1287 2271 970 1228 nand3_x0
xsubckt_1729_nexor2_x0 53 52 1590 852 1560 nexor2_x0
xsubckt_1634_or21nand_x0 53 52 1652 1653 802 1271 or21nand_x0
xsubckt_1506_and3_x1 53 52 1778 801 866 175 and3_x1
xsubckt_1305_and4_x1 53 52 1974 59 1002 1282 1292 and4_x1
xsubckt_448_or21nand_x0 53 52 517 533 534 536 or21nand_x0
xsubckt_353_nand3_x0 53 52 602 604 605 2478 nand3_x0
xsubckt_73_inv_x0 53 52 65 868 inv_x0
xsubckt_740_or2_x1 53 52 240 9 18 or2_x1
xsubckt_947_xor2_x0 53 52 13 23 2323 xor2_x0
xsubckt_989_or21nand_x0 53 52 2284 2289 2297 2299 or21nand_x0
xsubckt_2447_dff_x1 53 52 120 185 36 dff_x1
xsubckt_2072_nand4_x0 53 52 1200 1185 1196 170 50 nand4_x0
xsubckt_1994_mux2_x1 53 52 42 174 173 1285 mux2_x1
xsubckt_1952_and21nor_x0 53 52 1330 175 73 772 and21nor_x0
xsubckt_1933_nexor2_x0 53 52 1352 1359 1350 nexor2_x0
xsubckt_1497_or21nand_x0 53 52 1786 1793 1789 1787 or21nand_x0
xsubckt_1325_nand2_x0 53 52 1955 1957 798 nand2_x0
xsubckt_524_nand2_x0 53 52 444 29 76 nand2_x0
xsubckt_647_xor2_x0 53 52 37 47 327 xor2_x0
xsubckt_969_nand3_x0 53 52 2302 2303 2304 563 nand3_x0
xsubckt_1116_nand2_x0 53 52 2160 2162 811 nand2_x0
xsubckt_1163_nand2_x0 53 52 2114 67 175 nand2_x0
xsubckt_1189_nand2_x0 53 52 2088 2090 2091 nand2_x0
xsubckt_2288_nand2_x0 53 52 968 969 972 nand2_x0
xsubckt_2209_or2_x1 53 52 1053 1055 64 or2_x1
xsubckt_2205_nand3_x0 53 52 1058 769 949 174 nand3_x0
xsubckt_2154_nand2_x0 53 52 1112 1113 176 nand2_x0
xsubckt_1715_and21nor_x0 53 52 1574 1579 1602 1606 and21nor_x0
xsubckt_1665_or21nand_x0 53 52 1622 2240 1626 1623 or21nand_x0
xsubckt_1525_nexor2_x0 53 52 1765 73 1759 nexor2_x0
xsubckt_258_and2_x1 53 52 690 691 714 and2_x1
xsubckt_1106_nand2_x0 53 52 2170 68 175 nand2_x0
xsubckt_2065_and21nor_x0 53 52 1208 1264 1267 1272 and21nor_x0
xsubckt_2057_and2_x1 53 52 1216 1218 803 and2_x1
xsubckt_467_or21nand_x0 53 52 498 499 562 567 or21nand_x0
xsubckt_374_nexor2_x0 53 52 825 2476 583 nexor2_x0
xsubckt_687_and21nor_x0 53 52 289 290 294 568 and21nor_x0
xsubckt_833_and2_x1 53 52 2431 2432 2434 and2_x1
xsubckt_874_and21nor_x0 53 52 2392 2426 2445 2448 and21nor_x0
xsubckt_958_and2_x1 53 52 2313 12 61 and2_x1
xcmpt_zero_2 53 52 0 zero_x1
xsubckt_1835_and2_x1 53 52 1456 1458 22 and2_x1
xsubckt_1788_or21nand_x0 53 52 1503 44 1239 1249 or21nand_x0
xsubckt_1663_and21nor_x0 53 52 1624 854 2236 1625 and21nor_x0
xsubckt_1454_or21nand_x0 53 52 1828 1895 1904 1905 or21nand_x0
xsubckt_1366_and3_x1 53 52 1915 2013 1239 173 and3_x1
xsubckt_1304_or21nand_x0 53 52 1975 2240 1979 1976 or21nand_x0
xsubckt_519_and2_x1 53 52 449 450 454 and2_x1
xsubckt_472_and2_x1 53 52 494 495 496 and2_x1
xsubckt_98_and2_x1 53 52 843 844 2473 and2_x1
xsubckt_2_inv_x0 53 52 2478 1443 inv_x0
xsubckt_766_nexor2_x0 53 52 216 219 215 nexor2_x0
xsubckt_2429_dff_x1 53 52 106 185 64 dff_x1
xcmpt_zero_1 53 52 1 zero_x1
xsubckt_2038_and3_x1 53 52 1237 1238 1240 814 and3_x1
xsubckt_601_and21nor_x0 53 52 370 371 563 568 and21nor_x0
xsubckt_536_or2_x1 53 52 432 433 439 or2_x1
xsubckt_498_or21nand_x0 53 52 469 491 488 490 or21nand_x0
xsubckt_735_nand2_x0 53 52 245 21 9 nand2_x0
xsubckt_1138_and21nor_x0 53 52 2138 2139 2140 787 and21nor_x0
xsubckt_2336_or21nand_x0 53 52 918 942 944 945 or21nand_x0
xsubckt_2326_nexor2_x0 53 52 930 944 928 nexor2_x0
xsubckt_2185_or21nand_x0 53 52 1079 2240 1740 1080 or21nand_x0
xsubckt_2130_or21nand_x0 53 52 1138 1146 1157 66 or21nand_x0
xsubckt_2090_nexor2_x0 53 52 1189 67 1181 nexor2_x0
xsubckt_1849_and21nor_x0 53 52 1440 2241 2129 1441 and21nor_x0
xsubckt_1768_nor2_x0 53 52 109 1523 1530 nor2_x0
xsubckt_1593_or21nand_x0 53 52 1692 1712 1713 1271 or21nand_x0
xsubckt_1481_nor2_x0 53 52 1802 1808 1810 nor2_x0
xsubckt_543_or21nand_x0 53 52 426 446 445 444 or21nand_x0
xsubckt_80_inv_x0 53 52 3 861 inv_x0
xsubckt_900_nexor2_x0 53 52 2368 2371 2367 nexor2_x0
xsubckt_904_nand3_x0 53 52 2364 2365 687 169 nand3_x0
xsubckt_2213_or2_x1 53 52 1049 1055 866 or2_x1
xsubckt_2107_and4_x1 53 52 1162 59 861 1282 1292 and4_x1
xsubckt_1864_nand2_x0 53 52 1425 2270 45 nand2_x0
xsubckt_1772_mux2_x1 53 52 43 42 175 1519 mux2_x1
xsubckt_1709_and21nor_x0 53 52 1579 1634 1641 1644 and21nor_x0
xsubckt_1389_nand2_x0 53 52 1892 1893 1894 nand2_x0
xsubckt_635_and2_x1 53 52 338 339 563 and2_x1
xsubckt_481_and21nor_x0 53 52 485 558 487 486 and21nor_x0
xsubckt_437_nexor2_x0 53 52 528 531 527 nexor2_x0
xsubckt_1103_nand2_x0 53 52 2173 19 175 nand2_x0
xsubckt_1212_nand3_x0 53 52 2066 2170 174 1249 nand3_x0
xsubckt_2210_and2_x1 53 52 1052 1055 64 and2_x1
xsubckt_2067_nexor2_x0 53 52 1208 1221 1205 nexor2_x0
xsubckt_1807_nand4_x0 53 52 1484 59 16 1282 1292 nand4_x0
xsubckt_1699_nexor2_x0 53 52 1621 11 1589 nexor2_x0
xsubckt_606_nor2_x0 53 52 366 39 72 nor2_x0
xsubckt_574_and21nor_x0 53 52 396 430 449 452 and21nor_x0
xsubckt_227_nexor2_x0 53 52 721 727 720 nexor2_x0
xsubckt_749_nand2_x0 53 52 232 66 67 nand2_x0
xsubckt_909_or21nand_x0 53 52 2359 2378 2376 2377 or21nand_x0
xsubckt_2265_and21nor_x0 53 52 993 1004 1003 994 and21nor_x0
xsubckt_1963_and21nor_x0 53 52 1318 1326 1324 1319 and21nor_x0
xsubckt_1937_and2_x1 53 52 1345 1347 2237 and2_x1
xsubckt_1295_and21nor_x0 53 52 1984 2036 2042 2045 and21nor_x0
xsubckt_487_nand2_x0 53 52 479 73 74 nand2_x0
xsubckt_36_inv_x0 53 52 33 1077 inv_x0
xsubckt_198_nand3_x0 53 52 748 751 812 1249 nand3_x0
xsubckt_679_nand3_x0 53 52 297 299 302 312 nand3_x0
xsubckt_940_xor2_x0 53 52 13 62 2330 xor2_x0
xsubckt_1066_and21nor_x0 53 52 2209 2210 2227 1153 and21nor_x0
xsubckt_2372_dff_x1 53 52 60 185 172 dff_x1
xsubckt_1976_nexor2_x0 53 52 1306 1307 1304 nexor2_x0
xsubckt_1643_and3_x1 53 52 1644 1647 1650 949 and3_x1
xsubckt_175_nand3_x0 53 52 770 175 1239 173 nand3_x0
xsubckt_307_nand2_x0 53 52 644 645 646 nand2_x0
xsubckt_644_or21nand_x0 53 52 330 557 332 331 or21nand_x0
xsubckt_2449_dff_x1 53 52 118 185 34 dff_x1
xsubckt_2295_and2_x1 53 52 961 1626 2236 and2_x1
xsubckt_2240_nand3_x0 53 52 1020 801 949 175 nand3_x0
xsubckt_2149_and2_x1 53 52 1117 1118 1260 and2_x1
xsubckt_2078_mux2_x1 53 52 1195 1197 175 1194 mux2_x1
xsubckt_1658_nexor2_x0 53 52 1631 1635 1629 nexor2_x0
xsubckt_1381_nor2_x0 53 52 1900 1907 76 nor2_x0
xsubckt_329_nand3_x0 53 52 624 626 658 788 nand3_x0
xsubckt_238_mux2_x1 53 52 2474 182 777 709 mux2_x1
xsubckt_733_and21nor_x0 53 52 247 270 269 268 and21nor_x0
xsubckt_839_or2_x1 53 52 2426 62 63 or2_x1
xsubckt_1198_nand2_x0 53 52 2079 2080 2241 nand2_x0
xsubckt_1841_nand2_x0 53 52 1449 1451 1479 nand2_x0
xsubckt_362_nor3_x0 53 52 157 595 596 176 nor3_x0
xsubckt_169_mux2_x1 53 52 2482 184 777 776 mux2_x1
xsubckt_318_and21nor_x0 53 52 634 77 823 635 and21nor_x0
xsubckt_701_xor2_x0 53 52 19 18 277 xor2_x0
xsubckt_859_nand2_x0 53 52 2407 3 66 nand2_x0
xsubckt_897_nor2_x0 53 52 2370 2 62 nor2_x0
xsubckt_1120_or21nand_x0 53 52 2156 2159 2172 2174 or21nand_x0
xsubckt_2302_nand2_x0 53 52 953 954 802 nand2_x0
xsubckt_2225_and21nor_x0 53 52 1036 1039 1046 787 and21nor_x0
xsubckt_1884_nand2_x0 53 52 1403 1410 873 nand2_x0
xsubckt_1691_and3_x1 53 52 1597 1671 884 885 and3_x1
xsubckt_1336_nand2_x0 53 52 1944 1945 803 nand2_x0
xsubckt_466_nexor2_x0 53 52 500 503 499 nexor2_x0
xsubckt_127_and2_x1 53 52 142 816 1271 and2_x1
xsubckt_228_and2_x1 53 52 719 720 803 and2_x1
xsubckt_1192_or21nand_x0 53 52 2085 2142 2153 2154 or21nand_x0
xsubckt_2066_or21nand_x0 53 52 1207 1265 1266 1270 or21nand_x0
xsubckt_2059_mux2_x1 53 52 57 875 850 1214 mux2_x1
xsubckt_1998_and2_x1 53 52 1280 1281 814 and2_x1
xsubckt_1836_nand2_x0 53 52 1455 1458 22 nand2_x0
xsubckt_1827_and21nor_x0 53 52 1464 1471 1469 1466 and21nor_x0
xsubckt_1575_or21nand_x0 53 52 1710 1753 1759 1763 or21nand_x0
xsubckt_1410_mux2_x1 53 52 183 48 1923 1872 mux2_x1
xsubckt_1365_and4_x1 53 52 1916 1917 1918 1919 770 and4_x1
xsubckt_1306_and3_x1 53 52 1973 2074 867 869 and3_x1
xsubckt_1298_and3_x1 53 52 1981 2081 1002 1024 and3_x1
xsubckt_503_and21nor_x0 53 52 464 30 557 563 and21nor_x0
xsubckt_496_nexor2_x0 53 52 72 73 471 nexor2_x0
xsubckt_884_xor2_x0 53 52 23 61 2383 xor2_x0
xsubckt_2401_dff_x1 53 52 155 185 2475 dff_x1
xsubckt_2386_dff_x1 53 52 162 185 2482 dff_x1
xsubckt_1940_and2_x1 53 52 1342 1343 2244 and2_x1
xsubckt_1896_and2_x1 53 52 1390 1391 1393 and2_x1
xsubckt_1882_nand2_x0 53 52 1405 1410 21 nand2_x0
xsubckt_1608_or21nand_x0 53 52 1678 1684 1686 71 or21nand_x0
xsubckt_1529_nand2_x0 53 52 1755 1757 1759 nand2_x0
xsubckt_1330_nand2_x0 53 52 1950 1954 42 nand2_x0
xsubckt_755_or21nand_x0 53 52 226 247 246 245 or21nand_x0
xsubckt_2433_dff_x1 53 52 102 185 23 dff_x1
xsubckt_2290_and2_x1 53 52 966 967 968 and2_x1
xsubckt_1951_or21nand_x0 53 52 1331 1228 1013 773 or21nand_x0
xsubckt_1942_nand4_x0 53 52 1340 59 7 1282 1292 nand4_x0
xsubckt_1920_and21nor_x0 53 52 1364 1367 1375 880 and21nor_x0
xsubckt_1686_nexor2_x0 53 52 1608 69 1602 nexor2_x0
xsubckt_1329_and2_x1 53 52 1951 1954 42 and2_x1
xsubckt_428_nand2_x0 53 52 536 75 76 nand2_x0
xsubckt_731_nexor2_x0 53 52 67 68 249 nexor2_x0
xsubckt_855_nand2_x0 53 52 2410 2411 563 nand2_x0
xsubckt_1031_and2_x1 53 52 2243 59 57 and2_x1
xsubckt_1203_nor4_x0 53 52 2074 8 9 16 17 nor4_x0
xsubckt_1260_and2_x1 53 52 131 2019 2038 and2_x1
xsubckt_568_and21nor_x0 53 52 402 419 417 418 and21nor_x0
xsubckt_551_nor2_x0 53 52 418 28 72 nor2_x0
xsubckt_841_xor2_x0 53 52 62 63 2424 xor2_x0
xsubckt_858_nor2_x0 53 52 2408 3 66 nor2_x0
xsubckt_1919_nand2_x0 53 52 1365 1367 1375 nand2_x0
xsubckt_1876_nand2_x0 53 52 1412 1416 798 nand2_x0
xsubckt_1625_and21nor_x0 53 52 1661 58 1662 2246 and21nor_x0
xsubckt_1571_or21nand_x0 53 52 1714 1758 1760 1761 or21nand_x0
xsubckt_1513_and3_x1 53 52 1771 62 174 1249 and3_x1
xsubckt_1449_nand4_x0 53 52 1833 59 938 1282 1292 nand4_x0
xsubckt_617_or21nand_x0 53 52 355 357 358 563 or21nand_x0
xsubckt_455_or21nand_x0 53 52 510 531 530 529 or21nand_x0
xsubckt_84_inv_x0 53 52 15 857 inv_x0
xsubckt_655_mux2_x1 53 52 47 320 567 121 mux2_x1
xsubckt_921_and3_x1 53 52 2348 687 23 169 and3_x1
xsubckt_1159_mux2_x1 53 52 873 2119 2271 2118 mux2_x1
xsubckt_2241_and3_x1 53 52 1019 769 69 174 and3_x1
xsubckt_2115_and21nor_x0 53 52 1155 970 174 173 and21nor_x0
xsubckt_1580_nexor2_x0 53 52 1748 891 1705 nexor2_x0
xsubckt_629_and21nor_x0 53 52 344 558 346 345 and21nor_x0
xsubckt_424_nexor2_x0 53 52 540 544 539 nexor2_x0
xsubckt_328_and3_x1 53 52 625 626 658 788 and3_x1
xsubckt_1271_nand2_x0 53 52 2008 2009 2010 nand2_x0
xsubckt_2214_and2_x1 53 52 1048 1055 866 and2_x1
xsubckt_1784_and21nor_x0 53 52 1507 1508 1517 815 and21nor_x0
xsubckt_1670_nand4_x0 53 52 1617 59 885 1282 1292 nand4_x0
xsubckt_1462_nand3_x0 53 52 1821 801 868 175 nand3_x0
xsubckt_1394_nexor2_x0 53 52 1940 28 1887 nexor2_x0
xsubckt_1308_and21nor_x0 53 52 1971 2238 1972 1974 and21nor_x0
xsubckt_532_xor2_x0 53 52 29 73 436 xor2_x0
xsubckt_1185_nexor2_x0 53 52 2102 45 2092 nexor2_x0
xsubckt_1217_and4_x1 53 52 2061 2062 2063 2065 770 and4_x1
xsubckt_1241_or21nand_x0 53 52 2037 2085 2098 2099 or21nand_x0
xsubckt_1251_and2_x1 53 52 2027 2028 2031 and2_x1
xsubckt_2308_mux2_x1 53 52 927 908 686 947 mux2_x1
xsubckt_2173_mux2_x1 53 52 72 1096 798 1092 mux2_x1
xsubckt_2052_nand2_x0 53 52 1222 1231 875 nand2_x0
xsubckt_1833_mux2_x1 53 52 1066 1460 798 1458 mux2_x1
xsubckt_1620_and21nor_x0 53 52 1666 855 2236 1667 and21nor_x0
xsubckt_1550_mux2_x1 53 52 181 45 1923 1734 mux2_x1
xsubckt_1534_nand2_x0 53 52 1750 1752 1760 nand2_x0
xsubckt_124_or21nand_x0 53 52 817 1303 822 1292 or21nand_x0
xsubckt_212_nand2_x0 53 52 734 1260 2473 nand2_x0
xsubckt_689_or21nand_x0 53 52 288 293 301 303 or21nand_x0
xsubckt_752_or2_x1 53 52 229 231 233 or2_x1
xsubckt_894_and21nor_x0 53 52 2373 859 557 563 and21nor_x0
xsubckt_1176_mux2_x1 53 52 20 2103 798 2101 mux2_x1
xsubckt_2167_and3_x1 53 52 1098 769 970 174 and3_x1
xsubckt_1954_nand3_x0 53 52 1328 1333 1334 1335 nand3_x0
xsubckt_1899_or2_x1 53 52 1386 1387 1390 or2_x1
xsubckt_1802_nexor2_x0 53 52 1493 1533 1489 nexor2_x0
xsubckt_593_nexor2_x0 53 52 379 382 378 nexor2_x0
xsubckt_583_and21nor_x0 53 52 111 567 399 388 and21nor_x0
xsubckt_526_nexor2_x0 53 52 443 446 442 nexor2_x0
xsubckt_402_nand4_x0 53 52 560 801 44 169 175 nand4_x0
xsubckt_97_or3_x1 53 52 844 2474 2482 2481 or3_x1
xsubckt_229_and2_x1 53 52 718 1260 2472 and2_x1
xsubckt_785_or21nand_x0 53 52 197 68 66 67 or21nand_x0
xsubckt_961_and21nor_x0 53 52 2310 854 557 563 and21nor_x0
xsubckt_975_nexor2_x0 53 52 11 23 2297 nexor2_x0
xsubckt_2434_dff_x1 53 52 125 185 41 dff_x1
xsubckt_2317_or21nand_x0 53 52 937 2240 1588 939 or21nand_x0
xsubckt_2292_or21nand_x0 53 52 964 1006 1008 1009 or21nand_x0
xsubckt_2202_and2_x1 53 52 1061 47 173 and2_x1
xsubckt_1756_and3_x1 53 52 1534 1536 1538 849 and3_x1
xsubckt_451_nexor2_x0 53 52 74 75 514 nexor2_x0
xsubckt_684_nexor2_x0 53 52 293 302 292 nexor2_x0
xsubckt_802_nexor2_x0 53 52 2462 2465 2461 nexor2_x0
xsubckt_1111_nand3_x0 53 52 2165 2271 67 1228 nand3_x0
xsubckt_1118_or21nand_x0 53 52 2158 2169 2164 2161 or21nand_x0
xsubckt_1190_and21nor_x0 53 52 2087 2089 2092 802 and21nor_x0
xsubckt_1262_or21nand_x0 53 52 2017 2040 2042 2046 or21nand_x0
xsubckt_2442_dff_x1 53 52 111 185 27 dff_x1
xsubckt_2034_and2_x1 53 52 1242 1243 772 and2_x1
xsubckt_1834_mux2_x1 53 52 45 1459 798 1457 mux2_x1
xsubckt_1689_and21nor_x0 53 52 1599 1639 1631 1638 and21nor_x0
xsubckt_1383_nexor2_x0 53 52 1907 76 1898 nexor2_x0
xsubckt_1317_nand4_x0 53 52 1963 1964 1965 1966 770 nand4_x0
xsubckt_640_xor2_x0 53 52 37 70 334 xor2_x0
xsubckt_556_or21nand_x0 53 52 413 421 420 414 or21nand_x0
xsubckt_462_and21nor_x0 53 52 503 525 524 523 and21nor_x0
xsubckt_454_nand3_x0 53 52 511 512 513 568 nand3_x0
xsubckt_37_inv_x0 53 52 45 1066 inv_x0
xsubckt_716_nand2_x0 53 52 263 264 266 nand2_x0
xsubckt_923_or21nand_x0 53 52 2346 2362 2359 2361 or21nand_x0
xsubckt_982_or2_x1 53 52 2290 2291 2294 or2_x1
xsubckt_1124_or21nand_x0 53 52 2152 2157 2179 1099 or21nand_x0
xsubckt_2074_nand2_x0 53 52 1198 1199 176 nand2_x0
xsubckt_1736_and21nor_x0 53 52 1553 1554 1566 176 and21nor_x0
xsubckt_762_and21nor_x0 53 52 219 241 240 239 and21nor_x0
xsubckt_810_nand2_x0 53 52 2453 2454 563 nand2_x0
xsubckt_861_or21nand_x0 53 52 2405 2422 2420 2421 or21nand_x0
xsubckt_2318_nand4_x0 53 52 936 59 853 1282 1292 nand4_x0
xsubckt_1947_nand3_x0 53 52 1335 2271 991 1228 nand3_x0
xsubckt_334_and21nor_x0 53 52 619 621 624 628 and21nor_x0
xsubckt_106_or4_x1 53 52 835 2468 2467 2480 2479 or4_x1
xsubckt_22_inv_x0 53 52 175 1228 inv_x0
xsubckt_648_and21nor_x0 53 52 326 343 341 342 and21nor_x0
xsubckt_698_nand3_x0 53 52 279 280 281 563 nand3_x0
xsubckt_1037_nand3_x0 53 52 2237 59 1282 58 nand3_x0
xsubckt_2249_and21nor_x0 53 52 1010 1015 1020 864 and21nor_x0
xsubckt_2148_nand4_x0 53 52 1118 59 859 1282 1292 nand4_x0
xsubckt_1900_and2_x1 53 52 1385 1386 802 and2_x1
xsubckt_1808_nand4_x0 53 52 1483 59 40 1282 58 nand4_x0
xsubckt_1799_nexor2_x0 53 52 1499 24 1492 nexor2_x0
xsubckt_1468_or21nand_x0 53 52 1815 1228 63 815 or21nand_x0
xsubckt_1338_or21nand_x0 53 52 1942 1984 1988 1989 or21nand_x0
xsubckt_621_and3_x1 53 52 352 687 47 169 and3_x1
xsubckt_398_nand3_x0 53 52 564 565 687 169 nand3_x0
xsubckt_372_nand3_x0 53 52 585 587 590 1314 nand3_x0
xsubckt_70_inv_x0 53 52 8 871 inv_x0
xsubckt_1140_nor3_x0 53 52 2136 33 40 41 nor3_x0
xsubckt_128_and2_x1 53 52 815 174 1249 and2_x1
xsubckt_880_and21nor_x0 53 52 2386 2425 2392 2388 and21nor_x0
xsubckt_1080_nand3_x0 53 52 2195 2196 2197 788 nand3_x0
xsubckt_2009_nand2_x0 53 52 1268 1273 18 nand2_x0
xsubckt_1866_and3_x1 53 52 1423 1516 1239 173 and3_x1
xsubckt_1823_nand3_x0 53 52 1469 1547 1239 173 nand3_x0
xsubckt_1628_or21nand_x0 53 52 1658 1664 1661 1659 or21nand_x0
xsubckt_1479_and21nor_x0 53 52 1804 1812 1821 74 and21nor_x0
xsubckt_280_nand3_x0 53 52 669 842 1379 1389 nand3_x0
xsubckt_317_and21nor_x0 53 52 635 1465 186 2468 and21nor_x0
xsubckt_758_nexor2_x0 53 52 8 20 223 nexor2_x0
xsubckt_826_nexor2_x0 53 52 2439 2442 2438 nexor2_x0
xsubckt_999_nand2_x0 53 52 2274 2275 2278 nand2_x0
xsubckt_1146_nor3_x0 53 52 2130 9 16 17 nor3_x0
xsubckt_2448_dff_x1 53 52 119 185 35 dff_x1
xsubckt_2357_or2_x1 53 52 899 901 56 or2_x1
xsubckt_1824_nand3_x0 53 52 1468 752 42 173 nand3_x0
xsubckt_1727_and2_x1 53 52 1562 1563 2237 and2_x1
xsubckt_409_nand3_x0 53 52 553 555 560 41 nand3_x0
xsubckt_95_nor2_x0 53 52 846 2482 2481 nor2_x0
xsubckt_88_inv_x0 53 52 11 853 inv_x0
xsubckt_13_inv_x0 53 52 2473 1325 inv_x0
xsubckt_162_and2_x1 53 52 782 783 789 and2_x1
xsubckt_293_and21nor_x0 53 52 657 658 788 821 and21nor_x0
xsubckt_943_and21nor_x0 53 52 2327 855 557 563 and21nor_x0
xsubckt_2298_nand4_x0 53 52 957 59 885 1282 58 nand4_x0
xsubckt_1601_nand3_x0 53 52 1685 801 62 175 nand3_x0
xsubckt_1547_and21nor_x0 53 52 1737 2238 1740 1738 and21nor_x0
xsubckt_1545_nand4_x0 53 52 1739 59 900 1282 1292 nand4_x0
xsubckt_569_nexor2_x0 53 52 402 403 401 nexor2_x0
xsubckt_522_and21nor_x0 53 52 446 469 468 467 and21nor_x0
xsubckt_710_or2_x1 53 52 269 22 16 or2_x1
xsubckt_962_or21nand_x0 53 52 2309 557 2311 2310 or21nand_x0
xsubckt_1000_mux2_x1 53 52 23 2274 567 86 mux2_x1
xsubckt_2093_nand2_x0 53 52 1178 1180 1182 nand2_x0
xsubckt_1923_nand3_x0 53 52 1361 1367 1375 20 nand3_x0
xsubckt_1800_nexor2_x0 53 52 1493 1532 1491 nexor2_x0
xsubckt_1664_and2_x1 53 52 1623 1624 2237 and2_x1
xsubckt_1645_and21nor_x0 53 52 1642 1647 1650 949 and21nor_x0
xsubckt_1491_and4_x1 53 52 1792 1933 859 861 863 and4_x1
xsubckt_495_xor2_x0 53 52 72 73 472 xor2_x0
xsubckt_392_nand2_x0 53 52 569 570 1271 nand2_x0
xsubckt_115_or2_x1 53 52 826 828 835 or2_x1
xsubckt_692_nexor2_x0 53 52 287 288 285 nexor2_x0
xsubckt_1053_nand3_x0 53 52 2222 2224 2225 2226 nand3_x0
xsubckt_2071_nand3_x0 53 52 1201 1185 1196 170 nand3_x0
xsubckt_2032_mux2_x1 53 52 76 1245 2271 1244 mux2_x1
xsubckt_1541_and21nor_x0 53 52 1743 2242 1744 1745 and21nor_x0
xsubckt_1537_nexor2_x0 53 52 1799 39 1747 nexor2_x0
xsubckt_1509_nor2_x0 53 52 1775 1776 23 nor2_x0
xsubckt_1475_and21nor_x0 53 52 1808 1812 1821 1034 and21nor_x0
xsubckt_1348_nexor2_x0 53 52 1973 865 1932 nexor2_x0
xsubckt_563_and2_x1 53 52 407 408 558 and2_x1
xsubckt_509_nexor2_x0 53 52 459 462 458 nexor2_x0
xsubckt_720_xor2_x0 53 52 16 19 259 xor2_x0
xsubckt_945_and2_x1 53 52 2325 13 23 and2_x1
xsubckt_1022_or21nand_x0 53 52 2252 2264 2259 2255 or21nand_x0
xsubckt_2325_and21nor_x0 53 52 929 971 976 979 and21nor_x0
xsubckt_1975_or21nand_x0 53 52 1305 1358 1359 1363 or21nand_x0
xsubckt_1812_and21nor_x0 53 52 108 1480 1490 176 and21nor_x0
xsubckt_1791_or21nand_x0 53 52 1500 1228 1503 1504 or21nand_x0
xsubckt_1770_nand3_x0 53 52 1521 801 1099 175 nand3_x0
xsubckt_1441_and21nor_x0 53 52 1841 57 59 75 and21nor_x0
xsubckt_1386_or21nand_x0 53 52 1895 1947 1949 1950 or21nand_x0
xsubckt_1377_nor2_x0 53 52 1904 1907 1088 nor2_x0
xsubckt_1311_and21nor_x0 53 52 1968 788 1982 1969 and21nor_x0
xsubckt_539_or2_x1 53 52 430 70 71 or2_x1
xsubckt_737_nexor2_x0 53 52 244 247 243 nexor2_x0
xsubckt_750_xor2_x0 53 52 66 67 231 xor2_x0
xsubckt_1100_and21nor_x0 53 52 2176 175 174 173 and21nor_x0
xsubckt_1231_and2_x1 53 52 2047 2049 44 and2_x1
xsubckt_1244_and2_x1 53 52 2034 2081 1024 and2_x1
xsubckt_2441_dff_x1 53 52 112 185 28 dff_x1
xsubckt_1904_nexor2_x0 53 52 1383 1398 1381 nexor2_x0
xsubckt_1602_nor4_x0 53 52 1684 1687 1688 1689 799 nor4_x0
xsubckt_1587_and21nor_x0 53 52 1698 58 1699 2246 and21nor_x0
xsubckt_1281_nand3_x0 53 52 1998 801 879 175 nand3_x0
xsubckt_333_nand2_x0 53 52 620 622 820 nand2_x0
xsubckt_287_nand2_x0 53 52 150 663 665 nand2_x0
xsubckt_302_and3_x1 53 52 649 658 788 2469 and3_x1
xsubckt_700_mux2_x1 53 52 47 278 567 118 mux2_x1
xsubckt_889_or21nand_x0 53 52 2378 2408 2405 2407 or21nand_x0
xsubckt_917_or21nand_x0 53 52 2351 2353 2354 563 or21nand_x0
xsubckt_1125_and21nor_x0 53 52 2151 2156 2178 1099 and21nor_x0
xsubckt_1984_nand2_x0 53 52 1295 1296 1298 nand2_x0
xsubckt_1676_mux2_x1 53 52 1612 1613 1271 136 mux2_x1
xsubckt_1612_and21nor_x0 53 52 1674 1719 1711 1718 and21nor_x0
xsubckt_537_and2_x1 53 52 113 432 447 and2_x1
xsubckt_990_xor2_x0 53 52 10 23 2283 xor2_x0
xsubckt_2341_nexor2_x0 53 52 913 1575 912 nexor2_x0
xsubckt_2194_nexor2_x0 53 52 1071 1086 1069 nexor2_x0
xsubckt_2096_or21nand_x0 53 52 1175 1208 1223 1224 or21nand_x0
xsubckt_1480_nand2_x0 53 52 1803 1811 1034 nand2_x0
xsubckt_1432_nexor2_x0 53 52 1855 75 1850 nexor2_x0
xsubckt_149_and2_x1 53 52 795 797 2481 and2_x1
xsubckt_76_inv_x0 53 52 5 865 inv_x0
xsubckt_866_and2_x1 53 52 2400 3 63 and2_x1
xsubckt_1082_xor2_x0 53 52 40 41 2193 xor2_x0
xsubckt_1242_and21nor_x0 53 52 2036 2086 2097 2100 and21nor_x0
xsubckt_2026_and21nor_x0 53 52 1250 1305 1308 1312 and21nor_x0
xsubckt_625_and2_x1 53 52 348 38 71 and2_x1
xsubckt_351_nand3_x0 53 52 604 607 608 820 nand3_x0
xsubckt_196_nand2_x0 53 52 750 752 173 nand2_x0
xsubckt_650_and2_x1 53 52 324 326 327 and2_x1
xsubckt_1005_and3_x1 53 52 2269 175 174 173 and3_x1
xsubckt_1213_nand3_x0 53 52 2065 2271 65 1228 nand3_x0
xsubckt_1221_or21nand_x0 53 52 2057 2061 2060 2058 or21nand_x0
xsubckt_2300_and3_x1 53 52 955 956 957 1260 and3_x1
xsubckt_1464_or21nand_x0 53 52 1819 813 870 1249 or21nand_x0
xsubckt_1334_or21nand_x0 53 52 1946 2018 1987 1991 or21nand_x0
xsubckt_588_and3_x1 53 52 383 384 385 568 and3_x1
xsubckt_56_inv_x0 53 52 36 885 inv_x0
xsubckt_805_and21nor_x0 53 52 2458 211 212 213 and21nor_x0
xsubckt_837_and2_x1 53 52 81 2428 2443 and2_x1
xsubckt_1795_nand2_x0 53 52 1496 1499 24 nand2_x0
xsubckt_1564_or21nand_x0 53 52 1721 1726 1728 72 or21nand_x0
xsubckt_1321_and2_x1 53 52 1959 1960 811 and2_x1
xsubckt_1319_nand2_x0 53 52 1961 1962 1963 nand2_x0
xsubckt_620_nor2_x0 53 52 123 353 367 nor2_x0
xsubckt_370_nand2_x0 53 52 587 589 803 nand2_x0
xsubckt_251_or21nand_x0 53 52 697 725 727 728 or21nand_x0
xsubckt_288_mux2_x1 53 52 2471 179 777 662 mux2_x1
xsubckt_822_and21nor_x0 53 52 2442 2465 2464 2463 and21nor_x0
xsubckt_846_xor2_x0 53 52 4 67 2419 xor2_x0
xsubckt_938_nor2_x0 53 52 2332 13 62 nor2_x0
xsubckt_1039_and2_x1 53 52 2235 59 58 and2_x1
xsubckt_1087_nand4_x0 53 52 2188 59 1110 1282 1292 nand4_x0
xsubckt_1137_or21nand_x0 53 52 2139 2151 2149 2141 or21nand_x0
xsubckt_1167_and2_x1 53 52 2110 2111 811 and2_x1
xsubckt_1276_nand2_x0 53 52 2003 2006 2008 nand2_x0
xsubckt_2243_and21nor_x0 53 52 1017 908 800 769 and21nor_x0
xsubckt_2188_and3_x1 53 52 1075 1076 1078 787 and3_x1
xsubckt_1874_nand3_x0 53 52 1414 801 1142 175 nand3_x0
xsubckt_1652_nexor2_x0 53 52 1645 949 1635 nexor2_x0
xsubckt_335_or21nand_x0 53 52 618 620 625 627 or21nand_x0
xsubckt_87_inv_x0 53 52 12 854 inv_x0
xsubckt_831_and2_x1 53 52 2433 5 65 and2_x1
xsubckt_876_nand2_x0 53 52 2390 61 62 nand2_x0
xsubckt_898_nand2_x0 53 52 2369 2 62 nand2_x0
xsubckt_2369_and3_x1 53 52 888 889 892 893 and3_x1
xsubckt_1977_nand2_x0 53 52 1302 1304 803 nand2_x0
xsubckt_1855_and2_x1 53 52 1434 1435 787 and2_x1
xsubckt_1356_and2_x1 53 52 129 1925 1944 and2_x1
xsubckt_385_or21nand_x0 53 52 574 186 169 175 or21nand_x0
xsubckt_376_nand2_x0 53 52 581 582 714 nand2_x0
xsubckt_294_and2_x1 53 52 656 657 660 and2_x1
xsubckt_697_or21nand_x0 53 52 280 304 298 287 or21nand_x0
xsubckt_1007_nand2_x0 53 52 2267 2269 875 nand2_x0
xsubckt_1150_and2_x1 53 52 2126 2127 2131 and2_x1
xsubckt_2340_and21nor_x0 53 52 913 929 944 946 and21nor_x0
xsubckt_2195_and21nor_x0 53 52 1068 1069 803 176 and21nor_x0
xsubckt_1828_or21nand_x0 53 52 1463 1472 1470 1467 or21nand_x0
xsubckt_1544_nexor2_x0 53 52 1792 857 1740 nexor2_x0
xsubckt_1477_and3_x1 53 52 1806 1812 1821 74 and3_x1
xsubckt_1414_nand3_x0 53 52 1868 862 1239 173 nand3_x0
xsubckt_613_and2_x1 53 52 359 39 69 and2_x1
xsubckt_465_xor2_x0 53 52 32 76 500 xor2_x0
xsubckt_261_or21nand_x0 53 52 151 693 690 688 or21nand_x0
xsubckt_282_nand3_x0 53 52 667 823 839 77 nand3_x0
xsubckt_830_or21nand_x0 53 52 2434 2458 2457 2456 or21nand_x0
xsubckt_1161_and3_x1 53 52 2116 2117 2118 770 and3_x1
xsubckt_1805_mux2_x1 53 52 24 57 59 1486 mux2_x1
xsubckt_1637_nand3_x0 53 52 1650 801 860 175 nand3_x0
xsubckt_163_or21nand_x0 53 52 781 1303 822 782 or21nand_x0
xsubckt_2328_or21nand_x0 53 52 103 926 931 950 or21nand_x0
xsubckt_2011_nexor2_x0 53 52 1273 879 1266 nexor2_x0
xsubckt_1626_nand4_x0 53 52 1660 59 886 1282 1292 nand4_x0
xsubckt_862_nexor2_x0 53 52 2405 2406 2404 nexor2_x0
xsubckt_1227_and2_x1 53 52 2051 2054 798 and2_x1
xsubckt_2285_nexor2_x0 53 52 982 62 972 nexor2_x0
xsubckt_1988_or21nand_x0 53 52 1290 2247 1295 1291 or21nand_x0
xsubckt_1972_nexor2_x0 53 52 1313 19 1308 nexor2_x0
xsubckt_1771_nand2_x0 53 52 1520 42 175 nand2_x0
xsubckt_1685_nand2_x0 53 52 1603 1608 69 nand2_x0
xsubckt_1647_and3_x1 53 52 1640 1647 1650 70 and3_x1
xsubckt_1352_and2_x1 53 52 1928 1929 1260 and2_x1
xsubckt_566_and2_x1 53 52 404 27 71 and2_x1
xsubckt_529_nor2_x0 53 52 439 440 441 nor2_x0
xsubckt_192_mux2_x1 53 52 754 776 176 154 mux2_x1
xsubckt_306_nand3_x0 53 52 645 823 838 77 nand3_x0
xsubckt_658_and2_x1 53 52 317 36 69 and2_x1
xsubckt_787_nand2_x0 53 52 195 65 66 nand2_x0
xsubckt_908_nexor2_x0 53 52 15 64 2360 nexor2_x0
xsubckt_935_and2_x1 53 52 2334 2335 563 and2_x1
xsubckt_1229_or21nand_x0 53 52 2049 2056 2050 2052 or21nand_x0
xsubckt_2331_or21nand_x0 53 52 923 2240 1560 924 or21nand_x0
xsubckt_2098_nand2_x0 53 52 1172 1175 1182 nand2_x0
xsubckt_1877_or21nand_x0 53 52 1410 1418 1412 1414 or21nand_x0
xsubckt_1865_and4_x1 53 52 1424 1425 1426 1427 770 and4_x1
xsubckt_1819_nand2_x0 53 52 1473 2270 46 nand2_x0
xsubckt_1594_or21nand_x0 53 52 138 1692 1693 1732 or21nand_x0
xsubckt_1370_or21nand_x0 53 52 1911 1912 1914 1920 or21nand_x0
xsubckt_1358_nand4_x0 53 52 1923 1185 171 1206 50 nand4_x0
xsubckt_580_and21nor_x0 53 52 390 429 396 392 and21nor_x0
xsubckt_27_inv_x0 53 52 169 1174 inv_x0
xsubckt_2455_dff_x1 53 52 82 185 6 dff_x1
xsubckt_2215_nand2_x0 53 52 1047 1055 866 nand2_x0
xsubckt_1578_nand3_x0 53 52 1707 1799 891 900 nand3_x0
xsubckt_616_and2_x1 53 52 356 357 358 and2_x1
xsubckt_133_nexor2_x0 53 52 813 173 810 nexor2_x0
xsubckt_109_or21nand_x0 53 52 832 1400 839 837 or21nand_x0
xsubckt_869_nexor2_x0 53 52 2398 2399 2397 nexor2_x0
xsubckt_995_or2_x1 53 52 2278 2279 2280 or2_x1
xsubckt_2320_and3_x1 53 52 934 935 936 1260 and3_x1
xsubckt_1393_and2_x1 53 52 1888 1940 959 and2_x1
xsubckt_623_or21nand_x0 53 52 350 366 363 365 or21nand_x0
xsubckt_160_nor2_x0 53 52 784 186 2481 nor2_x0
xsubckt_656_or21nand_x0 53 52 319 336 333 335 or21nand_x0
xsubckt_964_nand2_x0 53 52 2307 12 23 nand2_x0
xsubckt_2168_nand3_x0 53 52 1097 769 970 174 nand3_x0
xsubckt_579_nand3_x0 53 52 391 392 396 429 nand3_x0
xsubckt_572_and3_x1 53 52 398 430 450 454 and3_x1
xsubckt_405_nand3_x0 53 52 557 769 169 174 nand3_x0
xsubckt_180_nand3_x0 53 52 765 768 770 2474 nand3_x0
xsubckt_718_nand2_x0 53 52 261 20 17 nand2_x0
xsubckt_1043_nand2_x0 53 52 2231 2232 2244 nand2_x0
xsubckt_1045_and21nor_x0 53 52 2229 2230 1260 176 and21nor_x0
xsubckt_1046_and2_x1 53 52 141 2229 2248 and2_x1
xsubckt_1222_and2_x1 53 52 2056 2057 2066 and2_x1
xsubckt_2405_dff_x1 53 52 132 185 45 dff_x1
xsubckt_2382_dff_x1 53 52 145 185 174 dff_x1
xsubckt_2199_nand2_x0 53 52 1064 1065 176 nand2_x0
xsubckt_2033_nand3_x0 53 52 1243 2271 949 1228 nand3_x0
xsubckt_1662_and21nor_x0 53 52 1625 57 59 70 and21nor_x0
xsubckt_1657_or21nand_x0 53 52 1630 1675 1677 1678 or21nand_x0
xsubckt_1345_and3_x1 53 52 1935 1936 1937 2237 and3_x1
xsubckt_1342_nexor2_x0 53 52 1981 981 1938 nexor2_x0
xsubckt_741_and2_x1 53 52 239 9 18 and2_x1
xsubckt_818_xor2_x0 53 52 63 64 2446 xor2_x0
xsubckt_1148_nexor2_x0 53 52 2187 874 2128 nexor2_x0
xsubckt_2140_and2_x1 53 52 1127 1128 788 and2_x1
xsubckt_2079_nand2_x0 53 52 1193 1194 173 nand2_x0
xsubckt_1832_or21nand_x0 53 52 1459 1477 1464 1461 or21nand_x0
xsubckt_1683_nand2_x0 53 52 1605 1607 69 nand2_x0
xsubckt_1291_nexor2_x0 53 52 1993 1120 1988 nexor2_x0
xsubckt_591_and2_x1 53 52 380 26 73 and2_x1
xsubckt_581_or21nand_x0 53 52 389 398 397 393 or21nand_x0
xsubckt_239_nand2_x0 53 52 708 709 176 nand2_x0
xsubckt_2004_nand3_x0 53 52 1274 801 76 175 nand3_x0
xsubckt_1825_and2_x1 53 52 1467 1468 811 and2_x1
xsubckt_1646_or21nand_x0 53 52 1641 1646 1651 70 or21nand_x0
xsubckt_578_nexor2_x0 53 52 69 70 392 nexor2_x0
xsubckt_416_xor2_x0 53 52 46 40 547 xor2_x0
xsubckt_332_and2_x1 53 52 621 622 820 and2_x1
xsubckt_181_nexor2_x0 53 52 767 2474 764 nexor2_x0
xsubckt_642_nexor2_x0 53 52 333 334 332 nexor2_x0
xsubckt_722_nand2_x0 53 52 257 258 261 nand2_x0
xsubckt_850_and21nor_x0 53 52 2415 2434 2432 2433 and21nor_x0
xsubckt_2440_dff_x1 53 52 113 185 29 dff_x1
xsubckt_2299_nand4_x0 53 52 956 59 854 1282 1292 nand4_x0
xsubckt_2145_nand4_x0 53 52 1122 59 26 1282 58 nand4_x0
xsubckt_2099_nand2_x0 53 52 1171 1173 1181 nand2_x0
xsubckt_2097_and21nor_x0 53 52 1173 1207 1222 1225 and21nor_x0
xsubckt_1806_nand3_x0 53 52 1485 1486 1487 1488 nand3_x0
xsubckt_1797_nand2_x0 53 52 1494 1498 24 nand2_x0
xsubckt_1380_nand2_x0 53 52 1901 1907 76 nand2_x0
xsubckt_1323_nand3_x0 53 52 1957 769 67 174 nand3_x0
xsubckt_368_nand3_x0 53 52 589 648 674 827 nand3_x0
xsubckt_363_and3_x1 53 52 594 186 2478 2477 and3_x1
xsubckt_316_and3_x1 53 52 636 648 674 1411 and3_x1
xsubckt_993_and2_x1 53 52 2280 2281 558 and2_x1
xsubckt_1165_nand3_x0 53 52 2112 2114 1239 173 nand3_x0
xsubckt_1269_nand4_x0 53 52 2010 2011 2012 2014 770 nand4_x0
xsubckt_1274_nand2_x0 53 52 2005 2007 811 nand2_x0
xsubckt_1936_nand2_x0 53 52 1347 2242 20 nand2_x0
xsubckt_1357_and4_x1 53 52 1924 1185 171 1206 50 and4_x1
xsubckt_232_and21nor_x0 53 52 715 77 823 176 and21nor_x0
xsubckt_320_nand2_x0 53 52 632 633 637 nand2_x0
xsubckt_661_and21nor_x0 53 52 314 885 557 563 and21nor_x0
xsubckt_683_or21nand_x0 53 52 293 319 317 318 or21nand_x0
xsubckt_879_nand3_x0 53 52 2387 2388 2392 2425 nand3_x0
xsubckt_2464_dff_x1 53 52 87 185 11 dff_x1
xsubckt_2411_dff_x1 53 52 126 185 74 dff_x1
xsubckt_2363_or21nand_x0 53 52 894 1303 822 895 or21nand_x0
xsubckt_2361_nand2_x0 53 52 167 896 897 nand2_x0
xsubckt_2161_and3_x1 53 52 1105 752 927 173 and3_x1
xsubckt_2100_nand3_x0 53 52 1170 1171 1172 788 nand3_x0
xsubckt_1906_and21nor_x0 53 52 100 1380 1384 176 and21nor_x0
xsubckt_1416_nand2_x0 53 52 1866 2270 67 nand2_x0
xsubckt_525_xor2_x0 53 52 29 76 443 xor2_x0
xsubckt_507_nand2_x0 53 52 460 30 74 nand2_x0
xsubckt_443_nexor2_x0 53 52 522 525 521 nexor2_x0
xsubckt_1009_mux2_x1 53 52 25 174 173 2265 mux2_x1
xsubckt_1076_and21nor_x0 53 52 2199 2204 2202 2200 and21nor_x0
xsubckt_2280_nor3_x0 53 52 977 983 984 862 nor3_x0
xsubckt_2117_or21nand_x0 53 52 1152 1154 1155 175 or21nand_x0
xsubckt_2113_and3_x1 53 52 1157 801 1013 175 and3_x1
xsubckt_1857_or21nand_x0 53 52 1431 787 1444 1433 or21nand_x0
xsubckt_1765_nand2_x0 53 52 1525 1526 1529 nand2_x0
xsubckt_1369_nand2_x0 53 52 1912 1913 811 nand2_x0
xsubckt_330_and4_x1 53 52 623 648 674 803 837 and4_x1
xsubckt_659_nexor2_x0 53 52 36 69 316 nexor2_x0
xsubckt_769_and2_x1 53 52 213 7 67 and2_x1
xsubckt_886_nand3_x0 53 52 2381 2383 2385 2390 nand3_x0
xsubckt_934_nexor2_x0 53 52 2336 2339 2335 nexor2_x0
xsubckt_1156_and3_x1 53 52 2121 2122 174 1249 and3_x1
xsubckt_2408_dff_x1 53 52 129 185 42 dff_x1
xsubckt_2278_and2_x1 53 52 979 980 862 and2_x1
xsubckt_2050_or2_x1 53 52 1224 1231 875 or2_x1
xsubckt_1944_and21nor_x0 53 52 1338 1339 1341 803 and21nor_x0
xsubckt_1915_mux2_x1 53 52 75 73 174 1370 mux2_x1
xsubckt_1892_and21nor_x0 53 52 1394 2241 2073 1395 and21nor_x0
xsubckt_1773_and3_x1 53 52 1518 1519 1239 173 and3_x1
xsubckt_1711_or21nand_x0 53 52 1577 1578 802 1271 or21nand_x0
xsubckt_194_nor2_x0 53 52 752 175 174 nor2_x0
xsubckt_210_or2_x1 53 52 736 738 743 or2_x1
xsubckt_225_nand3_x0 53 52 722 723 724 788 nand3_x0
xsubckt_286_nand2_x0 53 52 663 664 176 nand2_x0
xsubckt_745_or21nand_x0 53 52 235 563 242 236 or21nand_x0
xsubckt_827_and2_x1 53 52 2437 557 865 and2_x1
xsubckt_2220_and2_x1 53 52 1041 1042 1044 and2_x1
xsubckt_2086_nand3_x0 53 52 1186 1190 1193 67 nand3_x0
xsubckt_1697_nand2_x0 53 52 1591 1592 1593 nand2_x0
xsubckt_1623_and4_x1 53 52 1663 1792 855 856 857 and4_x1
xsubckt_600_nexor2_x0 53 52 372 375 371 nexor2_x0
xsubckt_440_or2_x1 53 52 524 33 42 or2_x1
xsubckt_2424_dff_x1 53 52 97 185 18 dff_x1
xsubckt_2104_and2_x1 53 52 1166 1167 1169 and2_x1
xsubckt_2017_nand2_x0 53 52 1259 1261 2237 nand2_x0
xsubckt_1748_and21nor_x0 53 52 1542 1550 1545 1543 and21nor_x0
xsubckt_1710_nexor2_x0 53 52 1580 1602 1578 nexor2_x0
xsubckt_352_mux2_x1 53 52 830 606 820 603 mux2_x1
xsubckt_233_or21nand_x0 53 52 714 1303 822 1271 or21nand_x0
xsubckt_257_nand2_x0 53 52 691 692 1271 nand2_x0
xsubckt_1230_and21nor_x0 53 52 2048 2055 2051 2053 and21nor_x0
xsubckt_2232_or21nand_x0 53 52 1028 1035 1032 1029 or21nand_x0
xsubckt_1826_nand2_x0 53 52 1466 1468 811 nand2_x0
xsubckt_1754_or21nand_x0 53 52 1536 1542 1540 1537 or21nand_x0
xsubckt_1570_and21nor_x0 53 52 1715 1757 1759 1762 and21nor_x0
xsubckt_178_and2_x1 53 52 767 768 770 and2_x1
xsubckt_1392_nexor2_x0 53 52 1891 1897 1889 nexor2_x0
xsubckt_1337_and21nor_x0 53 52 1943 1983 1987 1990 and21nor_x0
xsubckt_62_inv_x0 53 52 18 879 inv_x0
xsubckt_672_and2_x1 53 52 304 35 47 and2_x1
xsubckt_2391_dff_x1 53 52 151 185 2471 dff_x1
xsubckt_2333_nand4_x0 53 52 921 59 883 1282 58 nand4_x0
xsubckt_2137_and21nor_x0 53 52 1130 1175 1182 1187 and21nor_x0
xsubckt_2120_or21nand_x0 53 52 1149 1150 1151 1228 or21nand_x0
xsubckt_2029_nand2_x0 53 52 1246 1247 803 nand2_x0
xsubckt_1860_or21nand_x0 53 52 1429 1446 1450 1455 or21nand_x0
xsubckt_1789_and21nor_x0 53 52 1502 1142 174 173 and21nor_x0
xsubckt_1455_and21nor_x0 53 52 1827 1896 1903 1906 and21nor_x0
xsubckt_1429_nand3_x0 53 52 1853 1856 1870 75 nand3_x0
xsubckt_419_and2_x1 53 52 544 44 41 and2_x1
xsubckt_340_nand4_x0 53 52 614 626 658 788 2480 nand4_x0
xsubckt_337_nand2_x0 53 52 616 618 1432 nand2_x0
xsubckt_104_nor2_x0 53 52 837 2468 2467 nor2_x0
xsubckt_269_nand2_x0 53 52 680 681 683 nand2_x0
xsubckt_823_nor2_x0 53 52 2441 5 68 nor2_x0
xsubckt_953_nand2_x0 53 52 2317 2318 2321 nand2_x0
xsubckt_1061_nand3_x0 53 52 2214 2215 175 1249 nand3_x0
xsubckt_2419_dff_x1 53 52 108 185 24 dff_x1
xsubckt_2374_dff_x1 53 52 0 185 170 dff_x1
xsubckt_2197_or2_x1 53 52 107 1067 1109 or2_x1
xsubckt_2024_and21nor_x0 53 52 1252 1253 1254 803 and21nor_x0
xsubckt_1360_nand2_x0 53 52 1921 1922 176 nand2_x0
xsubckt_542_nexor2_x0 53 52 428 431 427 nexor2_x0
xsubckt_401_and4_x1 53 52 561 801 44 169 175 and4_x1
xsubckt_967_or21nand_x0 53 52 2304 2325 2320 2306 or21nand_x0
xsubckt_1214_nand2_x0 53 52 2064 64 175 nand2_x0
xsubckt_1273_and2_x1 53 52 2006 2007 811 and2_x1
xsubckt_2393_dff_x1 53 52 149 185 2469 dff_x1
xsubckt_2347_and4_x1 53 52 164 769 56 169 174 and4_x1
xsubckt_1883_and2_x1 53 52 1404 1410 873 and2_x1
xsubckt_1745_nand4_x0 53 52 1545 1546 1548 1549 770 nand4_x0
xsubckt_1562_nand3_x0 53 52 1723 1725 1727 991 nand3_x0
xsubckt_1328_or2_x1 53 52 1952 1954 1131 or2_x1
xsubckt_783_nor3_x0 53 52 199 230 249 252 nor3_x0
xsubckt_1112_and3_x1 53 52 2164 2165 2166 770 and3_x1
xsubckt_2444_dff_x1 53 52 123 185 39 dff_x1
xsubckt_1363_nand3_x0 53 52 1918 2271 62 1228 nand3_x0
xsubckt_631_nor2_x0 53 52 342 38 47 nor2_x0
xsubckt_446_or21nand_x0 53 52 518 563 526 519 or21nand_x0
xsubckt_277_nand2_x0 53 52 672 1260 2470 nand2_x0
xsubckt_299_nand2_x0 53 52 149 652 661 nand2_x0
xsubckt_651_nand2_x0 53 52 323 326 327 nand2_x0
xsubckt_840_nand2_x0 53 52 2425 62 63 nand2_x0
xsubckt_864_or21nand_x0 53 52 2402 861 558 562 or21nand_x0
xsubckt_868_and21nor_x0 53 52 2398 2415 2413 2414 and21nor_x0
xsubckt_882_and21nor_x0 53 52 2384 2385 2387 567 and21nor_x0
xsubckt_885_nexor2_x0 53 52 23 61 2382 nexor2_x0
xsubckt_1131_or21nand_x0 53 52 2145 2151 2149 2147 or21nand_x0
xsubckt_2273_or4_x1 53 52 985 70 175 174 173 or4_x1
xsubckt_2132_nand3_x0 53 52 1136 1145 1156 870 nand3_x0
xsubckt_1872_nand3_x0 53 52 1416 769 43 174 nand3_x0
xsubckt_1406_or21nand_x0 53 52 1875 1876 1878 802 or21nand_x0
xsubckt_1401_nexor2_x0 53 52 1933 863 1880 nexor2_x0
xsubckt_418_mux2_x1 53 52 1110 546 558 545 mux2_x1
xsubckt_347_nand3_x0 53 52 608 609 658 788 nand3_x0
xsubckt_838_and21nor_x0 53 52 2427 2450 2449 2448 and21nor_x0
xsubckt_891_and2_x1 53 52 2376 2 65 and2_x1
xsubckt_944_or21nand_x0 53 52 2326 557 2328 2327 or21nand_x0
xsubckt_1018_nand3_x0 53 52 2256 2257 175 1249 nand3_x0
xsubckt_1215_nand4_x0 53 52 2063 64 175 174 173 nand4_x0
xsubckt_60_inv_x0 53 52 24 881 inv_x0
xsubckt_1025_or21nand_x0 53 52 2249 2253 2273 49 or21nand_x0
xsubckt_2465_dff_x1 53 52 86 185 10 dff_x1
xsubckt_2410_dff_x1 53 52 127 185 75 dff_x1
xsubckt_1867_nand3_x0 53 52 1421 752 76 173 nand3_x0
xsubckt_1850_and2_x1 53 52 1439 1442 2237 and2_x1
xsubckt_1831_and21nor_x0 53 52 1460 1476 1463 1462 and21nor_x0
xsubckt_1527_and21nor_x0 53 52 1757 1823 1807 1810 and21nor_x0
xsubckt_1403_and2_x1 53 52 1878 1879 1883 and2_x1
xsubckt_582_and21nor_x0 53 52 388 389 391 567 and21nor_x0
xsubckt_417_nexor2_x0 53 52 547 550 546 nexor2_x0
xsubckt_378_nand3_x0 53 52 580 593 658 2476 nand3_x0
xsubckt_137_or21nand_x0 53 52 806 1303 822 808 or21nand_x0
xsubckt_291_and2_x1 53 52 659 679 684 and2_x1
xsubckt_657_or2_x1 53 52 318 36 69 or2_x1
xsubckt_848_and2_x1 53 52 2417 2418 558 and2_x1
xsubckt_887_or21nand_x0 53 52 2380 2391 2386 2382 or21nand_x0
xsubckt_2404_dff_x1 53 52 133 185 46 dff_x1
xsubckt_2383_dff_x1 53 52 144 185 173 dff_x1
xsubckt_2261_and4_x1 53 52 997 59 855 1282 1292 and4_x1
xsubckt_2080_and3_x1 53 52 1192 801 74 175 and3_x1
xsubckt_2047_and2_x1 53 52 1227 1231 68 and2_x1
xsubckt_2036_nand3_x0 53 52 1240 752 72 173 nand3_x0
xsubckt_1777_nand4_x0 53 52 1514 75 175 174 173 nand4_x0
xsubckt_1728_or21nand_x0 53 52 1561 2240 1565 1562 or21nand_x0
xsubckt_1551_mux2_x1 53 52 1734 1735 1271 139 mux2_x1
xsubckt_1470_and21nor_x0 53 52 1813 1816 1815 1814 and21nor_x0
xsubckt_594_and21nor_x0 53 52 377 917 557 563 and21nor_x0
xsubckt_276_nand3_x0 53 52 673 674 675 803 nand3_x0
xsubckt_298_nand3_x0 53 52 652 653 654 1271 nand3_x0
xsubckt_2427_dff_x1 53 52 94 185 66 dff_x1
xsubckt_1897_nand4_x0 53 52 1388 59 8 1282 1292 nand4_x0
xsubckt_1688_or21nand_x0 53 52 1600 1640 1630 1637 or21nand_x0
xsubckt_1661_nexor2_x0 53 52 1671 36 1626 nexor2_x0
xsubckt_343_or2_x1 53 52 611 613 2479 or2_x1
xsubckt_654_nand2_x0 53 52 320 321 330 nand2_x0
xsubckt_939_nand2_x0 53 52 2331 13 62 nand2_x0
xsubckt_1158_nand2_x0 53 52 2119 65 175 nand2_x0
xsubckt_2158_and3_x1 53 52 1108 801 991 175 and3_x1
xsubckt_2061_and4_x1 53 52 1212 59 959 1282 58 and4_x1
xsubckt_1875_and2_x1 53 52 1413 1416 798 and2_x1
xsubckt_1764_nand2_x0 53 52 1526 1527 2244 nand2_x0
xsubckt_1655_nexor2_x0 53 52 1634 1636 1632 nexor2_x0
xsubckt_518_xor2_x0 53 52 71 72 450 xor2_x0
xsubckt_42_inv_x0 53 52 73 1013 inv_x0
xsubckt_164_nexor2_x0 53 52 2482 2481 780 nexor2_x0
xsubckt_965_xor2_x0 53 52 12 23 2306 xor2_x0
xsubckt_1205_and21nor_x0 53 52 2072 58 2073 2246 and21nor_x0
xsubckt_2293_nexor2_x0 53 52 965 972 963 nexor2_x0
xsubckt_2262_nor3_x0 53 52 996 997 998 186 nor3_x0
xsubckt_2247_and3_x1 53 52 1012 1015 1020 63 and3_x1
xsubckt_2143_and2_x1 53 52 1124 1125 2237 and2_x1
xsubckt_1989_nand2_x0 53 52 1289 1290 1271 nand2_x0
xsubckt_1945_or21nand_x0 53 52 1337 1260 1350 1338 or21nand_x0
xsubckt_527_and2_x1 53 52 441 557 981 and2_x1
xsubckt_383_and2_x1 53 52 155 576 579 and2_x1
xsubckt_1115_and2_x1 53 52 2161 2162 811 and2_x1
xsubckt_1186_nexor2_x0 53 52 2102 1066 2091 nexor2_x0
xsubckt_1228_nand2_x0 53 52 2050 2054 798 nand2_x0
xsubckt_1259_and21nor_x0 53 52 2019 788 2035 2020 and21nor_x0
xsubckt_2015_nand2_x0 53 52 1262 1938 2236 nand2_x0
xsubckt_1347_and4_x1 53 52 1933 2074 865 867 869 and4_x1
xsubckt_1333_and21nor_x0 53 52 1947 2017 1988 1992 and21nor_x0
xsubckt_444_nand2_x0 53 52 520 532 568 nand2_x0
xsubckt_4_inv_x0 53 52 2467 1422 inv_x0
xsubckt_763_nor2_x0 53 52 218 8 68 nor2_x0
xsubckt_2270_or21nand_x0 53 52 105 988 993 1022 or21nand_x0
xsubckt_2268_nexor2_x0 53 52 992 1008 989 nexor2_x0
xsubckt_1705_or21nand_x0 53 52 1583 2245 1586 1584 or21nand_x0
xsubckt_1569_nand2_x0 53 52 1716 1721 1723 nand2_x0
xsubckt_1456_nexor2_x0 53 52 1828 1850 1826 nexor2_x0
xsubckt_547_nexor2_x0 53 52 423 426 422 nexor2_x0
xsubckt_453_or2_x1 53 52 512 515 517 or2_x1
xsubckt_365_nand3_x0 53 52 592 594 610 2480 nand3_x0
xsubckt_158_and2_x1 53 52 786 810 2482 and2_x1
xsubckt_135_nand2_x0 53 52 808 810 186 nand2_x0
xsubckt_122_and3_x1 53 52 819 823 58 77 and3_x1
xsubckt_16_inv_x0 53 52 58 1292 inv_x0
xsubckt_224_or2_x1 53 52 723 725 727 or2_x1
xsubckt_310_nand3_x0 53 52 641 642 643 1271 nand3_x0
xsubckt_931_nor2_x0 53 52 2338 14 23 nor2_x0
xsubckt_2437_dff_x1 53 52 116 185 32 dff_x1
xsubckt_2106_and4_x1 53 52 1164 59 938 1282 58 and4_x1
xsubckt_1999_and3_x1 53 52 1279 1280 1283 1284 and3_x1
xsubckt_1494_and21nor_x0 53 52 1789 58 1790 2246 and21nor_x0
xsubckt_1307_nexor2_x0 53 52 2026 867 1972 nexor2_x0
xsubckt_1299_nexor2_x0 53 52 2034 30 1980 nexor2_x0
xsubckt_511_and2_x1 53 52 456 457 463 and2_x1
xsubckt_190_nand2_x0 53 52 755 756 760 nand2_x0
xsubckt_1057_nand3_x0 53 52 2218 2220 2221 814 nand3_x0
xsubckt_1085_mux2_x1 53 52 1282 48 850 2190 mux2_x1
xsubckt_2016_nand2_x0 53 52 1261 2242 879 nand2_x0
xsubckt_1971_nand3_x0 53 52 1309 1315 1317 19 nand3_x0
xsubckt_1907_mux2_x1 53 52 44 42 174 1378 mux2_x1
xsubckt_461_and21nor_x0 53 52 504 558 506 505 and21nor_x0
xsubckt_447_nand2_x0 53 52 117 518 520 nand2_x0
xsubckt_47_inv_x0 53 52 28 959 inv_x0
xsubckt_230_and21nor_x0 53 52 717 77 823 718 and21nor_x0
xsubckt_772_and2_x1 53 52 210 211 212 and2_x1
xsubckt_1075_or21nand_x0 53 52 2200 2253 2273 851 or21nand_x0
xsubckt_1108_nand3_x0 53 52 2168 2170 1239 173 nand3_x0
xsubckt_1256_and2_x1 53 52 2022 2023 1260 and2_x1
xsubckt_2252_nexor2_x0 53 52 1014 63 1007 nexor2_x0
xsubckt_2128_nand3_x0 53 52 1140 1145 1156 66 nand3_x0
xsubckt_2019_nand2_x0 53 52 1257 1258 1262 nand2_x0
xsubckt_1782_and21nor_x0 53 52 1509 1510 1513 773 and21nor_x0
xsubckt_1346_or21nand_x0 53 52 1934 2240 1938 1935 or21nand_x0
xsubckt_338_and3_x1 53 52 160 616 617 1271 and3_x1
xsubckt_26_inv_x0 53 52 172 1185 inv_x0
xsubckt_213_and3_x1 53 52 733 734 735 739 and3_x1
xsubckt_1006_nand3_x0 53 52 2268 175 174 173 nand3_x0
xsubckt_2274_and3_x1 53 52 984 801 927 175 and3_x1
xsubckt_2008_and2_x1 53 52 1269 1273 18 and2_x1
xsubckt_1916_mux2_x1 53 52 1370 1372 175 1369 mux2_x1
xsubckt_1690_nexor2_x0 53 52 1600 1601 1598 nexor2_x0
xsubckt_1517_and2_x1 53 52 1767 1768 798 and2_x1
xsubckt_636_or21nand_x0 53 52 337 338 344 567 or21nand_x0
xsubckt_463_nor2_x0 53 52 502 32 76 nor2_x0
xsubckt_459_nexor2_x0 53 52 507 510 506 nexor2_x0
xsubckt_796_nexor2_x0 53 52 64 65 187 nexor2_x0
xsubckt_925_and2_x1 53 52 2344 14 63 and2_x1
xsubckt_1930_nand3_x0 53 52 1353 1354 1355 803 nand3_x0
xsubckt_1706_nand2_x0 53 52 1582 1583 802 nand2_x0
xsubckt_1283_nand2_x0 53 52 1996 2001 798 nand2_x0
xsubckt_425_and2_x1 53 52 538 539 563 and2_x1
xsubckt_326_nand3_x0 53 52 627 832 77 1465 nand3_x0
xsubckt_112_and21nor_x0 53 52 829 2469 840 833 and21nor_x0
xsubckt_6_inv_x0 53 52 2469 1400 inv_x0
xsubckt_249_and2_x1 53 52 699 1260 2471 and2_x1
xsubckt_1101_nor3_x0 53 52 2175 2177 813 173 nor3_x0
xsubckt_1224_nand3_x0 53 52 2054 769 18 174 nand3_x0
xsubckt_1246_nexor2_x0 53 52 2081 1024 2032 nexor2_x0
xsubckt_2458_dff_x1 53 52 79 185 3 dff_x1
xsubckt_2175_or21nand_x0 53 52 1090 1094 1108 65 or21nand_x0
xsubckt_2092_and21nor_x0 53 52 1179 1220 1226 1230 and21nor_x0
xsubckt_1978_and21nor_x0 53 52 1301 1351 1359 1362 and21nor_x0
xsubckt_1939_nand3_x0 53 52 1343 59 1024 1282 nand3_x0
xsubckt_1813_and21nor_x0 53 52 1479 1532 1493 1497 and21nor_x0
xsubckt_1713_nexor2_x0 53 52 23 47 1576 nexor2_x0
xsubckt_1523_or21nand_x0 53 52 1761 1767 1778 73 or21nand_x0
xsubckt_1458_and2_x1 53 52 1824 1825 1829 and2_x1
xsubckt_1341_nand4_x0 53 52 1939 2081 981 1002 1024 nand4_x0
xsubckt_393_and21nor_x0 53 52 144 810 575 569 and21nor_x0
xsubckt_72_inv_x0 53 52 7 869 inv_x0
xsubckt_214_mux2_x1 53 52 733 753 821 732 mux2_x1
xsubckt_902_and21nor_x0 53 52 78 2366 2372 2379 and21nor_x0
xsubckt_1170_or21nand_x0 53 52 2107 2116 2113 2110 or21nand_x0
xsubckt_2400_dff_x1 53 52 156 185 2476 dff_x1
xsubckt_2387_dff_x1 53 52 161 185 2481 dff_x1
xsubckt_2182_nexor2_x0 53 52 1084 1085 1082 nexor2_x0
xsubckt_1910_or2_x1 53 52 1375 1376 173 or2_x1
xsubckt_1378_or2_x1 53 52 1903 1907 1088 or2_x1
xsubckt_183_and21nor_x0 53 52 762 786 794 796 and21nor_x0
xsubckt_185_nand2_x0 53 52 760 761 788 nand2_x0
xsubckt_264_nand2_x0 53 52 685 686 2470 nand2_x0
xsubckt_284_or21nand_x0 53 52 665 666 670 1271 or21nand_x0
xsubckt_646_nand2_x0 53 52 328 37 47 nand2_x0
xsubckt_724_nand3_x0 53 52 255 256 257 563 nand3_x0
xsubckt_2438_dff_x1 53 52 115 185 31 dff_x1
xsubckt_2313_or21nand_x0 53 52 942 975 964 974 or21nand_x0
xsubckt_1851_nand2_x0 53 52 1438 1439 1440 nand2_x0
xsubckt_364_and3_x1 53 52 593 594 610 2480 and3_x1
xsubckt_820_nexor2_x0 53 52 2446 2450 2444 nexor2_x0
xsubckt_1275_and21nor_x0 53 52 2004 2010 2009 2005 and21nor_x0
xsubckt_2337_and2_x1 53 52 916 918 1576 and2_x1
xsubckt_1993_nand2_x0 53 52 1286 2269 949 nand2_x0
xsubckt_1840_nexor2_x0 53 52 1458 22 1450 nexor2_x0
xsubckt_1722_and21nor_x0 53 52 1567 1570 1576 787 and21nor_x0
xsubckt_1656_and21nor_x0 53 52 1631 1674 1676 1679 and21nor_x0
xsubckt_1639_or4_x1 53 52 1648 62 175 174 173 or4_x1
xsubckt_1364_nand2_x0 53 52 1917 2270 68 nand2_x0
xsubckt_626_xor2_x0 53 52 38 71 347 xor2_x0
xsubckt_2027_or21nand_x0 53 52 1248 1306 1307 1311 or21nand_x0
xsubckt_1750_and3_x1 53 52 1540 1541 174 1249 and3_x1
xsubckt_1695_nand2_x0 53 52 1593 2236 853 nand2_x0
xsubckt_1397_and2_x1 53 52 1884 1885 2237 and2_x1
xsubckt_438_mux2_x1 53 52 33 527 558 526 mux2_x1
xsubckt_339_or21nand_x0 53 52 615 623 821 1432 or21nand_x0
xsubckt_10_inv_x0 53 52 2481 1357 inv_x0
xsubckt_186_and21nor_x0 53 52 759 791 793 795 and21nor_x0
xsubckt_742_xor2_x0 53 52 9 18 238 xor2_x0
xsubckt_793_nand2_x0 53 52 83 190 200 nand2_x0
xsubckt_2007_or2_x1 53 52 1270 1273 879 or2_x1
xsubckt_1766_nand2_x0 53 52 1524 1525 1260 nand2_x0
xsubckt_1615_and4_x1 53 52 1671 1799 886 891 900 and4_x1
xsubckt_1210_and21nor_x0 53 52 2067 2088 2087 2068 and21nor_x0
xsubckt_2256_and21nor_x0 53 52 1003 1005 1007 787 and21nor_x0
xsubckt_2002_nand3_x0 53 52 1276 1277 175 1249 nand3_x0
xsubckt_1732_nand4_x0 53 52 1557 59 883 1282 1292 nand4_x0
xsubckt_1499_or21nand_x0 53 52 1784 1848 1849 1853 or21nand_x0
xsubckt_1367_nor2_x0 53 52 1914 1915 1916 nor2_x0
xsubckt_624_or2_x1 53 52 349 38 71 or2_x1
xsubckt_92_inv_x0 53 52 25 849 inv_x0
xsubckt_709_and2_x1 53 52 270 24 17 and2_x1
xsubckt_949_or2_x1 53 52 2321 2322 2323 or2_x1
xsubckt_1020_nand2_x0 53 52 2254 2256 2258 nand2_x0
xsubckt_1096_and2_x1 53 52 140 2180 2182 and2_x1
xsubckt_1128_nand3_x0 53 52 2148 2156 2178 1099 nand3_x0
xsubckt_2396_dff_x1 53 52 160 185 2480 dff_x1
xsubckt_2310_nand2_x0 53 52 945 947 61 nand2_x0
xsubckt_2297_or21nand_x0 53 52 958 2240 1619 960 or21nand_x0
xsubckt_2037_nand4_x0 53 52 1238 71 175 1239 173 nand4_x0
xsubckt_1682_and2_x1 53 52 1606 1607 69 and2_x1
xsubckt_1605_and3_x1 53 52 1681 1683 1685 71 and3_x1
xsubckt_1548_nand2_x0 53 52 1736 1737 1742 nand2_x0
xsubckt_1512_nor3_x0 53 52 1772 1773 1774 1775 nor3_x0
xsubckt_1289_and3_x1 53 52 1990 1994 1998 43 and3_x1
xsubckt_598_nand2_x0 53 52 373 26 70 nand2_x0
xsubckt_469_and2_x1 53 52 497 31 75 and2_x1
xsubckt_147_mux2_x1 53 52 1239 800 175 797 mux2_x1
xsubckt_177_or2_x1 53 52 768 175 173 or2_x1
xsubckt_1034_nand2_x0 53 52 2240 2243 1292 nand2_x0
xsubckt_1180_nand2_x0 53 52 2097 2101 45 nand2_x0
xsubckt_1743_nand2_x0 53 52 1547 76 175 nand2_x0
xsubckt_1667_nexor2_x0 53 52 1663 12 1620 nexor2_x0
xsubckt_170_nexor2_x0 53 52 846 2474 775 nexor2_x0
xsubckt_275_or2_x1 53 52 674 676 682 or2_x1
xsubckt_304_and3_x1 53 52 647 648 674 803 and3_x1
xsubckt_2435_dff_x1 53 52 124 185 40 dff_x1
xsubckt_1917_and21nor_x0 53 52 1367 173 1369 1374 and21nor_x0
xsubckt_1908_and3_x1 53 52 1377 76 175 174 and3_x1
xsubckt_1878_and21nor_x0 53 52 1409 1417 1413 1415 and21nor_x0
xsubckt_1648_nand3_x0 53 52 1639 1647 1650 70 nand3_x0
xsubckt_468_or21nand_x0 53 52 116 498 504 511 or21nand_x0
xsubckt_193_nexor2_x0 53 52 845 1325 753 nexor2_x0
xsubckt_922_nand3_x0 53 52 2347 687 23 169 nand3_x0
xsubckt_971_or2_x1 53 52 88 2301 2348 or2_x1
xsubckt_1032_nand2_x0 53 52 2242 59 57 nand2_x0
xsubckt_2114_nand3_x0 53 52 1156 801 1013 175 nand3_x0
xsubckt_2003_nand2_x0 53 52 1275 1276 1278 nand2_x0
xsubckt_1881_and2_x1 53 52 1406 1410 21 and2_x1
xsubckt_1500_nexor2_x0 53 52 1785 1802 1783 nexor2_x0
xsubckt_157_nand2_x0 53 52 787 186 2475 nand2_x0
xsubckt_842_nexor2_x0 53 52 2424 2427 2423 nexor2_x0
xsubckt_852_nand2_x0 53 52 2413 4 64 nand2_x0
xsubckt_1179_and2_x1 53 52 2098 2101 45 and2_x1
xsubckt_1798_nexor2_x0 53 52 1499 881 1493 nexor2_x0
xsubckt_1555_and21nor_x0 53 52 1730 64 801 1865 and21nor_x0
xsubckt_1530_nand3_x0 53 52 1754 1755 1756 803 nand3_x0
xsubckt_471_and21nor_x0 53 52 495 503 501 502 and21nor_x0
xsubckt_431_or21nand_x0 53 52 533 76 43 42 or21nand_x0
xsubckt_397_nexor2_x0 53 52 43 42 565 nexor2_x0
xsubckt_663_or2_x1 53 52 312 36 47 or2_x1
xsubckt_1173_and21nor_x0 53 52 2104 2120 2107 2106 and21nor_x0
xsubckt_2030_and3_x1 53 52 97 1246 1251 1271 and3_x1
xsubckt_1737_or2_x1 53 52 134 1553 1610 or2_x1
xsubckt_394_and2_x1 53 52 568 687 169 and2_x1
xsubckt_714_nexor2_x0 53 52 267 270 265 nexor2_x0
xsubckt_821_nand2_x0 53 52 2443 2444 568 nand2_x0
xsubckt_1055_nand4_x0 53 52 2220 18 175 1239 173 nand4_x0
xsubckt_1149_or21nand_x0 53 52 2127 1292 2128 2247 or21nand_x0
xsubckt_1982_nand2_x0 53 52 1297 2242 878 nand2_x0
xsubckt_1922_and3_x1 53 52 1362 1367 1375 20 and3_x1
xsubckt_1576_nexor2_x0 53 52 1711 1716 1709 nexor2_x0
xsubckt_610_nexor2_x0 53 52 363 364 362 nexor2_x0
xsubckt_1052_and3_x1 53 52 2223 2224 2225 2226 and3_x1
xsubckt_1223_nand2_x0 53 52 2055 2057 2066 nand2_x0
xsubckt_2344_or21nand_x0 53 52 102 176 910 950 or21nand_x0
xsubckt_2191_or21nand_x0 53 52 1072 787 1082 1073 or21nand_x0
xsubckt_1932_and21nor_x0 53 52 1351 1430 1405 1408 and21nor_x0
xsubckt_1757_nand3_x0 53 52 1533 1536 1538 849 nand3_x0
xsubckt_1687_nexor2_x0 53 52 1608 927 1601 nexor2_x0
xsubckt_1618_nexor2_x0 53 52 1708 886 1668 nexor2_x0
xsubckt_38_inv_x0 53 52 75 1056 inv_x0
xsubckt_1_inv_x0 53 52 2477 1454 inv_x0
xsubckt_172_and2_x1 53 52 773 1239 173 and2_x1
xsubckt_311_nand2_x0 53 52 148 641 650 nand2_x0
xsubckt_1266_nand2_x0 53 52 2013 63 175 nand2_x0
xcmpt_one_0 53 52 60 one_x1
xsubckt_2327_or21nand_x0 53 52 926 928 802 1271 or21nand_x0
xsubckt_2237_mux2_x1 53 52 179 19 1200 1023 mux2_x1
xsubckt_2091_or21nand_x0 53 52 1180 1219 1227 1229 or21nand_x0
xsubckt_2031_nand2_x0 53 52 1245 927 175 nand2_x0
xsubckt_1817_nand3_x0 53 52 1475 2271 75 1228 nand3_x0
xsubckt_1504_nand2_x0 53 52 1779 1780 176 nand2_x0
xsubckt_1322_and21nor_x0 53 52 1958 1959 1961 1967 and21nor_x0
xsubckt_1314_nand3_x0 53 52 1966 2271 63 1228 nand3_x0
xsubckt_596_and21nor_x0 53 52 375 405 402 404 and21nor_x0
xsubckt_534_or21nand_x0 53 52 434 436 438 563 or21nand_x0
xsubckt_151_nexor2_x0 53 52 797 1357 793 nexor2_x0
xsubckt_20_inv_x0 53 52 173 1249 inv_x0
xsubckt_854_nexor2_x0 53 52 2412 2415 2411 nexor2_x0
xsubckt_970_and21nor_x0 53 52 2301 2302 2309 568 and21nor_x0
xsubckt_1102_or21nand_x0 53 52 2174 175 2216 2176 or21nand_x0
xsubckt_1105_nand3_x0 53 52 2171 2173 174 1249 nand3_x0
xsubckt_1746_nand3_x0 53 52 1544 752 44 173 nand3_x0
xsubckt_1558_nand4_x0 53 52 1727 1729 1730 1731 798 nand4_x0
xsubckt_2462_dff_x1 53 52 89 185 13 dff_x1
xsubckt_2417_dff_x1 53 52 134 185 47 dff_x1
xsubckt_1312_and2_x1 53 52 130 1968 1985 and2_x1
xsubckt_40_inv_x0 53 52 74 1034 inv_x0
xsubckt_747_nand2_x0 53 52 85 234 235 nand2_x0
xsubckt_767_or21nand_x0 53 52 214 215 562 567 or21nand_x0
xsubckt_1235_nexor2_x0 53 52 2049 1142 2043 nexor2_x0
xsubckt_2395_dff_x1 53 52 147 185 2467 dff_x1
xsubckt_2304_or21nand_x0 53 52 104 952 966 986 or21nand_x0
xsubckt_2248_nand3_x0 53 52 1011 1015 1020 63 nand3_x0
xsubckt_2178_nexor2_x0 53 52 1092 65 1086 nexor2_x0
xsubckt_1565_and3_x1 53 52 1720 1725 1727 72 and3_x1
xsubckt_1496_and2_x1 53 52 1787 1788 1260 and2_x1
xsubckt_1340_and4_x1 53 52 1940 2081 981 1002 1024 and4_x1
xsubckt_513_or21nand_x0 53 52 455 74 72 73 or21nand_x0
xsubckt_478_or21nand_x0 53 52 488 510 508 509 or21nand_x0
xsubckt_321_nand3_x0 53 52 631 633 637 1422 nand3_x0
xsubckt_870_nand2_x0 53 52 2396 2397 563 nand2_x0
xsubckt_1169_and21nor_x0 53 52 2108 2115 2112 2109 and21nor_x0
xsubckt_2356_and21nor_x0 53 52 901 778 172 1217 and21nor_x0
xsubckt_2275_or21nand_x0 53 52 983 47 801 985 or21nand_x0
xsubckt_2121_and3_x1 53 52 1148 47 174 173 and3_x1
xsubckt_1948_nand2_x0 53 52 1334 2269 970 nand2_x0
xsubckt_1893_nand3_x0 53 52 1393 1394 1396 2237 nand3_x0
xsubckt_1818_nand4_x0 53 52 1474 74 175 174 173 nand4_x0
xsubckt_1549_nand3_x0 53 52 1735 1736 1749 1754 nand3_x0
xsubckt_1407_and21nor_x0 53 52 1874 788 1889 1875 and21nor_x0
xsubckt_1301_and4_x1 53 52 1978 59 6 57 58 and4_x1
xsubckt_1285_or21nand_x0 53 52 1994 2016 2004 1997 or21nand_x0
xsubckt_521_nand2_x0 53 52 447 448 568 nand2_x0
xsubckt_930_and21nor_x0 53 52 2339 2353 2354 2355 and21nor_x0
xsubckt_1035_nand3_x0 53 52 2239 59 1163 1292 nand3_x0
xsubckt_1264_nand3_x0 53 52 2015 2114 174 1249 nand3_x0
xsubckt_1339_nexor2_x0 53 52 1943 1948 1941 nexor2_x0
xsubckt_585_nexor2_x0 53 52 47 69 386 nexor2_x0
xsubckt_476_nand2_x0 53 52 490 31 43 nand2_x0
xsubckt_202_nexor2_x0 53 52 747 1325 744 nexor2_x0
xsubckt_205_nand2_x0 53 52 741 742 744 nand2_x0
xsubckt_980_nand4_x0 53 52 2292 2296 2297 2307 2324 nand4_x0
xsubckt_1078_nand3_x0 53 52 2197 2202 2204 2249 nand3_x0
xsubckt_1092_nand3_x0 53 52 2183 2184 2188 2189 nand3_x0
xsubckt_1237_or21nand_x0 53 52 2041 2096 2090 2093 or21nand_x0
xsubckt_2439_dff_x1 53 52 114 185 30 dff_x1
xsubckt_2181_and21nor_x0 53 52 1083 1138 1130 1137 and21nor_x0
xsubckt_2134_and21nor_x0 53 52 1134 1179 1181 1184 and21nor_x0
xsubckt_1423_and21nor_x0 53 52 1859 1863 1862 1860 and21nor_x0
xsubckt_567_xor2_x0 53 52 27 71 403 xor2_x0
xsubckt_341_and21nor_x0 53 52 613 614 615 628 and21nor_x0
xsubckt_144_or2_x1 53 52 800 174 173 or2_x1
xsubckt_31_inv_x0 53 52 42 1131 inv_x0
xsubckt_8_inv_x0 53 52 2471 1379 inv_x0
xsubckt_207_nand3_x0 53 52 739 740 741 803 nand3_x0
xsubckt_988_or2_x1 53 52 87 2285 2348 or2_x1
xsubckt_1763_or21nand_x0 53 52 1527 25 2233 1528 or21nand_x0
xsubckt_1610_nexor2_x0 53 52 1682 970 1676 nexor2_x0
xsubckt_1561_and3_x1 53 52 1724 1725 1727 991 and3_x1
xsubckt_348_nand4_x0 53 52 607 648 674 803 836 nand4_x0
xsubckt_81_inv_x0 53 52 61 860 inv_x0
xsubckt_666_nexor2_x0 53 52 36 47 309 nexor2_x0
xsubckt_668_nand3_x0 53 52 307 309 323 328 nand3_x0
xsubckt_1206_nand4_x0 53 52 2071 59 32 1282 1292 nand4_x0
xsubckt_2406_dff_x1 53 52 131 185 44 dff_x1
xsubckt_2381_dff_x1 53 52 146 185 175 dff_x1
xsubckt_2311_nexor2_x0 53 52 948 860 944 nexor2_x0
xsubckt_1848_and2_x1 53 52 1441 2242 22 and2_x1
xsubckt_1589_and2_x1 53 52 1696 1697 787 and2_x1
xsubckt_1582_and21nor_x0 53 52 1703 856 2236 1704 and21nor_x0
xsubckt_1461_or21nand_x0 53 52 1822 1828 1850 1851 or21nand_x0
xsubckt_1418_nand4_x0 53 52 1864 23 175 174 173 nand4_x0
xsubckt_1405_nand2_x0 53 52 1876 1877 787 nand2_x0
xsubckt_426_and21nor_x0 53 52 537 562 545 538 and21nor_x0
xsubckt_241_and2_x1 53 52 707 801 2471 and2_x1
xsubckt_730_xor2_x0 53 52 67 68 250 xor2_x0
xsubckt_888_and3_x1 53 52 2379 2380 2381 568 and3_x1
xsubckt_932_nand2_x0 53 52 2337 14 23 nand2_x0
xsubckt_1142_nand4_x0 53 52 2134 2135 2137 2243 1292 nand4_x0
xsubckt_2244_nor3_x0 53 52 1016 1017 1018 1019 nor3_x0
xsubckt_1721_nand2_x0 53 52 1568 1569 1575 nand2_x0
xsubckt_1673_and21nor_x0 53 52 1614 803 1632 1615 and21nor_x0
xsubckt_1627_and2_x1 53 52 1659 1660 787 and2_x1
xsubckt_1535_nand3_x0 53 52 1749 1750 1751 788 nand3_x0
xsubckt_1413_and3_x1 53 52 1869 2064 174 1249 and3_x1
xsubckt_1292_nexor2_x0 53 52 1993 43 1987 nexor2_x0
xsubckt_794_and2_x1 53 52 189 192 195 and2_x1
xsubckt_867_xor2_x0 53 52 3 63 2399 xor2_x0
xsubckt_2352_nand2_x0 53 52 904 2268 186 nand2_x0
xsubckt_1931_or21nand_x0 53 52 1352 1429 1406 1407 or21nand_x0
xsubckt_1741_nand3_x0 53 52 1549 2271 42 1228 nand3_x0
xsubckt_1353_nand2_x0 53 52 1927 1928 1930 nand2_x0
xsubckt_176_nor2_x0 53 52 769 175 173 nor2_x0
xsubckt_236_and2_x1 53 52 711 712 1271 and2_x1
xsubckt_1155_nand2_x0 53 52 2122 18 175 nand2_x0
xsubckt_2423_dff_x1 53 52 98 185 19 dff_x1
xsubckt_2335_or21nand_x0 53 52 919 925 923 920 or21nand_x0
xsubckt_1969_or21nand_x0 53 52 1311 1316 1318 19 or21nand_x0
xsubckt_1921_nand2_x0 53 52 1363 1365 20 nand2_x0
xsubckt_1590_or21nand_x0 53 52 1695 1701 1698 1696 or21nand_x0
xsubckt_1552_mux2_x1 53 52 180 44 1923 1733 mux2_x1
xsubckt_1451_or21nand_x0 53 52 1831 1838 1834 1832 or21nand_x0
xsubckt_154_nexor2_x0 53 52 792 794 790 nexor2_x0
xsubckt_1208_or21nand_x0 53 52 2069 2075 2072 2070 or21nand_x0
xsubckt_1240_nand2_x0 53 52 2038 2039 803 nand2_x0
xsubckt_2226_and3_x1 53 52 1035 1706 1707 2236 and3_x1
xsubckt_2169_and21nor_x0 53 52 1096 1102 1101 1098 and21nor_x0
xsubckt_2060_or21nand_x0 53 52 1213 2240 1880 1214 or21nand_x0
xsubckt_1794_and2_x1 53 52 1497 1499 24 and2_x1
xsubckt_1573_or21nand_x0 53 52 1712 1714 1716 803 or21nand_x0
xsubckt_1493_nexor2_x0 53 52 1837 859 1790 nexor2_x0
xsubckt_55_inv_x0 53 52 37 886 inv_x0
xsubckt_798_or21nand_x0 53 52 2465 207 204 206 or21nand_x0
xsubckt_804_or21nand_x0 53 52 2459 557 2461 2460 or21nand_x0
xsubckt_871_or21nand_x0 53 52 2395 2403 2402 2396 or21nand_x0
xsubckt_1063_nand2_x0 53 52 2212 2214 2217 nand2_x0
xsubckt_2254_and21nor_x0 53 52 1005 1049 1039 1048 and21nor_x0
xsubckt_2227_mux2_x1 53 52 57 866 850 1033 mux2_x1
xsubckt_1747_nand2_x0 53 52 1543 1544 811 nand2_x0
xsubckt_1488_and21nor_x0 53 52 1795 859 2236 1796 and21nor_x0
xsubckt_1438_nand3_x0 53 52 1844 1940 938 959 nand3_x0
xsubckt_1368_nand3_x0 53 52 1913 752 64 173 nand3_x0
xsubckt_497_nexor2_x0 53 52 472 473 470 nexor2_x0
xsubckt_389_or2_x1 53 52 571 574 174 or2_x1
xsubckt_369_and2_x1 53 52 588 589 803 and2_x1
xsubckt_90_inv_x0 53 52 49 851 inv_x0
xsubckt_704_nor2_x0 53 52 274 275 276 nor2_x0
xsubckt_1141_or3_x1 53 52 2135 33 40 41 or3_x1
xsubckt_1776_and4_x1 53 52 1515 75 175 174 173 and4_x1
xsubckt_562_nexor2_x0 53 52 409 410 408 nexor2_x0
xsubckt_550_and21nor_x0 53 52 419 438 436 437 and21nor_x0
xsubckt_254_nand3_x0 53 52 694 695 696 788 nand3_x0
xsubckt_736_xor2_x0 53 52 21 9 244 xor2_x0
xsubckt_816_and2_x1 53 52 2448 63 64 and2_x1
xsubckt_1132_nand3_x0 53 52 2144 2146 2148 2150 nand3_x0
xsubckt_1990_and21nor_x0 53 52 1288 788 1299 1289 and21nor_x0
xsubckt_150_nexor2_x0 53 52 797 2481 794 nexor2_x0
xsubckt_148_nor2_x0 53 52 796 797 1357 nor2_x0
xsubckt_244_nexor2_x0 53 52 801 2471 704 nexor2_x0
xsubckt_773_or21nand_x0 53 52 209 211 212 563 or21nand_x0
xsubckt_1058_nand3_x0 53 52 2217 769 873 174 nand3_x0
xsubckt_1068_and3_x1 53 52 2207 2210 2227 1153 and3_x1
xsubckt_1095_and21nor_x0 53 52 2180 2181 2195 176 and21nor_x0
xsubckt_2389_dff_x1 53 52 153 185 2473 dff_x1
xsubckt_2334_and3_x1 53 52 920 921 922 787 and3_x1
xsubckt_1668_nexor2_x0 53 52 1663 854 1619 nexor2_x0
xsubckt_1641_or21nand_x0 53 52 1646 23 801 1648 or21nand_x0
xsubckt_1630_and21nor_x0 53 52 1656 1673 1672 1657 and21nor_x0
xsubckt_1427_nand2_x0 53 52 1855 1856 1870 nand2_x0
xsubckt_602_and21nor_x0 53 52 110 370 376 383 and21nor_x0
xsubckt_2324_or21nand_x0 53 52 930 969 977 978 or21nand_x0
xsubckt_2126_or21nand_x0 53 52 1143 1146 1157 870 or21nand_x0
xsubckt_605_and21nor_x0 53 52 367 390 387 368 and21nor_x0
xsubckt_146_nand2_x0 53 52 798 801 175 nand2_x0
xsubckt_883_and21nor_x0 53 52 79 567 2395 2384 and21nor_x0
xsubckt_1698_and3_x1 53 52 1590 1663 853 854 and3_x1
xsubckt_1546_nand2_x0 53 52 1738 1739 1260 nand2_x0
xsubckt_1543_and2_x1 53 52 1741 1792 857 and2_x1
xsubckt_1514_or2_x1 53 52 1770 1771 559 or2_x1
xsubckt_1484_and4_x1 53 52 1799 1940 917 938 959 and4_x1
xsubckt_484_or3_x1 53 52 482 514 533 534 or3_x1
xsubckt_482_or21nand_x0 53 52 484 485 492 567 or21nand_x0
xsubckt_357_and4_x1 53 52 599 648 674 803 834 and4_x1
xsubckt_243_nexor2_x0 53 52 801 1379 705 nexor2_x0
xsubckt_259_mux2_x1 53 52 2473 181 777 689 mux2_x1
xsubckt_727_and21nor_x0 53 52 92 263 253 254 and21nor_x0
xsubckt_2196_and2_x1 53 52 1067 1068 1072 and2_x1
xsubckt_2087_and21nor_x0 53 52 1184 1190 1193 872 and21nor_x0
xsubckt_1886_nand2_x0 53 52 1401 1409 21 nand2_x0
xsubckt_517_nand2_x0 53 52 451 71 72 nand2_x0
xsubckt_386_or3_x1 53 52 573 169 175 186 or3_x1
xsubckt_139_and21nor_x0 53 52 804 2482 806 176 and21nor_x0
xsubckt_250_and21nor_x0 53 52 698 77 823 699 and21nor_x0
xsubckt_2345_or21nand_x0 53 52 909 847 55 850 or21nand_x0
xsubckt_2239_and3_x1 53 52 1021 801 949 175 and3_x1
xsubckt_2108_nor3_x0 53 52 1161 1162 1164 186 nor3_x0
xsubckt_1821_nand4_x0 53 52 1471 1473 1474 1475 770 nand4_x0
xsubckt_1642_and2_x1 53 52 1645 1647 1650 and2_x1
xsubckt_502_nexor2_x0 53 52 466 469 465 nexor2_x0
xsubckt_325_and3_x1 53 52 628 832 77 1465 and3_x1
xsubckt_101_and21nor_x0 53 52 840 842 1379 1389 and21nor_x0
xsubckt_77_inv_x0 53 52 63 864 inv_x0
xsubckt_2144_or21nand_x0 53 52 1123 2240 1791 1124 or21nand_x0
xsubckt_1503_mux2_x1 53 52 182 46 1923 1780 mux2_x1
xsubckt_595_or21nand_x0 53 52 376 557 378 377 or21nand_x0
xsubckt_457_and2_x1 53 52 508 32 44 and2_x1
xsubckt_808_nexor2_x0 53 52 6 66 2455 nexor2_x0
xsubckt_893_nexor2_x0 53 52 2375 2378 2374 nexor2_x0
xsubckt_1040_nand2_x0 53 52 2234 2235 882 nand2_x0
xsubckt_2394_dff_x1 53 52 148 185 2468 dff_x1
xsubckt_1644_nand3_x0 53 52 1643 1647 1650 949 nand3_x0
xsubckt_1588_nand4_x0 53 52 1697 59 891 1282 1292 nand4_x0
xsubckt_587_or21nand_x0 53 52 384 395 390 386 or21nand_x0
xsubckt_473_or21nand_x0 53 52 493 495 496 563 or21nand_x0
xsubckt_295_nand2_x0 53 52 655 657 660 nand2_x0
xsubckt_1147_nexor2_x0 53 52 2187 9 2129 nexor2_x0
xsubckt_2366_or21nand_x0 53 52 892 50 56 171 or21nand_x0
xsubckt_2142_nand2_x0 53 52 1125 2242 870 nand2_x0
xsubckt_1965_and3_x1 53 52 1316 801 42 175 and3_x1
xsubckt_1428_and3_x1 53 52 1854 1856 1870 75 and3_x1
xsubckt_218_or21nand_x0 53 52 729 752 173 2472 or21nand_x0
xsubckt_2346_and2_x1 53 52 163 909 56 and2_x1
xsubckt_2266_or21nand_x0 53 52 992 1042 1052 1053 or21nand_x0
xsubckt_1577_and3_x1 53 52 1708 1799 891 900 and3_x1
xsubckt_1296_or21nand_x0 53 52 1983 2037 2043 2044 or21nand_x0
xsubckt_619_nor2_x0 53 52 353 354 360 nor2_x0
xsubckt_549_or21nand_x0 53 52 420 28 558 562 or21nand_x0
xsubckt_129_nand2_x0 53 52 814 174 1249 nand2_x0
xsubckt_51_inv_x0 53 52 26 917 inv_x0
xsubckt_702_and4_x1 53 52 276 801 20 169 175 and4_x1
xsubckt_1065_or21nand_x0 53 52 2210 2223 2218 2213 or21nand_x0
xsubckt_1211_and2_x1 53 52 132 2067 2082 and2_x1
xsubckt_2450_dff_x1 53 52 93 185 17 dff_x1
xsubckt_2306_nand2_x0 53 52 950 951 176 nand2_x0
xsubckt_2287_or21nand_x0 53 52 969 992 1007 1011 or21nand_x0
xsubckt_2070_and3_x1 53 52 1202 1185 1196 170 and3_x1
xsubckt_2062_and4_x1 53 52 1211 59 863 1282 1292 and4_x1
xsubckt_1880_nand2_x0 53 52 1407 1409 873 nand2_x0
xsubckt_614_xor2_x0 53 52 39 69 358 xor2_x0
xsubckt_499_or2_x1 53 52 468 30 42 or2_x1
xsubckt_371_or21nand_x0 53 52 586 588 591 2476 or21nand_x0
xsubckt_43_inv_x0 53 52 30 1002 inv_x0
xsubckt_209_nand2_x0 53 52 737 738 743 nand2_x0
xsubckt_660_nexor2_x0 53 52 316 319 315 nexor2_x0
xsubckt_1178_nand2_x0 53 52 2099 2102 1066 nand2_x0
xsubckt_48_inv_x0 53 52 70 949 inv_x0
xsubckt_221_nexor2_x0 53 52 749 2472 726 nexor2_x0
xsubckt_918_or21nand_x0 53 52 2350 2351 2352 567 or21nand_x0
xsubckt_1056_and3_x1 53 52 2219 2220 2221 814 and3_x1
xsubckt_1139_or21nand_x0 53 52 2137 41 40 33 or21nand_x0
xsubckt_599_xor2_x0 53 52 26 70 372 xor2_x0
xsubckt_23_inv_x0 53 52 50 1217 inv_x0
xsubckt_1257_nand2_x0 53 52 2021 2022 2024 nand2_x0
xsubckt_2231_and3_x1 53 52 1029 1030 1031 1260 and3_x1
xsubckt_116_and21nor_x0 53 52 825 2469 840 826 and21nor_x0
xsubckt_46_inv_x0 53 52 71 970 inv_x0
xsubckt_941_or21nand_x0 53 52 2329 2346 2344 2345 or21nand_x0
xsubckt_1175_mux2_x1 53 52 880 2104 798 2102 mux2_x1
xsubckt_2190_and2_x1 53 52 1073 1074 802 and2_x1
xsubckt_2166_and21nor_x0 53 52 1100 175 949 814 and21nor_x0
xsubckt_2041_and3_x1 53 52 1234 1371 175 1249 and3_x1
xsubckt_2028_nexor2_x0 53 52 1250 1267 1247 nexor2_x0
xsubckt_1991_and2_x1 53 52 98 1288 1302 and2_x1
xsubckt_1751_nand3_x0 53 52 1539 769 46 174 nand3_x0
xsubckt_1483_and2_x1 53 52 1800 1801 803 and2_x1
xsubckt_54_inv_x0 53 52 38 891 inv_x0
xsubckt_223_nand2_x0 53 52 724 725 727 nand2_x0
xsubckt_681_nand2_x0 53 52 295 296 563 nand2_x0
xsubckt_807_nand2_x0 53 52 2456 6 66 nand2_x0
xsubckt_1094_and2_x1 53 52 2181 2183 802 and2_x1
xsubckt_2422_dff_x1 53 52 99 185 20 dff_x1
xsubckt_1846_nexor2_x0 53 52 1446 1451 1444 nexor2_x0
xsubckt_711_and2_x1 53 52 268 22 16 and2_x1
xsubckt_776_nand2_x0 53 52 206 7 19 nand2_x0
xsubckt_853_xor2_x0 53 52 4 64 2412 xor2_x0
xsubckt_1074_and21nor_x0 53 52 2201 2252 2272 49 and21nor_x0
xsubckt_452_nand2_x0 53 52 513 515 517 nand2_x0
xsubckt_89_inv_x0 53 52 10 852 inv_x0
xsubckt_12_inv_x0 53 52 2474 1336 inv_x0
xsubckt_219_nand3_x0 53 52 728 751 1249 2472 nand3_x0
xsubckt_682_or2_x1 53 52 294 295 298 or2_x1
xsubckt_1024_and21nor_x0 53 52 2250 2252 2272 851 and21nor_x0
xsubckt_2351_and2_x1 53 52 166 905 56 and2_x1
xsubckt_2056_nexor2_x0 53 52 1220 1221 1218 nexor2_x0
xsubckt_1465_nand4_x0 53 52 1818 860 175 1239 173 nand4_x0
xsubckt_182_nexor2_x0 53 52 767 1336 763 nexor2_x0
xsubckt_309_nand2_x0 53 52 642 644 2468 nand2_x0
xsubckt_959_nexor2_x0 53 52 12 61 2312 nexor2_x0
xsubckt_2272_nand2_x0 53 52 986 987 176 nand2_x0
xsubckt_2023_and21nor_x0 53 52 1253 2245 865 186 and21nor_x0
xsubckt_2005_or21nand_x0 53 52 1273 1279 1275 1274 or21nand_x0
xsubckt_491_nand3_x0 53 52 475 477 481 482 nand3_x0
xsubckt_58_inv_x0 53 52 34 883 inv_x0
xsubckt_245_or21nand_x0 53 52 703 721 726 729 or21nand_x0
xsubckt_916_and2_x1 53 52 2352 2353 2354 and2_x1
xsubckt_928_or21nand_x0 53 52 2341 14 558 562 or21nand_x0
xsubckt_992_nexor2_x0 53 52 2283 2284 2281 nexor2_x0
xsubckt_2390_dff_x1 53 52 152 185 2472 dff_x1
xsubckt_2303_or21nand_x0 53 52 952 953 962 1271 or21nand_x0
xsubckt_2177_nand3_x0 53 52 1087 1093 1107 65 nand3_x0
xsubckt_2174_and21nor_x0 53 52 1091 1093 1107 868 and21nor_x0
xsubckt_2043_nand3_x0 53 52 1232 801 75 175 nand3_x0
xsubckt_1775_nand2_x0 53 52 1516 75 175 nand2_x0
xsubckt_1554_nand3_x0 53 52 1731 769 62 174 nand3_x0
xsubckt_1522_and21nor_x0 53 52 1762 1766 1777 1013 and21nor_x0
xsubckt_1521_nand3_x0 53 52 1763 1766 1777 73 nand3_x0
xsubckt_514_or21nand_x0 53 52 454 476 471 455 or21nand_x0
xsubckt_355_and2_x1 53 52 158 601 602 and2_x1
xsubckt_99_and21nor_x0 53 52 842 844 2473 2472 and21nor_x0
xsubckt_305_or21nand_x0 53 52 646 647 649 820 or21nand_x0
xsubckt_1001_and3_x1 53 52 2273 801 24 175 and3_x1
xsubckt_1091_and2_x1 53 52 2184 2185 1260 and2_x1
xsubckt_1172_nand3_x0 53 52 2105 769 19 174 nand3_x0
xsubckt_2267_and21nor_x0 53 52 990 1043 1051 1054 and21nor_x0
xsubckt_2102_nand2_x0 53 52 1168 1836 2241 nand2_x0
xsubckt_2042_or2_x1 53 52 1233 1234 1235 or2_x1
xsubckt_2020_nand3_x0 53 52 1256 59 29 1282 nand3_x0
xsubckt_1842_nand2_x0 53 52 1448 1450 1478 nand2_x0
xsubckt_1583_nand2_x0 53 52 1702 1703 2237 nand2_x0
xsubckt_1309_and21nor_x0 53 52 1970 1971 1975 186 and21nor_x0
xsubckt_429_xor2_x0 53 52 75 76 535 xor2_x0
xsubckt_118_nexor2_x0 53 52 824 2475 823 nexor2_x0
xsubckt_41_inv_x0 53 52 31 1024 inv_x0
xsubckt_789_nexor2_x0 53 52 65 66 193 nexor2_x0
xsubckt_1064_and21nor_x0 53 52 2211 2222 2219 2212 and21nor_x0
xsubckt_2459_dff_x1 53 52 78 185 2 dff_x1
xsubckt_2068_or21nand_x0 53 52 1204 787 1205 1209 or21nand_x0
xsubckt_1787_nand3_x0 53 52 1504 769 45 174 nand3_x0
xsubckt_1621_nand2_x0 53 52 1665 1666 2237 nand2_x0
xsubckt_1400_nexor2_x0 53 52 1933 4 1881 nexor2_x0
xsubckt_303_and21nor_x0 53 52 648 686 2470 2469 and21nor_x0
xsubckt_790_or21nand_x0 53 52 192 199 196 194 or21nand_x0
xsubckt_942_nexor2_x0 53 52 2329 2330 2328 nexor2_x0
xsubckt_2193_and21nor_x0 53 52 1070 1134 1140 1144 and21nor_x0
xsubckt_1435_and21nor_x0 53 52 1847 1901 1891 1900 and21nor_x0
xsubckt_622_nand3_x0 53 52 351 687 47 169 nand3_x0
xsubckt_356_and4_x1 53 52 600 609 658 788 2478 and4_x1
xsubckt_25_inv_x0 53 52 171 1196 inv_x0
xsubckt_271_nand3_x0 53 52 678 679 680 788 nand3_x0
xsubckt_690_xor2_x0 53 52 34 47 287 xor2_x0
xsubckt_732_nexor2_x0 53 52 250 252 248 nexor2_x0
xsubckt_1174_or21nand_x0 53 52 2103 2121 2108 2105 or21nand_x0
xsubckt_1774_nand3_x0 53 52 1517 1519 1239 173 nand3_x0
xsubckt_1638_nor4_x0 53 52 1649 62 175 174 173 nor4_x0
xsubckt_1344_nand2_x0 53 52 1936 2242 42 nand2_x0
xsubckt_570_nand2_x0 53 52 400 401 563 nand2_x0
xsubckt_336_nand2_x0 53 52 617 619 2480 nand2_x0
xsubckt_143_nor2_x0 53 52 801 174 173 nor2_x0
xsubckt_140_and2_x1 53 52 162 804 805 and2_x1
xsubckt_669_nand3_x0 53 52 306 307 308 563 nand3_x0
xsubckt_1041_and21nor_x0 53 52 2233 1292 1282 850 and21nor_x0
xsubckt_2373_dff_x1 53 52 1 185 171 dff_x1
xsubckt_2353_or21nand_x0 53 52 903 1303 823 904 or21nand_x0
xsubckt_2251_nexor2_x0 53 52 1014 864 1008 nexor2_x0
xsubckt_2153_mux2_x1 53 52 182 22 1200 1113 mux2_x1
xsubckt_1402_or21nand_x0 53 52 1879 1292 1881 2247 or21nand_x0
xsubckt_1396_and21nor_x0 53 52 1885 863 2236 1886 and21nor_x0
xsubckt_379_mux2_x1 53 52 580 186 1465 579 mux2_x1
xsubckt_360_and21nor_x0 53 52 596 597 598 1454 and21nor_x0
xsubckt_705_nexor2_x0 53 52 274 17 273 nexor2_x0
xsubckt_786_nand2_x0 53 52 196 232 251 nand2_x0
xsubckt_849_or21nand_x0 53 52 2416 4 558 562 or21nand_x0
xsubckt_1187_and21nor_x0 53 52 2090 2146 2148 2151 and21nor_x0
xsubckt_2139_nexor2_x0 53 52 1130 1135 1128 nexor2_x0
xsubckt_2048_nand2_x0 53 52 1226 1231 68 nand2_x0
xsubckt_1779_or21nand_x0 53 52 1512 1153 2271 1514 or21nand_x0
xsubckt_1726_and21nor_x0 53 52 1563 852 2236 1564 and21nor_x0
xsubckt_1463_nand2_x0 53 52 1820 2271 858 nand2_x0
xsubckt_510_nand2_x0 53 52 457 458 563 nand2_x0
xsubckt_403_and2_x1 53 52 559 769 174 and2_x1
xsubckt_237_or21nand_x0 53 52 710 719 716 711 or21nand_x0
xsubckt_301_nand2_x0 53 52 650 651 176 nand2_x0
xsubckt_645_and2_x1 53 52 329 37 47 and2_x1
xsubckt_813_or21nand_x0 53 52 2451 66 64 65 or21nand_x0
xsubckt_2425_dff_x1 53 52 96 185 68 dff_x1
xsubckt_2315_and3_x1 53 52 940 1595 1596 2236 and3_x1
xsubckt_2236_or21nand_x0 53 52 106 1025 1026 1064 or21nand_x0
xsubckt_2045_nor2_x0 53 52 1230 1231 68 nor2_x0
xsubckt_1574_and21nor_x0 53 52 1711 1752 1760 1764 and21nor_x0
xsubckt_1320_nand3_x0 53 52 1960 752 65 173 nand3_x0
xsubckt_612_and21nor_x0 53 52 360 558 362 361 and21nor_x0
xsubckt_388_nand2_x0 53 52 572 574 174 nand2_x0
xsubckt_152_and2_x1 53 52 792 810 1346 and2_x1
xsubckt_313_nand2_x0 53 52 639 640 176 nand2_x0
xsubckt_685_and21nor_x0 53 52 291 884 557 563 and21nor_x0
xsubckt_803_and21nor_x0 53 52 2460 6 557 563 and21nor_x0
xsubckt_927_nexor2_x0 53 52 2343 2346 2342 nexor2_x0
xsubckt_1113_nand3_x0 53 52 2163 2165 2166 770 nand3_x0
xsubckt_1166_nand3_x0 53 52 2111 752 68 173 nand3_x0
xsubckt_2077_mux2_x1 53 52 71 69 174 1195 mux2_x1
xsubckt_1617_nexor2_x0 53 52 1708 37 1669 nexor2_x0
xsubckt_493_nand2_x0 53 52 115 474 484 nand2_x0
xsubckt_441_and2_x1 53 52 523 33 42 and2_x1
xsubckt_113_or2_x1 53 52 828 2478 2477 or2_x1
xsubckt_66_inv_x0 53 52 68 875 inv_x0
xsubckt_863_and2_x1 53 52 2403 2404 558 and2_x1
xsubckt_1154_nor3_x0 53 52 133 2123 2138 2143 nor3_x0
xsubckt_2053_nexor2_x0 53 52 1231 875 1221 nexor2_x0
xsubckt_1847_nand3_x0 53 52 1442 2135 2137 2236 nand3_x0
xsubckt_1442_and21nor_x0 53 52 1840 861 2236 1841 and21nor_x0
xsubckt_187_nexor2_x0 53 52 759 764 758 nexor2_x0
xsubckt_266_nexor2_x0 53 52 687 2470 683 nexor2_x0
xsubckt_746_nand2_x0 53 52 234 248 568 nand2_x0
xsubckt_856_or21nand_x0 53 52 2409 2417 2416 2410 or21nand_x0
xsubckt_997_or21nand_x0 53 52 2276 2300 2294 2283 or21nand_x0
xsubckt_2233_nand2_x0 53 52 1027 1028 802 nand2_x0
xsubckt_1559_and3_x1 53 52 1726 801 864 175 and3_x1
xsubckt_483_nor3_x0 53 52 483 514 533 534 nor3_x0
xsubckt_33_inv_x0 53 52 40 1110 inv_x0
xsubckt_267_nexor2_x0 53 52 687 1389 682 nexor2_x0
xsubckt_725_and21nor_x0 53 52 254 271 272 567 and21nor_x0
xsubckt_1008_nand3_x0 53 52 2266 2271 879 1228 nand3_x0
xsubckt_1049_nand2_x0 53 52 2226 2269 872 nand2_x0
xsubckt_2284_nexor2_x0 53 52 982 862 973 nexor2_x0
xsubckt_2183_and2_x1 53 52 1081 1747 2236 and2_x1
xsubckt_2131_and3_x1 53 52 1137 1145 1156 870 and3_x1
xsubckt_1973_nexor2_x0 53 52 1313 878 1307 nexor2_x0
xsubckt_545_and2_x1 53 52 424 28 75 and2_x1
xsubckt_490_or21nand_x0 53 52 476 483 480 478 or21nand_x0
xsubckt_344_and3_x1 53 52 159 611 612 1271 and3_x1
xsubckt_173_nand2_x0 53 52 772 1239 173 nand2_x0
xsubckt_2431_dff_x1 53 52 104 185 62 dff_x1
xsubckt_2138_or21nand_x0 53 52 1129 1173 1181 1186 or21nand_x0
xsubckt_2083_and2_x1 53 52 1189 1190 1193 and2_x1
xsubckt_1717_nand2_x0 53 52 1572 1573 1576 nand2_x0
xsubckt_1459_or2_x1 53 52 127 1824 1871 or2_x1
xsubckt_125_and3_x1 53 52 143 817 818 1271 and3_x1
xsubckt_161_and21nor_x0 53 52 783 788 785 784 and21nor_x0
xsubckt_290_nand3_x0 53 52 660 674 685 803 nand3_x0
xsubckt_913_and2_x1 53 52 2355 15 61 and2_x1
xsubckt_1067_or21nand_x0 53 52 2208 2211 2228 48 or21nand_x0
xsubckt_1987_and3_x1 53 52 1291 1293 1294 1260 and3_x1
xsubckt_1859_and21nor_x0 53 52 1430 1445 1451 1456 and21nor_x0
xsubckt_107_and2_x1 53 52 834 836 1443 and2_x1
xsubckt_694_or21nand_x0 53 52 283 34 558 562 or21nand_x0
xsubckt_948_and21nor_x0 53 52 2322 2339 2337 2338 and21nor_x0
xsubckt_2055_or21nand_x0 53 52 1219 1250 1267 1268 or21nand_x0
xsubckt_1935_nand2_x0 53 52 1348 2025 2241 nand2_x0
xsubckt_1858_and21nor_x0 53 52 101 1431 1447 176 and21nor_x0
xsubckt_1804_nand3_x0 53 52 1487 2186 2243 1292 nand3_x0
xsubckt_1440_nexor2_x0 53 52 1888 938 1842 nexor2_x0
xsubckt_64_inv_x0 53 52 16 877 inv_x0
xsubckt_167_nor2_x0 53 52 778 171 170 nor2_x0
xsubckt_696_nand3_x0 53 52 281 286 297 303 nand3_x0
xsubckt_890_or2_x1 53 52 2377 2 65 or2_x1
xsubckt_1047_and3_x1 53 52 2228 801 22 175 and3_x1
xsubckt_2403_dff_x1 53 52 140 185 48 dff_x1
xsubckt_2384_dff_x1 53 52 143 185 58 dff_x1
xsubckt_2203_and3_x1 53 52 1060 813 69 1249 and3_x1
xsubckt_1927_and21nor_x0 53 52 1356 1383 1401 1404 and21nor_x0
xsubckt_1505_nand2_x0 53 52 126 1779 1781 nand2_x0
xsubckt_1478_nand3_x0 53 52 1805 1812 1821 74 nand3_x0
xsubckt_1436_nexor2_x0 53 52 1848 1849 1846 nexor2_x0
xsubckt_1030_nand3_x0 53 52 2244 59 1282 1292 nand3_x0
xsubckt_1079_or21nand_x0 53 52 2196 2203 2205 2250 or21nand_x0
xsubckt_1093_or21nand_x0 53 52 2182 2198 2199 803 or21nand_x0
xsubckt_2189_or21nand_x0 53 52 1074 1081 1079 1075 or21nand_x0
xsubckt_1696_nand2_x0 53 52 1592 2242 927 nand2_x0
xsubckt_508_nexor2_x0 53 52 30 74 459 nexor2_x0
xsubckt_346_and2_x1 53 52 609 610 2480 and2_x1
xsubckt_114_nor2_x0 53 52 827 828 835 nor2_x0
xsubckt_184_nexor2_x0 53 52 762 763 761 nexor2_x0
xsubckt_957_or2_x1 53 52 2314 12 61 or2_x1
xsubckt_1019_and2_x1 53 52 2255 2256 2258 and2_x1
xsubckt_2319_nand4_x0 53 52 935 59 884 1282 58 nand4_x0
xsubckt_1995_nand3_x0 53 52 1284 1285 1286 1287 nand3_x0
xsubckt_1734_and21nor_x0 53 52 1555 1561 1558 1556 and21nor_x0
xsubckt_1714_xor2_x0 53 52 23 47 1575 xor2_x0
xsubckt_1510_and3_x1 53 52 1774 752 860 173 and3_x1
xsubckt_415_and2_x1 53 52 548 46 40 and2_x1
xsubckt_703_and4_x1 53 52 275 769 24 169 174 and4_x1
xsubckt_1086_or3_x1 53 52 2189 2190 2191 2194 or3_x1
xsubckt_1553_nand2_x0 53 52 1732 1733 176 nand2_x0
xsubckt_1502_or21nand_x0 53 52 1781 1782 1800 1271 or21nand_x0
xsubckt_1267_nand4_x0 53 52 2012 63 175 174 173 nand4_x0
xsubckt_2269_or21nand_x0 53 52 988 989 802 1271 or21nand_x0
xsubckt_2180_or21nand_x0 53 52 1084 1139 1129 1136 or21nand_x0
xsubckt_2135_or21nand_x0 53 52 1133 1180 1182 1183 or21nand_x0
xsubckt_1801_or2_x1 53 52 1490 1491 802 or2_x1
xsubckt_1659_nand2_x0 53 52 1628 1629 788 nand2_x0
xsubckt_1540_or2_x1 53 52 1744 59 73 or2_x1
xsubckt_1457_and21nor_x0 53 52 1825 1826 803 176 and21nor_x0
xsubckt_590_or2_x1 53 52 381 26 73 or2_x1
xsubckt_345_and4_x1 53 52 610 2469 2468 2467 2479 and4_x1
xsubckt_1081_and4_x1 53 52 2194 59 16 57 58 and4_x1
xsubckt_2152_or21nand_x0 53 52 1114 1115 1127 1271 or21nand_x0
xsubckt_1979_or21nand_x0 53 52 1300 1352 1360 1361 or21nand_x0
xsubckt_1918_and2_x1 53 52 1366 1367 1375 and2_x1
xsubckt_1528_nand2_x0 53 52 1756 1758 1760 nand2_x0
xsubckt_1420_and2_x1 53 52 1862 1868 750 and2_x1
xsubckt_558_nor2_x0 53 52 412 27 74 nor2_x0
xsubckt_751_nexor2_x0 53 52 66 67 230 nexor2_x0
xsubckt_851_nor2_x0 53 52 2414 4 64 nor2_x0
xsubckt_903_or21nand_x0 53 52 2365 62 23 61 or21nand_x0
xsubckt_1195_nand2_x0 53 52 2082 2083 2084 nand2_x0
xsubckt_2133_nand2_x0 53 52 1135 1140 1143 nand2_x0
xsubckt_577_xor2_x0 53 52 69 70 393 xor2_x0
xsubckt_540_nand2_x0 53 52 429 70 71 nand2_x0
xsubckt_474_nor2_x0 53 52 492 493 494 nor2_x0
xsubckt_728_or21nand_x0 53 52 252 68 19 18 or21nand_x0
xsubckt_1089_nexor2_x0 53 52 16 17 2186 nexor2_x0
xsubckt_1121_and3_x1 53 52 2155 2156 2178 46 and3_x1
xsubckt_1196_nor4_x0 53 52 2081 32 33 40 41 nor4_x0
xsubckt_2235_or21nand_x0 53 52 1025 1040 1041 1271 or21nand_x0
xsubckt_2129_and21nor_x0 53 52 1139 1145 1156 870 and21nor_x0
xsubckt_2105_nand2_x0 53 52 1165 1166 1168 nand2_x0
xsubckt_2006_nor2_x0 53 52 1272 1273 879 nor2_x0
xsubckt_639_nand2_x0 53 52 335 37 70 nand2_x0
xsubckt_538_and21nor_x0 53 52 431 454 453 452 and21nor_x0
xsubckt_420_nand2_x0 53 52 543 44 41 nand2_x0
xsubckt_234_nexor2_x0 53 52 843 1368 713 nexor2_x0
xsubckt_2276_nor2_x0 53 52 982 983 984 nor2_x0
xsubckt_2250_or21nand_x0 53 52 1009 1016 1021 63 or21nand_x0
xsubckt_2076_mux2_x1 53 52 70 47 174 1197 mux2_x1
xsubckt_1901_or21nand_x0 53 52 1384 787 1397 1385 or21nand_x0
xsubckt_1863_nand3_x0 53 52 1426 2271 74 1228 nand3_x0
xsubckt_1816_nand3_x0 53 52 1476 1551 174 1249 nand3_x0
xsubckt_1439_or21nand_x0 53 52 1843 28 1939 27 or21nand_x0
xsubckt_553_xor2_x0 53 52 28 72 416 xor2_x0
xsubckt_145_and2_x1 53 52 799 801 175 and2_x1
xsubckt_130_and2_x1 53 52 813 175 174 and2_x1
xsubckt_94_inv_x0 53 52 54 847 inv_x0
xsubckt_29_inv_x0 53 52 48 1153 inv_x0
xsubckt_812_mux2_x1 53 52 2452 2466 568 82 mux2_x1
xsubckt_829_nor2_x0 53 52 2435 2436 2437 nor2_x0
xsubckt_926_xor2_x0 53 52 14 63 2343 xor2_x0
xsubckt_1109_nand2_x0 53 52 2167 66 175 nand2_x0
xsubckt_2103_nand2_x0 53 52 1167 2242 67 nand2_x0
xsubckt_2040_and3_x1 53 52 1235 769 1034 174 and3_x1
xsubckt_1409_or21nand_x0 53 52 128 1873 1874 1921 or21nand_x0
xsubckt_552_nand2_x0 53 52 417 28 72 nand2_x0
xsubckt_200_and3_x1 53 52 746 748 750 2473 and3_x1
xsubckt_676_nand3_x0 53 52 300 312 326 327 nand3_x0
xsubckt_1171_and3_x1 53 52 2106 769 19 174 and3_x1
xsubckt_2456_dff_x1 53 52 81 185 5 dff_x1
xsubckt_2281_or3_x1 53 52 976 983 984 862 or3_x1
xsubckt_1716_or21nand_x0 53 52 1573 1580 1601 1605 or21nand_x0
xsubckt_1640_and21nor_x0 53 52 1647 858 800 1649 and21nor_x0
xsubckt_450_xor2_x0 53 52 74 75 515 xor2_x0
xsubckt_2348_and4_x1 53 52 907 175 174 173 186 and4_x1
xsubckt_2301_or21nand_x0 53 52 954 961 958 955 or21nand_x0
xsubckt_2156_mux2_x1 53 52 181 21 1200 1111 mux2_x1
xsubckt_1879_and2_x1 53 52 1408 1409 873 and2_x1
xsubckt_1487_and21nor_x0 53 52 1796 57 59 74 and21nor_x0
xsubckt_627_nexor2_x0 53 52 347 350 346 nexor2_x0
xsubckt_589_or21nand_x0 53 52 382 412 409 411 or21nand_x0
xsubckt_475_nor2_x0 53 52 491 31 43 nor2_x0
xsubckt_354_and21nor_x0 53 52 601 1443 603 176 and21nor_x0
xsubckt_91_inv_x0 53 52 59 850 inv_x0
xsubckt_231_nand2_x0 53 52 716 717 722 nand2_x0
xsubckt_1202_and2_x1 53 52 2075 2076 2079 and2_x1
xsubckt_2454_dff_x1 53 52 83 185 7 dff_x1
xsubckt_2312_nexor2_x0 53 52 948 61 943 nexor2_x0
xsubckt_1938_nand2_x0 53 52 1344 1345 1348 nand2_x0
xsubckt_1783_or21nand_x0 53 52 1508 1511 1512 772 or21nand_x0
xsubckt_1382_or2_x1 53 52 1899 1907 76 or2_x1
xsubckt_413_and2_x1 53 52 550 48 41 and2_x1
xsubckt_32_inv_x0 53 52 43 1120 inv_x0
xsubckt_165_nand3_x0 53 52 779 780 823 77 nand3_x0
xsubckt_191_and21nor_x0 53 52 754 820 755 774 and21nor_x0
xsubckt_670_and21nor_x0 53 52 305 306 313 568 and21nor_x0
xsubckt_713_nand2_x0 53 52 266 557 877 nand2_x0
xsubckt_801_xor2_x0 53 52 6 18 2462 xor2_x0
xsubckt_1088_nor2_x0 53 52 2187 16 17 nor2_x0
xsubckt_2123_and3_x1 53 52 1146 1147 1149 1152 and3_x1
xsubckt_2073_mux2_x1 53 52 184 25 1200 1199 mux2_x1
xsubckt_2058_and2_x1 53 52 1215 1887 2236 and2_x1
xsubckt_1898_nand2_x0 53 52 1387 1388 787 nand2_x0
xsubckt_1803_nand2_x0 53 52 1488 2192 2236 nand2_x0
xsubckt_1476_nand2_x0 53 52 1807 1811 74 nand2_x0
xsubckt_1445_and3_x1 53 52 1837 1933 861 863 and3_x1
xsubckt_1411_and2_x1 53 52 1871 1872 176 and2_x1
xsubckt_575_and2_x1 53 52 395 69 70 and2_x1
xsubckt_500_and2_x1 53 52 467 30 42 and2_x1
xsubckt_350_or3_x1 53 52 605 831 1303 2475 or3_x1
xsubckt_168_and4_x1 53 52 777 172 1196 1206 50 and4_x1
xsubckt_1104_and3_x1 53 52 2172 2173 174 1249 and3_x1
xsubckt_2463_dff_x1 53 52 88 185 12 dff_x1
xsubckt_2416_dff_x1 53 52 135 185 69 dff_x1
xsubckt_1894_nand3_x0 53 52 1392 59 1045 1282 nand3_x0
xsubckt_1712_or21nand_x0 53 52 135 1577 1581 1609 or21nand_x0
xsubckt_1703_nand4_x0 53 52 1585 59 884 1282 1292 nand4_x0
xsubckt_1701_and21nor_x0 53 52 1587 2241 1594 1591 and21nor_x0
xsubckt_1284_and21nor_x0 53 52 1995 2015 2003 1996 and21nor_x0
xsubckt_546_xor2_x0 53 52 28 75 423 xor2_x0
xsubckt_391_or3_x1 53 52 570 169 173 186 or3_x1
xsubckt_63_inv_x0 53 52 19 878 inv_x0
xsubckt_179_or21nand_x0 53 52 766 769 771 2474 or21nand_x0
xsubckt_2176_and3_x1 53 52 1089 1093 1107 65 and3_x1
xsubckt_1616_nand4_x0 53 52 1670 1799 886 891 900 nand4_x0
xsubckt_1520_and3_x1 53 52 1764 1766 1777 73 and3_x1
xsubckt_1490_and21nor_x0 53 52 1793 2241 1797 1794 and21nor_x0
xsubckt_1469_and3_x1 53 52 1814 769 866 174 and3_x1
xsubckt_1310_or2_x1 53 52 1969 1970 176 or2_x1
xsubckt_410_nand3_x0 53 52 552 553 554 567 nand3_x0
xsubckt_312_mux2_x1 53 52 2469 177 777 640 mux2_x1
xsubckt_2461_dff_x1 53 52 90 185 14 dff_x1
xsubckt_2414_dff_x1 53 52 137 185 71 dff_x1
xsubckt_2379_dff_x1 53 52 164 185 59 dff_x1
xsubckt_1871_nand2_x0 53 52 1417 1419 1428 nand2_x0
xsubckt_1707_and21nor_x0 53 52 1581 788 1598 1582 and21nor_x0
xsubckt_1376_nand2_x0 53 52 1905 1907 1088 nand2_x0
xsubckt_7_inv_x0 53 52 2470 1389 inv_x0
xsubckt_641_or21nand_x0 53 52 333 350 348 349 or21nand_x0
xsubckt_753_and21nor_x0 53 52 228 231 233 567 and21nor_x0
xsubckt_1272_nand3_x0 53 52 2007 752 66 173 nand3_x0
xsubckt_2124_nand3_x0 53 52 1145 1147 1149 1152 nand3_x0
xsubckt_1446_nexor2_x0 53 52 1882 3 1836 nexor2_x0
xsubckt_460_or21nand_x0 53 52 505 1045 558 562 or21nand_x0
xsubckt_79_inv_x0 53 52 62 862 inv_x0
xsubckt_272_and2_x1 53 52 677 800 2471 and2_x1
xsubckt_662_or21nand_x0 53 52 313 557 315 314 or21nand_x0
xsubckt_845_and2_x1 53 52 2420 4 67 and2_x1
xsubckt_857_mux2_x1 53 52 2409 2423 568 80 mux2_x1
xsubckt_974_xor2_x0 53 52 11 23 2298 xor2_x0
xsubckt_1070_and3_x1 53 52 2205 2210 2227 48 and3_x1
xsubckt_2234_and21nor_x0 53 52 1026 1037 1036 1027 and21nor_x0
xsubckt_2141_and2_x1 53 52 1126 1797 2236 and2_x1
xsubckt_2081_mux2_x1 53 52 1370 1373 175 1191 mux2_x1
xsubckt_1903_or21nand_x0 53 52 1382 1479 1451 1452 or21nand_x0
xsubckt_1399_and2_x1 53 52 1882 1933 863 and2_x1
xsubckt_608_nexor2_x0 53 52 39 72 364 nexor2_x0
xsubckt_693_and2_x1 53 52 284 285 558 and2_x1
xsubckt_715_and21nor_x0 53 52 264 265 558 563 and21nor_x0
xsubckt_832_xor2_x0 53 52 5 65 2432 xor2_x0
xsubckt_910_nexor2_x0 53 52 2359 2360 2358 nexor2_x0
xsubckt_1073_or21nand_x0 53 52 2202 2211 2228 1153 or21nand_x0
xsubckt_1160_nand3_x0 53 52 2117 2271 66 1228 nand3_x0
xsubckt_2179_nexor2_x0 53 52 1092 868 1085 nexor2_x0
xsubckt_2118_and3_x1 53 52 1151 70 1239 173 and3_x1
xsubckt_1854_nand4_x0 53 52 1435 59 9 1282 1292 nand4_x0
xsubckt_1839_nexor2_x0 53 52 1458 876 1451 nexor2_x0
xsubckt_11_inv_x0 53 52 2482 1346 inv_x0
xsubckt_240_nand2_x0 53 52 152 708 710 nand2_x0
xsubckt_1151_nand4_x0 53 52 2125 59 33 1282 1292 nand4_x0
xsubckt_2443_dff_x1 53 52 110 185 26 dff_x1
xsubckt_2257_and2_x1 53 52 1001 1669 2236 and2_x1
xsubckt_142_nand2_x0 53 52 802 186 1465 nand2_x0
xsubckt_111_or21nand_x0 53 52 830 1400 839 836 or21nand_x0
xsubckt_652_and21nor_x0 53 52 322 326 327 562 and21nor_x0
xsubckt_780_or21nand_x0 53 52 202 7 558 562 or21nand_x0
xsubckt_795_xor2_x0 53 52 64 65 188 xor2_x0
xsubckt_1890_nand2_x0 53 52 1396 2080 2236 nand2_x0
xsubckt_1738_and2_x1 53 52 1552 43 175 and2_x1
xsubckt_1486_nexor2_x0 53 52 1845 917 1797 nexor2_x0
xsubckt_1433_nexor2_x0 53 52 1855 1056 1849 nexor2_x0
xsubckt_699_nand2_x0 53 52 278 279 282 nand2_x0
xsubckt_994_or21nand_x0 53 52 2279 10 558 562 or21nand_x0
xsubckt_1168_nand2_x0 53 52 2109 2111 811 nand2_x0
xsubckt_1182_nand2_x0 53 52 2095 2101 1066 nand2_x0
xsubckt_2399_dff_x1 53 52 157 185 2477 dff_x1
xsubckt_2258_mux2_x1 53 52 57 864 850 1000 mux2_x1
xsubckt_1957_and2_x1 53 52 1324 1332 814 and2_x1
xsubckt_1343_nand4_x0 53 52 1937 59 5 57 58 nand4_x0
xsubckt_607_nand2_x0 53 52 365 39 72 nand2_x0
xsubckt_449_nand2_x0 53 52 516 74 75 nand2_x0
xsubckt_331_nand4_x0 53 52 622 648 674 803 837 nand4_x0
xsubckt_131_nand2_x0 53 52 812 175 174 nand2_x0
xsubckt_171_and3_x1 53 52 774 775 823 77 and3_x1
xsubckt_695_or2_x1 53 52 282 283 284 or2_x1
xsubckt_788_xor2_x0 53 52 65 66 194 xor2_x0
xsubckt_1027_and2_x1 53 52 2247 59 1282 and2_x1
xsubckt_1050_nand3_x0 53 52 2225 2271 875 1228 nand3_x0
xsubckt_2253_or21nand_x0 53 52 1006 1050 1038 1047 or21nand_x0
xsubckt_2075_nand2_x0 53 52 96 1198 1203 nand2_x0
xsubckt_1761_nand3_x0 53 52 1529 59 882 1292 nand3_x0
xsubckt_464_nand2_x0 53 52 501 32 76 nand2_x0
xsubckt_159_nexor2_x0 53 52 786 794 785 nexor2_x0
xsubckt_174_and3_x1 53 52 771 175 1239 173 and3_x1
xsubckt_199_and2_x1 53 52 747 748 750 and2_x1
xsubckt_314_and21nor_x0 53 52 638 840 2469 2468 and21nor_x0
xsubckt_649_or2_x1 53 52 325 326 327 or2_x1
xsubckt_757_and2_x1 53 52 224 8 20 and2_x1
xsubckt_1119_and21nor_x0 53 52 2157 2158 2171 2175 and21nor_x0
xsubckt_1219_nand3_x0 53 52 2059 752 67 173 nand3_x0
xsubckt_2296_mux2_x1 53 52 57 862 850 960 mux2_x1
xsubckt_2277_or2_x1 53 52 980 983 984 or2_x1
xsubckt_1844_and21nor_x0 53 52 1446 1533 1492 1495 and21nor_x0
xsubckt_756_or2_x1 53 52 225 8 20 or2_x1
xsubckt_792_nand3_x0 53 52 190 191 192 568 nand3_x0
xsubckt_872_and3_x1 53 52 2394 2426 2446 2450 and3_x1
xsubckt_906_nor2_x0 53 52 2362 15 64 nor2_x0
xsubckt_1252_and2_x1 53 52 2026 2074 869 and2_x1
xsubckt_2398_dff_x1 53 52 158 185 2478 dff_x1
xsubckt_2159_nand3_x0 53 52 1107 801 991 175 nand3_x0
xsubckt_2014_nexor2_x0 53 52 1265 1266 1263 nexor2_x0
xsubckt_1953_and3_x1 53 52 1329 1333 1334 1335 and3_x1
xsubckt_1856_and21nor_x0 53 52 1433 1434 1436 803 and21nor_x0
xsubckt_1355_and21nor_x0 53 52 1925 788 1941 1926 and21nor_x0
xsubckt_430_nexor2_x0 53 52 75 76 534 nexor2_x0
xsubckt_373_nand3_x0 53 52 584 585 586 820 nand3_x0
xsubckt_96_nor3_x0 53 52 845 2474 2482 2481 nor3_x0
xsubckt_279_and21nor_x0 53 52 670 671 678 821 and21nor_x0
xsubckt_817_nand2_x0 53 52 2447 63 64 nand2_x0
xsubckt_828_or21nand_x0 53 52 2436 2438 557 562 or21nand_x0
xsubckt_984_nexor2_x0 53 52 2289 2298 2288 nexor2_x0
xsubckt_1002_nand3_x0 53 52 2272 801 24 175 nand3_x0
xsubckt_1023_and3_x1 53 52 2251 2252 2272 851 and3_x1
xsubckt_2377_dff_x1 53 52 168 185 186 dff_x1
xsubckt_2322_nand2_x0 53 52 932 933 802 nand2_x0
xsubckt_2245_or3_x1 53 52 1015 1017 1018 1019 or3_x1
xsubckt_2155_nand2_x0 53 52 94 1112 1114 nand2_x0
xsubckt_2094_nand2_x0 53 52 1177 1179 1181 nand2_x0
xsubckt_2018_and21nor_x0 53 52 1258 2241 1932 1259 and21nor_x0
xsubckt_1959_nand3_x0 53 52 1322 769 1088 174 nand3_x0
xsubckt_1404_nand4_x0 53 52 1877 59 959 1282 1292 nand4_x0
xsubckt_1316_nand2_x0 53 52 1964 2270 18 nand2_x0
xsubckt_434_nor2_x0 53 52 530 45 33 nor2_x0
xsubckt_395_nand2_x0 53 52 567 687 169 nand2_x0
xsubckt_5_inv_x0 53 52 2468 1411 inv_x0
xsubckt_1280_and3_x1 53 52 1999 801 879 175 and3_x1
xsubckt_2367_or21nand_x0 53 52 890 1923 56 1206 or21nand_x0
xsubckt_2187_nand4_x0 53 52 1076 59 900 1282 58 nand4_x0
xsubckt_2165_or21nand_x0 53 52 1101 1228 70 815 or21nand_x0
xsubckt_2063_nor3_x0 53 52 1210 1211 1212 186 nor3_x0
xsubckt_1996_nand3_x0 53 52 1283 752 73 173 nand3_x0
xsubckt_1968_and21nor_x0 53 52 1312 1315 1317 878 and21nor_x0
xsubckt_1702_mux2_x1 53 52 1587 1589 2238 1586 mux2_x1
xsubckt_1361_nand3_x0 53 52 1920 2119 174 1249 nand3_x0
xsubckt_576_nand2_x0 53 52 394 69 70 nand2_x0
xsubckt_520_nexor2_x0 53 52 450 454 448 nexor2_x0
xsubckt_408_or21nand_x0 53 52 554 556 561 1163 or21nand_x0
xsubckt_82_inv_x0 53 52 2 859 inv_x0
xsubckt_19_inv_x0 53 52 186 1260 inv_x0
xsubckt_278_and2_x1 53 52 671 672 673 and2_x1
xsubckt_924_or2_x1 53 52 2345 14 63 or2_x1
xsubckt_954_nand2_x0 53 52 2316 2317 2326 nand2_x0
xsubckt_956_or21nand_x0 53 52 2315 2332 2329 2331 or21nand_x0
xsubckt_2421_dff_x1 53 52 100 185 21 dff_x1
xsubckt_2186_nand4_x0 53 52 1078 59 857 1282 1292 nand4_x0
xsubckt_2049_nor2_x0 53 52 1225 1231 875 nor2_x0
xsubckt_1758_and3_x1 53 52 1532 1536 1538 25 and3_x1
xsubckt_1718_and21nor_x0 53 52 1571 1574 1575 802 and21nor_x0
xsubckt_1387_nand2_x0 53 52 1894 1896 1898 nand2_x0
xsubckt_156_and2_x1 53 52 788 186 2475 and2_x1
xsubckt_665_xor2_x0 53 52 36 47 310 xor2_x0
xsubckt_814_or21nand_x0 53 52 2450 192 187 2451 or21nand_x0
xsubckt_1004_nand2_x0 53 52 2270 174 173 nand2_x0
xsubckt_2457_dff_x1 53 52 80 185 4 dff_x1
xsubckt_2316_mux2_x1 53 52 57 860 850 939 mux2_x1
xsubckt_2291_and21nor_x0 53 52 965 1005 1007 1010 and21nor_x0
xsubckt_2150_nand2_x0 53 52 1116 1117 1119 nand2_x0
xsubckt_1845_or21nand_x0 53 52 1445 1534 1493 1494 or21nand_x0
xsubckt_1443_nand2_x0 53 52 1839 1840 2237 nand2_x0
xsubckt_1395_and21nor_x0 53 52 1886 57 59 76 and21nor_x0
xsubckt_1351_nand4_x0 53 52 1929 59 29 1282 1292 nand4_x0
xsubckt_492_nand3_x0 53 52 474 475 476 568 nand3_x0
xsubckt_327_and3_x1 53 52 626 2469 2468 2467 and3_x1
xsubckt_1059_and2_x1 53 52 2216 20 174 and2_x1
xsubckt_1126_or21nand_x0 53 52 2150 2157 2179 46 or21nand_x0
xsubckt_1225_and3_x1 53 52 2053 801 878 175 and3_x1
xsubckt_1248_and2_x1 53 52 2030 2236 869 and2_x1
xsubckt_1261_and21nor_x0 53 52 2018 2041 2043 2047 and21nor_x0
xsubckt_2069_or21nand_x0 53 52 1203 1204 1216 1271 or21nand_x0
xsubckt_1613_nand2_x0 53 52 1673 1674 1676 nand2_x0
xsubckt_349_and2_x1 53 52 606 607 608 and2_x1
xsubckt_1207_and2_x1 53 52 2070 2071 1260 and2_x1
xsubckt_1270_nand3_x0 53 52 2009 2119 1239 173 nand3_x0
xsubckt_2307_mux2_x1 53 52 69 47 686 948 mux2_x1
xsubckt_2022_nand2_x0 53 52 1254 1255 1257 nand2_x0
xsubckt_1967_and2_x1 53 52 1313 1315 1317 and2_x1
xsubckt_1912_and2_x1 53 52 1373 72 174 and2_x1
xsubckt_1829_and3_x1 53 52 1462 769 44 174 and3_x1
xsubckt_1542_or21nand_x0 53 52 1742 2240 1746 1743 or21nand_x0
xsubckt_1326_or21nand_x0 53 52 1954 1958 1955 1956 or21nand_x0
xsubckt_404_and3_x1 53 52 558 769 169 174 and3_x1
xsubckt_59_inv_x0 53 52 17 882 inv_x0
xsubckt_877_xor2_x0 53 52 61 62 2389 xor2_x0
xsubckt_899_xor2_x0 53 52 2 62 2368 xor2_x0
xsubckt_1062_and2_x1 53 52 2213 2214 2217 and2_x1
xsubckt_1144_nand2_x0 53 52 2132 2242 46 nand2_x0
xsubckt_2350_or2_x1 53 52 905 906 907 or2_x1
xsubckt_2230_nand4_x0 53 52 1030 59 856 1282 1292 nand4_x0
xsubckt_1983_mux2_x1 53 52 1297 1980 2236 1296 mux2_x1
xsubckt_1966_nand3_x0 53 52 1315 801 42 175 nand3_x0
xsubckt_1290_nand3_x0 53 52 1989 1994 1998 43 nand3_x0
xsubckt_565_or2_x1 53 52 405 27 71 or2_x1
xsubckt_21_inv_x0 53 52 174 1239 inv_x0
xsubckt_201_and21nor_x0 53 52 745 748 750 1325 and21nor_x0
xsubckt_1016_nand3_x0 53 52 2258 769 876 174 nand3_x0
xsubckt_2204_nor4_x0 53 52 1059 1060 1061 1062 559 nor4_x0
xsubckt_1950_nand3_x0 53 52 1332 752 74 173 nand3_x0
xsubckt_637_nand2_x0 53 52 122 337 351 nand2_x0
xsubckt_489_nexor2_x0 53 52 73 74 477 nexor2_x0
xsubckt_242_nand2_x0 53 52 706 800 1379 nand2_x0
xsubckt_929_and21nor_x0 53 52 2340 558 2342 2341 and21nor_x0
xsubckt_2371_and21nor_x0 53 52 51 887 888 1271 and21nor_x0
xsubckt_1724_nexor2_x0 53 52 1597 34 1565 nexor2_x0
xsubckt_1460_and21nor_x0 53 52 1823 1827 1849 1852 and21nor_x0
xsubckt_571_or21nand_x0 53 52 399 407 406 400 or21nand_x0
xsubckt_504_or21nand_x0 53 52 463 557 465 464 or21nand_x0
xsubckt_52_inv_x0 53 52 47 908 inv_x0
xsubckt_246_or2_x1 53 52 702 703 704 or2_x1
xsubckt_285_mux2_x1 53 52 2472 180 777 664 mux2_x1
xsubckt_955_mux2_x1 53 52 23 2316 567 89 mux2_x1
xsubckt_1054_nand3_x0 53 52 2221 752 19 173 nand3_x0
xsubckt_1194_and21nor_x0 53 52 2083 2085 2091 787 and21nor_x0
xsubckt_2446_dff_x1 53 52 121 185 37 dff_x1
xsubckt_2208_nor2_x0 53 52 1054 1055 64 nor2_x0
xsubckt_1649_and21nor_x0 53 52 1638 1647 1650 70 and21nor_x0
xsubckt_1511_and21nor_x0 53 52 1773 812 65 173 and21nor_x0
xsubckt_1318_nand3_x0 53 52 1962 2064 1239 173 nand3_x0
xsubckt_1282_and2_x1 53 52 1997 2001 798 and2_x1
xsubckt_387_and3_x1 53 52 146 573 574 1271 and3_x1
xsubckt_726_and2_x1 53 52 253 255 567 and2_x1
xsubckt_836_or2_x1 53 52 2428 2429 2435 or2_x1
xsubckt_907_nand2_x0 53 52 2361 15 64 nand2_x0
xsubckt_1164_and3_x1 53 52 2113 2114 1239 173 and3_x1
xsubckt_2217_nexor2_x0 53 52 1055 64 1044 nexor2_x0
xsubckt_1949_nand2_x0 53 52 1333 2270 1120 nand2_x0
xsubckt_1759_nand3_x0 53 52 1531 1536 1538 25 nand3_x0
xsubckt_1680_mux2_x1 53 52 61 23 686 1608 mux2_x1
xsubckt_1302_or2_x1 53 52 1977 59 43 or2_x1
xsubckt_323_nand3_x0 53 52 629 630 631 1271 nand3_x0
xsubckt_3_inv_x0 53 52 2480 1432 inv_x0
xsubckt_973_nand2_x0 53 52 2299 11 23 nand2_x0
xsubckt_1268_nand2_x0 53 52 2011 2270 19 nand2_x0
xsubckt_2259_or21nand_x0 53 52 999 2240 1662 1000 or21nand_x0
xsubckt_110_and21nor_x0 53 52 831 2469 840 835 and21nor_x0
xsubckt_664_nand2_x0 53 52 311 36 47 nand2_x0
xsubckt_781_and21nor_x0 53 52 201 558 203 202 and21nor_x0
xsubckt_809_nexor2_x0 53 52 2455 2458 2454 nexor2_x0
xsubckt_892_nexor2_x0 53 52 2 65 2375 nexor2_x0
xsubckt_2452_dff_x1 53 52 85 185 9 dff_x1
xsubckt_2339_or21nand_x0 53 52 914 915 916 919 or21nand_x0
xsubckt_2263_or21nand_x0 53 52 995 1001 999 996 or21nand_x0
xsubckt_2184_mux2_x1 53 52 57 868 850 1080 mux2_x1
xsubckt_1792_and21nor_x0 53 52 1499 1501 1506 1522 and21nor_x0
xsubckt_1518_nand2_x0 53 52 1766 1768 798 nand2_x0
xsubckt_1421_nand3_x0 53 52 1861 752 63 173 nand3_x0
xsubckt_1385_and21nor_x0 53 52 1896 1946 1948 1951 and21nor_x0
xsubckt_1371_nand3_x0 53 52 1910 769 66 174 nand3_x0
xsubckt_632_nand2_x0 53 52 341 38 47 nand2_x0
xsubckt_554_nexor2_x0 53 52 416 419 415 nexor2_x0
xsubckt_396_and2_x1 53 52 566 1120 42 and2_x1
xsubckt_153_nand2_x0 53 52 791 810 1346 nand2_x0
xsubckt_45_inv_x0 53 52 29 981 inv_x0
xsubckt_247_nand2_x0 53 52 701 703 704 nand2_x0
xsubckt_1069_nand3_x0 53 52 2206 2210 2227 1153 nand3_x0
xsubckt_2171_and2_x1 53 52 1094 1095 798 and2_x1
xsubckt_2082_and21nor_x0 53 52 1190 1249 1191 1192 and21nor_x0
xsubckt_86_inv_x0 53 52 13 855 inv_x0
xsubckt_912_and21nor_x0 53 52 2356 558 2358 2357 and21nor_x0
xsubckt_985_and21nor_x0 53 52 2287 853 557 563 and21nor_x0
xsubckt_1029_and3_x1 53 52 2245 59 1282 1292 and3_x1
xsubckt_1048_nand3_x0 53 52 2227 801 22 175 nand3_x0
xsubckt_1133_and21nor_x0 53 52 2143 2144 2145 802 and21nor_x0
xsubckt_2221_or21nand_x0 53 52 1040 1042 1044 803 or21nand_x0
xsubckt_252_nand2_x0 53 52 696 697 705 nand2_x0
xsubckt_706_mux2_x1 53 52 273 277 568 93 mux2_x1
xsubckt_2170_or21nand_x0 53 52 1095 1103 1100 1097 or21nand_x0
xsubckt_2127_and3_x1 53 52 1141 1145 1156 66 and3_x1
xsubckt_2044_or21nand_x0 53 52 1231 1236 1233 1232 or21nand_x0
xsubckt_1891_and2_x1 53 52 1395 2242 21 and2_x1
xsubckt_1672_and21nor_x0 53 52 1615 1622 1618 1616 and21nor_x0
xsubckt_1607_and21nor_x0 53 52 1679 1683 1685 970 and21nor_x0
xsubckt_1526_or21nand_x0 53 52 1758 1822 1808 1809 or21nand_x0
xsubckt_71_inv_x0 53 52 66 870 inv_x0
xsubckt_204_or21nand_x0 53 52 742 759 764 765 or21nand_x0
xsubckt_1011_nand3_x0 53 52 2263 2265 2266 2267 nand3_x0
xsubckt_1183_and2_x1 53 52 2094 2102 45 and2_x1
xsubckt_2354_and2_x1 53 52 168 903 56 and2_x1
xsubckt_2151_or21nand_x0 53 52 1115 802 1132 1116 or21nand_x0
xsubckt_2116_and2_x1 53 52 1154 69 1239 and2_x1
xsubckt_2054_and21nor_x0 53 52 1220 1248 1266 1269 and21nor_x0
xsubckt_2039_and2_x1 53 52 1236 1237 1241 and2_x1
xsubckt_1811_or21nand_x0 53 52 1480 787 1489 1481 or21nand_x0
xsubckt_1532_and21nor_x0 53 52 1752 1805 1785 1804 and21nor_x0
xsubckt_535_or21nand_x0 53 52 433 434 435 567 or21nand_x0
xsubckt_342_nand2_x0 53 52 612 613 2479 nand2_x0
xsubckt_643_and21nor_x0 53 52 331 886 557 563 and21nor_x0
xsubckt_707_nand3_x0 53 52 272 68 878 18 nand3_x0
xsubckt_1013_nand4_x0 53 52 2261 19 175 1239 173 nand4_x0
xsubckt_1098_nand3_x0 53 52 2178 801 873 175 nand3_x0
xsubckt_2255_nand2_x0 53 52 1004 1006 1008 nand2_x0
xsubckt_1869_or21nand_x0 53 52 1419 1424 1423 1420 or21nand_x0
xsubckt_1793_or21nand_x0 53 52 1498 1500 1507 1521 or21nand_x0
xsubckt_1489_nand2_x0 53 52 1794 1795 2237 nand2_x0
xsubckt_515_or2_x1 53 52 453 71 72 or2_x1
xsubckt_361_and3_x1 53 52 595 597 598 1454 and3_x1
xsubckt_273_and21nor_x0 53 52 676 704 703 677 and21nor_x0
xsubckt_712_xor2_x0 53 52 22 16 267 xor2_x0
xsubckt_717_and2_x1 53 52 262 20 17 and2_x1
xsubckt_960_nexor2_x0 53 52 2312 2315 2311 nexor2_x0
xsubckt_978_and3_x1 53 52 2294 2295 2298 2308 and3_x1
xsubckt_1263_and3_x1 53 52 2016 2114 174 1249 and3_x1
xsubckt_2309_and2_x1 53 52 946 948 61 and2_x1
xsubckt_1516_or21nand_x0 53 52 1768 1772 1770 1769 or21nand_x0
xsubckt_638_nor2_x0 53 52 336 37 70 nor2_x0
xsubckt_427_mux2_x1 53 52 537 551 568 124 mux2_x1
xsubckt_423_xor2_x0 53 52 40 43 540 xor2_x0
xsubckt_421_nor2_x0 53 52 542 40 43 nor2_x0
xsubckt_83_inv_x0 53 52 23 858 inv_x0
xsubckt_18_inv_x0 53 52 176 1271 inv_x0
xsubckt_253_or2_x1 53 52 695 697 705 or2_x1
xsubckt_920_nor2_x0 53 52 91 2349 2363 nor2_x0
xsubckt_1177_and2_x1 53 52 2100 2102 1066 and2_x1
xsubckt_1265_nand3_x0 53 52 2014 2271 64 1228 nand3_x0
xsubckt_2376_dff_x1 53 52 165 185 77 dff_x1
xsubckt_2365_nand4_x0 53 52 893 778 848 172 50 nand4_x0
xsubckt_2198_mux2_x1 53 52 180 20 1200 1065 mux2_x1
xsubckt_2013_or21nand_x0 53 52 1264 1301 1308 1309 or21nand_x0
xsubckt_1943_and2_x1 53 52 1339 1340 787 and2_x1
xsubckt_1895_and2_x1 53 52 1391 1392 2244 and2_x1
xsubckt_1719_and21nor_x0 53 52 1570 1599 1601 1604 and21nor_x0
xsubckt_1591_nand2_x0 53 52 1694 1695 802 nand2_x0
xsubckt_488_xor2_x0 53 52 73 74 478 xor2_x0
xsubckt_315_nand3_x0 53 52 637 638 823 77 nand3_x0
xsubckt_759_nexor2_x0 53 52 223 226 222 nexor2_x0
xsubckt_979_nand3_x0 53 52 2293 2295 2298 2308 nand3_x0
xsubckt_983_or21nand_x0 53 52 2289 2315 2313 2314 or21nand_x0
xsubckt_1033_and2_x1 53 52 2241 2243 1292 and2_x1
xsubckt_1135_or21nand_x0 53 52 2141 2249 2207 2208 or21nand_x0
xsubckt_1209_nand2_x0 53 52 2068 2069 1271 nand2_x0
xsubckt_1958_nand2_x0 53 52 1323 1332 814 nand2_x0
xsubckt_1889_nexor2_x0 53 52 1399 1430 1397 nexor2_x0
xsubckt_1815_and3_x1 53 52 1477 1551 174 1249 and3_x1
xsubckt_1723_nand2_x0 53 52 1566 1567 1568 nand2_x0
xsubckt_1622_and21nor_x0 53 52 1664 2241 1668 1665 and21nor_x0
xsubckt_782_or21nand_x0 53 52 200 201 208 567 or21nand_x0
xsubckt_896_and21nor_x0 53 52 2371 2401 2398 2400 and21nor_x0
xsubckt_1028_nand2_x0 53 52 2246 59 1282 nand2_x0
xsubckt_1107_and3_x1 53 52 2169 2170 1239 173 and3_x1
xsubckt_1955_and21nor_x0 53 52 1327 770 1328 1330 and21nor_x0
xsubckt_1624_nexor2_x0 53 52 1700 855 1662 nexor2_x0
xsubckt_1313_and3_x1 53 52 1967 2167 174 1249 and3_x1
xsubckt_458_nexor2_x0 53 52 32 44 507 nexor2_x0
xsubckt_132_nand2_x0 53 52 811 813 1249 nand2_x0
xsubckt_797_nexor2_x0 53 52 188 189 2466 nexor2_x0
xsubckt_1981_nand2_x0 53 52 1298 1972 2241 nand2_x0
xsubckt_1700_nexor2_x0 53 52 1621 853 1588 nexor2_x0
xsubckt_1609_nexor2_x0 53 52 1682 71 1677 nexor2_x0
xsubckt_1592_and21nor_x0 53 52 1693 788 1709 1694 and21nor_x0
xsubckt_1398_or21nand_x0 53 52 1883 2240 1887 1884 or21nand_x0
xsubckt_1303_and21nor_x0 53 52 1976 2242 1977 1978 and21nor_x0
xsubckt_322_nand2_x0 53 52 630 632 2467 nand2_x0
xsubckt_14_inv_x0 53 52 2476 1314 inv_x0
xsubckt_671_or2_x1 53 52 120 305 352 or2_x1
xsubckt_678_and3_x1 53 52 298 299 302 312 and3_x1
xsubckt_721_nexor2_x0 53 52 16 19 258 nexor2_x0
xsubckt_1044_nand2_x0 53 52 2230 2231 2239 nand2_x0
xsubckt_2343_and21nor_x0 53 52 910 802 914 911 and21nor_x0
xsubckt_1837_and2_x1 53 52 1453 1457 22 and2_x1
xsubckt_1739_nand2_x0 53 52 1551 43 175 nand2_x0
xsubckt_1482_nexor2_x0 53 52 1802 1823 1801 nexor2_x0
xsubckt_1430_and21nor_x0 53 52 1852 1856 1870 1056 and21nor_x0
xsubckt_541_xor2_x0 53 52 70 71 428 xor2_x0
xsubckt_215_mux2_x1 53 52 2481 183 777 731 mux2_x1
xsubckt_1234_nand2_x0 53 52 2044 2048 44 nand2_x0
xsubckt_2412_dff_x1 53 52 139 185 73 dff_x1
xsubckt_2223_or21nand_x0 53 52 1038 1084 1085 1090 or21nand_x0
xsubckt_1870_and2_x1 53 52 1418 1419 1428 and2_x1
xsubckt_1692_nand3_x0 53 52 1596 1671 884 885 nand3_x0
xsubckt_1452_and2_x1 53 52 1830 1831 802 and2_x1
xsubckt_399_and3_x1 53 52 563 801 169 175 and3_x1
xsubckt_123_nand3_x0 53 52 818 823 58 77 nand3_x0
xsubckt_78_inv_x0 53 52 4 863 inv_x0
xsubckt_166_and21nor_x0 53 52 161 779 781 176 and21nor_x0
xsubckt_760_or21nand_x0 53 52 221 871 558 562 or21nand_x0
xsubckt_2402_dff_x1 53 52 141 185 49 dff_x1
xsubckt_2385_dff_x1 53 52 142 185 57 dff_x1
xsubckt_2349_and21nor_x0 53 52 906 174 769 1174 and21nor_x0
xsubckt_2342_and2_x1 53 52 911 912 803 and2_x1
xsubckt_2211_nand2_x0 53 52 1051 1055 64 nand2_x0
xsubckt_1913_mux2_x1 53 52 74 72 174 1372 mux2_x1
xsubckt_1902_and21nor_x0 53 52 1383 1478 1450 1453 and21nor_x0
xsubckt_119_nexor2_x0 53 52 824 1465 822 nexor2_x0
xsubckt_770_xor2_x0 53 52 7 67 212 xor2_x0
xsubckt_835_or21nand_x0 53 52 2429 2430 2431 567 or21nand_x0
xsubckt_1072_and21nor_x0 53 52 2203 2210 2227 48 and21nor_x0
xsubckt_1254_nand2_x0 53 52 2024 2025 2238 nand2_x0
xsubckt_2359_nand2_x0 53 52 897 54 55 nand2_x0
xsubckt_1970_and3_x1 53 52 1310 1315 1317 19 and3_x1
xsubckt_1924_nexor2_x0 53 52 1366 20 1360 nexor2_x0
xsubckt_1557_and4_x1 53 52 1728 1729 1730 1731 798 and4_x1
xsubckt_1408_nand2_x0 53 52 1873 1892 1271 nand2_x0
xsubckt_274_nand2_x0 53 52 675 676 682 nand2_x0
xsubckt_708_or21nand_x0 53 52 271 879 19 875 or21nand_x0
xsubckt_744_and21nor_x0 53 52 236 237 563 568 and21nor_x0
xsubckt_775_nor2_x0 53 52 207 7 19 nor2_x0
xsubckt_1110_mux2_x1 53 52 876 2167 2271 2166 mux2_x1
xsubckt_1245_nexor2_x0 53 52 2081 31 2033 nexor2_x0
xsubckt_1277_and3_x1 53 52 2002 769 68 174 and3_x1
xsubckt_2201_and2_x1 53 52 1062 2176 72 and2_x1
xsubckt_1925_nexor2_x0 53 52 1366 880 1359 nexor2_x0
xsubckt_1531_or21nand_x0 53 52 1753 1806 1784 1803 or21nand_x0
xsubckt_1315_nand4_x0 53 52 1965 62 175 174 173 nand4_x0
xsubckt_1287_and21nor_x0 53 52 1992 1994 1998 1120 and21nor_x0
xsubckt_57_inv_x0 53 52 35 884 inv_x0
xsubckt_217_or21nand_x0 53 52 153 176 732 730 or21nand_x0
xsubckt_1218_and3_x1 53 52 2060 2167 1239 173 and3_x1
xsubckt_2212_nor2_x0 53 52 1050 1055 866 nor2_x0
xsubckt_2200_nand3_x0 53 52 1063 801 71 175 nand3_x0
xsubckt_1749_nand2_x0 53 52 1541 45 175 nand2_x0
xsubckt_30_inv_x0 53 52 44 1142 inv_x0
xsubckt_9_inv_x0 53 52 2472 1368 inv_x0
xsubckt_262_nor3_x0 53 52 687 175 174 173 nor3_x0
xsubckt_972_and2_x1 53 52 2300 11 23 and2_x1
xsubckt_1197_nexor2_x0 53 52 2136 32 2080 nexor2_x0
xsubckt_2084_nand2_x0 53 52 1188 1190 1193 nand2_x0
xsubckt_1986_nand4_x0 53 52 1293 59 6 1282 1292 nand4_x0
xsubckt_1538_nexor2_x0 53 52 1799 900 1746 nexor2_x0
xsubckt_628_or21nand_x0 53 52 345 38 558 562 or21nand_x0
xsubckt_615_and21nor_x0 53 52 357 375 373 374 and21nor_x0
xsubckt_195_or2_x1 53 52 751 175 174 or2_x1
xsubckt_2360_and21nor_x0 53 52 896 176 1201 848 and21nor_x0
xsubckt_2162_and21nor_x0 53 52 1104 812 73 173 and21nor_x0
xsubckt_2000_nand3_x0 53 52 1278 769 1056 174 nand3_x0
xsubckt_1704_and2_x1 53 52 1584 1585 787 and2_x1
xsubckt_1678_and2_x1 53 52 1610 1611 176 and2_x1
xsubckt_555_nand2_x0 53 52 414 415 563 nand2_x0
xsubckt_102_or21nand_x0 53 52 839 841 2471 2470 or21nand_x0
xsubckt_263_or3_x1 53 52 686 175 174 173 or3_x1
xsubckt_688_or2_x1 53 52 119 289 352 or2_x1
xsubckt_919_nor2_x0 53 52 2349 2350 2356 nor2_x0
xsubckt_2426_dff_x1 53 52 95 185 67 dff_x1
xsubckt_1997_nand4_x0 53 52 1281 72 175 1239 173 nand4_x0
xsubckt_1762_nand2_x0 53 52 1528 2235 1163 nand2_x0
xsubckt_1730_nexor2_x0 53 52 1590 10 1559 nexor2_x0
xsubckt_1579_or21nand_x0 53 52 1706 39 1798 38 or21nand_x0
xsubckt_1485_nand4_x0 53 52 1798 1940 917 938 959 nand4_x0
xsubckt_895_or21nand_x0 53 52 2372 557 2374 2373 or21nand_x0
xsubckt_1136_nand3_x0 53 52 2140 2142 2148 2150 nand3_x0
xsubckt_2242_and2_x1 53 52 1018 801 71 and2_x1
xsubckt_2164_or3_x1 53 52 1102 1104 1105 1106 or3_x1
xsubckt_1873_and3_x1 53 52 1415 801 1142 175 and3_x1
xsubckt_1694_nexor2_x0 53 52 1627 884 1594 nexor2_x0
xsubckt_436_xor2_x0 53 52 45 33 528 xor2_x0
xsubckt_319_or21nand_x0 53 52 633 649 636 634 or21nand_x0
xsubckt_677_nand3_x0 53 52 299 311 323 328 nand3_x0
xsubckt_1708_or21nand_x0 53 52 1580 1633 1642 1643 or21nand_x0
xsubckt_1660_and2_x1 53 52 1627 1671 885 and2_x1
xsubckt_1519_and21nor_x0 53 52 1765 798 1768 1778 and21nor_x0
xsubckt_494_and2_x1 53 52 473 476 479 and2_x1
xsubckt_480_or21nand_x0 53 52 486 31 558 562 or21nand_x0
xsubckt_68_inv_x0 53 52 21 873 inv_x0
xsubckt_255_and3_x1 53 52 693 694 698 700 and3_x1
xsubckt_1184_nand2_x0 53 52 2093 2102 45 nand2_x0
xsubckt_2051_and2_x1 53 52 1223 1231 875 and2_x1
xsubckt_1974_and21nor_x0 53 52 1306 1356 1360 1364 and21nor_x0
xsubckt_1905_nand2_x0 53 52 1380 1381 803 nand2_x0
xsubckt_1790_and21nor_x0 53 52 1501 175 1502 1505 and21nor_x0
xsubckt_1495_nand4_x0 53 52 1788 59 917 1282 1292 nand4_x0
xsubckt_609_or21nand_x0 53 52 363 382 380 381 or21nand_x0
xsubckt_235_nand3_x0 53 52 712 713 823 77 nand3_x0
xsubckt_911_or21nand_x0 53 52 2357 15 558 562 or21nand_x0
xsubckt_986_or21nand_x0 53 52 2286 557 2288 2287 or21nand_x0
xsubckt_1130_or21nand_x0 53 52 2146 2201 2203 2204 or21nand_x0
xsubckt_2010_nexor2_x0 53 52 1273 18 1267 nexor2_x0
xsubckt_1720_or21nand_x0 53 52 1569 1600 1602 1603 or21nand_x0
xsubckt_1666_and2_x1 53 52 1621 1663 854 and2_x1
xsubckt_1654_or21nand_x0 53 52 1633 1655 1676 1680 or21nand_x0
xsubckt_1467_nand4_x0 53 52 1816 1817 1818 1819 1820 nand4_x0
xsubckt_222_and21nor_x0 53 52 725 738 743 745 and21nor_x0
xsubckt_806_nor2_x0 53 52 2457 6 66 nor2_x0
xsubckt_1216_nand2_x0 53 52 2062 2270 20 nand2_x0
xsubckt_1258_or21nand_x0 53 52 2020 2021 2027 1271 or21nand_x0
.ends cordic_cor_opt
