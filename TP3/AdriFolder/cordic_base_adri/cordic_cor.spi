* Coriolis Structural SPICE Driver
* Generated on Feb 04, 2026, 12:24
* Cell/Subckt "cordic_cor".
*
* INTERF y_p[7]
* INTERF y_p[6]
* INTERF y_p[5]
* INTERF y_p[4]
* INTERF y_p[3]
* INTERF y_p[2]
* INTERF y_p[1]
* INTERF y_p[0]
* INTERF x_p[7]
* INTERF x_p[6]
* INTERF x_p[5]
* INTERF x_p[4]
* INTERF x_p[3]
* INTERF x_p[2]
* INTERF x_p[1]
* INTERF x_p[0]
* INTERF wr_axy_p
* INTERF wok_axy_p
* INTERF vss
* INTERF vdd
* INTERF rok_nxy_p
* INTERF rd_nxy_p
* INTERF raz
* INTERF ny_p[7]
* INTERF ny_p[6]
* INTERF ny_p[5]
* INTERF ny_p[4]
* INTERF ny_p[3]
* INTERF ny_p[2]
* INTERF ny_p[1]
* INTERF ny_p[0]
* INTERF nx_p[7]
* INTERF nx_p[6]
* INTERF nx_p[5]
* INTERF nx_p[4]
* INTERF nx_p[3]
* INTERF nx_p[2]
* INTERF nx_p[1]
* INTERF nx_p[0]
* INTERF ck
* INTERF a_p[7]
* INTERF a_p[6]
* INTERF a_p[5]
* INTERF a_p[4]
* INTERF a_p[3]
* INTERF a_p[2]
* INTERF a_p[1]
* INTERF a_p[0]

* Terminal models (aka standard cells) used througout all the hierarchy.
.include and2_x1.spi
.include and21nor_x0.spi
.include and3_x1.spi
.include inv_x0.spi
.include or3_x1.spi
.include or2_x1.spi
.include or21nand_x0.spi
.include nexor2_x0.spi
.include nand2_x0.spi
.include and4_x1.spi
.include nand3_x0.spi
.include xor2_x0.spi
.include mux2_x1.spi
.include dff_x1.spi
.include nor2_x0.spi
.include nand4_x0.spi
.include nor3_x0.spi
.include nor4_x0.spi
.include or4_x1.spi

* Non-terminal models (part of the user's design hierarchy).

.subckt cordic_cor 16 17 18 19 20 21 22 23 48 49 50 51 52 53 54 55 64 65 66 67 68 69 70 74 75 76 77 78 79 80 81 82 83 84 85 86 87 88 89 186 2376 2377 2378 2379 2380 2381 2382 2383
* NET     0 = ykc[9]
* NET     1 = ykc[8]
* NET     2 = ykc[7]
* NET     3 = ykc[6]
* NET     4 = ykc[5]
* NET     5 = ykc[4]
* NET     6 = ykc[3]
* NET     7 = ykc[2]
* NET     8 = ykc[15]
* NET     9 = ykc[14]
* NET    10 = ykc[13]
* NET    11 = ykc[12]
* NET    12 = ykc[11]
* NET    13 = ykc[10]
* NET    14 = ykc[1]
* NET    15 = ykc[0]
* NET    16 = y_p[7]
* NET    17 = y_p[6]
* NET    18 = y_p[5]
* NET    19 = y_p[4]
* NET    20 = y_p[3]
* NET    21 = y_p[2]
* NET    22 = y_p[1]
* NET    23 = y_p[0]
* NET    24 = y[6]
* NET    25 = y[5]
* NET    26 = y[4]
* NET    27 = y[3]
* NET    28 = y[2]
* NET    29 = y[15]
* NET    30 = y[1]
* NET    31 = y[0]
* NET    32 = xkc[9]
* NET    33 = xkc[8]
* NET    34 = xkc[7]
* NET    35 = xkc[6]
* NET    36 = xkc[5]
* NET    37 = xkc[4]
* NET    38 = xkc[3]
* NET    39 = xkc[2]
* NET    40 = xkc[15]
* NET    41 = xkc[14]
* NET    42 = xkc[13]
* NET    43 = xkc[12]
* NET    44 = xkc[11]
* NET    45 = xkc[10]
* NET    46 = xkc[1]
* NET    47 = xkc[0]
* NET    48 = x_p[7]
* NET    49 = x_p[6]
* NET    50 = x_p[5]
* NET    51 = x_p[4]
* NET    52 = x_p[3]
* NET    53 = x_p[2]
* NET    54 = x_p[1]
* NET    55 = x_p[0]
* NET    56 = x[6]
* NET    57 = x[5]
* NET    58 = x[4]
* NET    59 = x[3]
* NET    60 = x[2]
* NET    61 = x[15]
* NET    62 = x[1]
* NET    63 = x[0]
* NET    64 = wr_axy_p
* NET    65 = wok_axy_p
* NET    66 = vss
* NET    67 = vdd
* NET    68 = rok_nxy_p
* NET    69 = rd_nxy_p
* NET    70 = raz
* NET    71 = quadrant[1]
* NET    72 = quadrant[0]
* NET    73 = place
* NET    74 = ny_p[7]
* NET    75 = ny_p[6]
* NET    76 = ny_p[5]
* NET    77 = ny_p[4]
* NET    78 = ny_p[3]
* NET    79 = ny_p[2]
* NET    80 = ny_p[1]
* NET    81 = ny_p[0]
* NET    82 = nx_p[7]
* NET    83 = nx_p[6]
* NET    84 = nx_p[5]
* NET    85 = nx_p[4]
* NET    86 = nx_p[3]
* NET    87 = nx_p[2]
* NET    88 = nx_p[1]
* NET    89 = nx_p[0]
* NET    90 = norm
* NET    91 = n_ykc[9]
* NET    92 = n_ykc[8]
* NET    93 = n_ykc[7]
* NET    94 = n_ykc[6]
* NET    95 = n_ykc[5]
* NET    96 = n_ykc[4]
* NET    97 = n_ykc[3]
* NET    98 = n_ykc[2]
* NET    99 = n_ykc[15]
* NET   100 = n_ykc[14]
* NET   101 = n_ykc[13]
* NET   102 = n_ykc[12]
* NET   103 = n_ykc[11]
* NET   104 = n_ykc[10]
* NET   105 = n_ykc[1]
* NET   106 = n_ykc[0]
* NET   107 = n_y[9]
* NET   108 = n_y[8]
* NET   109 = n_y[7]
* NET   110 = n_y[6]
* NET   111 = n_y[5]
* NET   112 = n_y[4]
* NET   113 = n_y[3]
* NET   114 = n_y[2]
* NET   115 = n_y[15]
* NET   116 = n_y[14]
* NET   117 = n_y[13]
* NET   118 = n_y[12]
* NET   119 = n_y[11]
* NET   120 = n_y[10]
* NET   121 = n_y[1]
* NET   122 = n_y[0]
* NET   123 = n_xkc[9]
* NET   124 = n_xkc[8]
* NET   125 = n_xkc[7]
* NET   126 = n_xkc[6]
* NET   127 = n_xkc[5]
* NET   128 = n_xkc[4]
* NET   129 = n_xkc[3]
* NET   130 = n_xkc[2]
* NET   131 = n_xkc[15]
* NET   132 = n_xkc[14]
* NET   133 = n_xkc[13]
* NET   134 = n_xkc[12]
* NET   135 = n_xkc[11]
* NET   136 = n_xkc[10]
* NET   137 = n_xkc[1]
* NET   138 = n_xkc[0]
* NET   139 = n_x[9]
* NET   140 = n_x[8]
* NET   141 = n_x[7]
* NET   142 = n_x[6]
* NET   143 = n_x[5]
* NET   144 = n_x[4]
* NET   145 = n_x[3]
* NET   146 = n_x[2]
* NET   147 = n_x[15]
* NET   148 = n_x[14]
* NET   149 = n_x[13]
* NET   150 = n_x[12]
* NET   151 = n_x[11]
* NET   152 = n_x[10]
* NET   153 = n_x[1]
* NET   154 = n_x[0]
* NET   155 = n_quadrant[1]
* NET   156 = n_quadrant[0]
* NET   157 = n_i[2]
* NET   158 = n_i[1]
* NET   159 = n_i[0]
* NET   160 = n_a[9]
* NET   161 = n_a[8]
* NET   162 = n_a[7]
* NET   163 = n_a[6]
* NET   164 = n_a[5]
* NET   165 = n_a[4]
* NET   166 = n_a[3]
* NET   167 = n_a[2]
* NET   168 = n_a[15]
* NET   169 = n_a[14]
* NET   170 = n_a[13]
* NET   171 = n_a[12]
* NET   172 = n_a[11]
* NET   173 = n_a[10]
* NET   174 = n_a[1]
* NET   175 = n_a[0]
* NET   176 = n0_put_0_0
* NET   177 = n0_place_0_0
* NET   178 = n0_norm_0_0
* NET   179 = n0_mkc_0_0
* NET   180 = n0_get_0_0
* NET   181 = n0_calc_0_0
* NET   182 = mkc
* NET   183 = i[2]
* NET   184 = i[1]
* NET   185 = i[0]
* NET   186 = ck
* NET   187 = calc
* NET   188 = abc_5896_new_n999
* NET   189 = abc_5896_new_n998
* NET   190 = abc_5896_new_n997
* NET   191 = abc_5896_new_n996
* NET   192 = abc_5896_new_n995
* NET   193 = abc_5896_new_n994
* NET   194 = abc_5896_new_n993
* NET   195 = abc_5896_new_n992
* NET   196 = abc_5896_new_n991
* NET   197 = abc_5896_new_n990
* NET   198 = abc_5896_new_n989
* NET   199 = abc_5896_new_n988
* NET   200 = abc_5896_new_n987
* NET   201 = abc_5896_new_n986
* NET   202 = abc_5896_new_n985
* NET   203 = abc_5896_new_n983
* NET   204 = abc_5896_new_n982
* NET   205 = abc_5896_new_n981
* NET   206 = abc_5896_new_n980
* NET   207 = abc_5896_new_n979
* NET   208 = abc_5896_new_n978
* NET   209 = abc_5896_new_n977
* NET   210 = abc_5896_new_n976
* NET   211 = abc_5896_new_n975
* NET   212 = abc_5896_new_n974
* NET   213 = abc_5896_new_n973
* NET   214 = abc_5896_new_n972
* NET   215 = abc_5896_new_n971
* NET   216 = abc_5896_new_n970
* NET   217 = abc_5896_new_n969
* NET   218 = abc_5896_new_n968
* NET   219 = abc_5896_new_n967
* NET   220 = abc_5896_new_n966
* NET   221 = abc_5896_new_n965
* NET   222 = abc_5896_new_n964
* NET   223 = abc_5896_new_n962
* NET   224 = abc_5896_new_n961
* NET   225 = abc_5896_new_n960
* NET   226 = abc_5896_new_n959
* NET   227 = abc_5896_new_n958
* NET   228 = abc_5896_new_n957
* NET   229 = abc_5896_new_n956
* NET   230 = abc_5896_new_n955
* NET   231 = abc_5896_new_n954
* NET   232 = abc_5896_new_n953
* NET   233 = abc_5896_new_n952
* NET   234 = abc_5896_new_n951
* NET   235 = abc_5896_new_n950
* NET   236 = abc_5896_new_n949
* NET   237 = abc_5896_new_n948
* NET   238 = abc_5896_new_n947
* NET   239 = abc_5896_new_n946
* NET   240 = abc_5896_new_n945
* NET   241 = abc_5896_new_n944
* NET   242 = abc_5896_new_n943
* NET   243 = abc_5896_new_n942
* NET   244 = abc_5896_new_n940
* NET   245 = abc_5896_new_n939
* NET   246 = abc_5896_new_n938
* NET   247 = abc_5896_new_n937
* NET   248 = abc_5896_new_n936
* NET   249 = abc_5896_new_n935
* NET   250 = abc_5896_new_n934
* NET   251 = abc_5896_new_n933
* NET   252 = abc_5896_new_n932
* NET   253 = abc_5896_new_n931
* NET   254 = abc_5896_new_n930
* NET   255 = abc_5896_new_n929
* NET   256 = abc_5896_new_n928
* NET   257 = abc_5896_new_n927
* NET   258 = abc_5896_new_n926
* NET   259 = abc_5896_new_n925
* NET   260 = abc_5896_new_n924
* NET   261 = abc_5896_new_n923
* NET   262 = abc_5896_new_n922
* NET   263 = abc_5896_new_n921
* NET   264 = abc_5896_new_n919
* NET   265 = abc_5896_new_n918
* NET   266 = abc_5896_new_n917
* NET   267 = abc_5896_new_n916
* NET   268 = abc_5896_new_n915
* NET   269 = abc_5896_new_n914
* NET   270 = abc_5896_new_n913
* NET   271 = abc_5896_new_n912
* NET   272 = abc_5896_new_n911
* NET   273 = abc_5896_new_n910
* NET   274 = abc_5896_new_n909
* NET   275 = abc_5896_new_n908
* NET   276 = abc_5896_new_n907
* NET   277 = abc_5896_new_n906
* NET   278 = abc_5896_new_n905
* NET   279 = abc_5896_new_n904
* NET   280 = abc_5896_new_n903
* NET   281 = abc_5896_new_n902
* NET   282 = abc_5896_new_n901
* NET   283 = abc_5896_new_n899
* NET   284 = abc_5896_new_n898
* NET   285 = abc_5896_new_n897
* NET   286 = abc_5896_new_n896
* NET   287 = abc_5896_new_n895
* NET   288 = abc_5896_new_n894
* NET   289 = abc_5896_new_n893
* NET   290 = abc_5896_new_n892
* NET   291 = abc_5896_new_n891
* NET   292 = abc_5896_new_n890
* NET   293 = abc_5896_new_n889
* NET   294 = abc_5896_new_n888
* NET   295 = abc_5896_new_n887
* NET   296 = abc_5896_new_n886
* NET   297 = abc_5896_new_n885
* NET   298 = abc_5896_new_n884
* NET   299 = abc_5896_new_n882
* NET   300 = abc_5896_new_n881
* NET   301 = abc_5896_new_n880
* NET   302 = abc_5896_new_n879
* NET   303 = abc_5896_new_n878
* NET   304 = abc_5896_new_n876
* NET   305 = abc_5896_new_n875
* NET   306 = abc_5896_new_n874
* NET   307 = abc_5896_new_n873
* NET   308 = abc_5896_new_n872
* NET   309 = abc_5896_new_n871
* NET   310 = abc_5896_new_n870
* NET   311 = abc_5896_new_n869
* NET   312 = abc_5896_new_n868
* NET   313 = abc_5896_new_n867
* NET   314 = abc_5896_new_n866
* NET   315 = abc_5896_new_n864
* NET   316 = abc_5896_new_n863
* NET   317 = abc_5896_new_n862
* NET   318 = abc_5896_new_n861
* NET   319 = abc_5896_new_n860
* NET   320 = abc_5896_new_n859
* NET   321 = abc_5896_new_n858
* NET   322 = abc_5896_new_n857
* NET   323 = abc_5896_new_n856
* NET   324 = abc_5896_new_n855
* NET   325 = abc_5896_new_n854
* NET   326 = abc_5896_new_n853
* NET   327 = abc_5896_new_n852
* NET   328 = abc_5896_new_n851
* NET   329 = abc_5896_new_n850
* NET   330 = abc_5896_new_n849
* NET   331 = abc_5896_new_n847
* NET   332 = abc_5896_new_n846
* NET   333 = abc_5896_new_n845
* NET   334 = abc_5896_new_n844
* NET   335 = abc_5896_new_n843
* NET   336 = abc_5896_new_n842
* NET   337 = abc_5896_new_n841
* NET   338 = abc_5896_new_n840
* NET   339 = abc_5896_new_n839
* NET   340 = abc_5896_new_n838
* NET   341 = abc_5896_new_n837
* NET   342 = abc_5896_new_n836
* NET   343 = abc_5896_new_n835
* NET   344 = abc_5896_new_n834
* NET   345 = abc_5896_new_n833
* NET   346 = abc_5896_new_n831
* NET   347 = abc_5896_new_n830
* NET   348 = abc_5896_new_n829
* NET   349 = abc_5896_new_n828
* NET   350 = abc_5896_new_n827
* NET   351 = abc_5896_new_n826
* NET   352 = abc_5896_new_n825
* NET   353 = abc_5896_new_n824
* NET   354 = abc_5896_new_n823
* NET   355 = abc_5896_new_n822
* NET   356 = abc_5896_new_n821
* NET   357 = abc_5896_new_n820
* NET   358 = abc_5896_new_n819
* NET   359 = abc_5896_new_n818
* NET   360 = abc_5896_new_n817
* NET   361 = abc_5896_new_n816
* NET   362 = abc_5896_new_n815
* NET   363 = abc_5896_new_n813
* NET   364 = abc_5896_new_n812
* NET   365 = abc_5896_new_n811
* NET   366 = abc_5896_new_n810
* NET   367 = abc_5896_new_n809
* NET   368 = abc_5896_new_n808
* NET   369 = abc_5896_new_n807
* NET   370 = abc_5896_new_n806
* NET   371 = abc_5896_new_n805
* NET   372 = abc_5896_new_n804
* NET   373 = abc_5896_new_n803
* NET   374 = abc_5896_new_n802
* NET   375 = abc_5896_new_n801
* NET   376 = abc_5896_new_n800
* NET   377 = abc_5896_new_n799
* NET   378 = abc_5896_new_n798
* NET   379 = abc_5896_new_n796
* NET   380 = abc_5896_new_n795
* NET   381 = abc_5896_new_n794
* NET   382 = abc_5896_new_n793
* NET   383 = abc_5896_new_n792
* NET   384 = abc_5896_new_n791
* NET   385 = abc_5896_new_n790
* NET   386 = abc_5896_new_n789
* NET   387 = abc_5896_new_n788
* NET   388 = abc_5896_new_n787
* NET   389 = abc_5896_new_n786
* NET   390 = abc_5896_new_n785
* NET   391 = abc_5896_new_n784
* NET   392 = abc_5896_new_n783
* NET   393 = abc_5896_new_n782
* NET   394 = abc_5896_new_n781
* NET   395 = abc_5896_new_n780
* NET   396 = abc_5896_new_n778
* NET   397 = abc_5896_new_n777
* NET   398 = abc_5896_new_n776
* NET   399 = abc_5896_new_n775
* NET   400 = abc_5896_new_n774
* NET   401 = abc_5896_new_n773
* NET   402 = abc_5896_new_n772
* NET   403 = abc_5896_new_n771
* NET   404 = abc_5896_new_n770
* NET   405 = abc_5896_new_n769
* NET   406 = abc_5896_new_n768
* NET   407 = abc_5896_new_n767
* NET   408 = abc_5896_new_n766
* NET   409 = abc_5896_new_n765
* NET   410 = abc_5896_new_n764
* NET   411 = abc_5896_new_n763
* NET   412 = abc_5896_new_n762
* NET   413 = abc_5896_new_n761
* NET   414 = abc_5896_new_n759
* NET   415 = abc_5896_new_n758
* NET   416 = abc_5896_new_n757
* NET   417 = abc_5896_new_n756
* NET   418 = abc_5896_new_n755
* NET   419 = abc_5896_new_n754
* NET   420 = abc_5896_new_n753
* NET   421 = abc_5896_new_n752
* NET   422 = abc_5896_new_n751
* NET   423 = abc_5896_new_n750
* NET   424 = abc_5896_new_n749
* NET   425 = abc_5896_new_n748
* NET   426 = abc_5896_new_n747
* NET   427 = abc_5896_new_n746
* NET   428 = abc_5896_new_n745
* NET   429 = abc_5896_new_n744
* NET   430 = abc_5896_new_n743
* NET   431 = abc_5896_new_n742
* NET   432 = abc_5896_new_n741
* NET   433 = abc_5896_new_n740
* NET   434 = abc_5896_new_n739
* NET   435 = abc_5896_new_n738
* NET   436 = abc_5896_new_n737
* NET   437 = abc_5896_new_n735
* NET   438 = abc_5896_new_n734
* NET   439 = abc_5896_new_n733
* NET   440 = abc_5896_new_n732
* NET   441 = abc_5896_new_n731
* NET   442 = abc_5896_new_n730
* NET   443 = abc_5896_new_n729
* NET   444 = abc_5896_new_n728
* NET   445 = abc_5896_new_n727
* NET   446 = abc_5896_new_n726
* NET   447 = abc_5896_new_n725
* NET   448 = abc_5896_new_n724
* NET   449 = abc_5896_new_n723
* NET   450 = abc_5896_new_n722
* NET   451 = abc_5896_new_n721
* NET   452 = abc_5896_new_n720
* NET   453 = abc_5896_new_n719
* NET   454 = abc_5896_new_n718
* NET   455 = abc_5896_new_n717
* NET   456 = abc_5896_new_n715
* NET   457 = abc_5896_new_n714
* NET   458 = abc_5896_new_n713
* NET   459 = abc_5896_new_n712
* NET   460 = abc_5896_new_n711
* NET   461 = abc_5896_new_n710
* NET   462 = abc_5896_new_n709
* NET   463 = abc_5896_new_n708
* NET   464 = abc_5896_new_n707
* NET   465 = abc_5896_new_n706
* NET   466 = abc_5896_new_n705
* NET   467 = abc_5896_new_n704
* NET   468 = abc_5896_new_n703
* NET   469 = abc_5896_new_n702
* NET   470 = abc_5896_new_n701
* NET   471 = abc_5896_new_n700
* NET   472 = abc_5896_new_n699
* NET   473 = abc_5896_new_n698
* NET   474 = abc_5896_new_n697
* NET   475 = abc_5896_new_n696
* NET   476 = abc_5896_new_n695
* NET   477 = abc_5896_new_n694
* NET   478 = abc_5896_new_n693
* NET   479 = abc_5896_new_n691
* NET   480 = abc_5896_new_n690
* NET   481 = abc_5896_new_n689
* NET   482 = abc_5896_new_n688
* NET   483 = abc_5896_new_n687
* NET   484 = abc_5896_new_n686
* NET   485 = abc_5896_new_n685
* NET   486 = abc_5896_new_n684
* NET   487 = abc_5896_new_n683
* NET   488 = abc_5896_new_n682
* NET   489 = abc_5896_new_n681
* NET   490 = abc_5896_new_n680
* NET   491 = abc_5896_new_n679
* NET   492 = abc_5896_new_n678
* NET   493 = abc_5896_new_n677
* NET   494 = abc_5896_new_n676
* NET   495 = abc_5896_new_n675
* NET   496 = abc_5896_new_n674
* NET   497 = abc_5896_new_n673
* NET   498 = abc_5896_new_n671
* NET   499 = abc_5896_new_n670
* NET   500 = abc_5896_new_n669
* NET   501 = abc_5896_new_n668
* NET   502 = abc_5896_new_n667
* NET   503 = abc_5896_new_n666
* NET   504 = abc_5896_new_n665
* NET   505 = abc_5896_new_n664
* NET   506 = abc_5896_new_n663
* NET   507 = abc_5896_new_n662
* NET   508 = abc_5896_new_n661
* NET   509 = abc_5896_new_n660
* NET   510 = abc_5896_new_n659
* NET   511 = abc_5896_new_n658
* NET   512 = abc_5896_new_n657
* NET   513 = abc_5896_new_n656
* NET   514 = abc_5896_new_n655
* NET   515 = abc_5896_new_n654
* NET   516 = abc_5896_new_n653
* NET   517 = abc_5896_new_n652
* NET   518 = abc_5896_new_n651
* NET   519 = abc_5896_new_n649
* NET   520 = abc_5896_new_n648
* NET   521 = abc_5896_new_n647
* NET   522 = abc_5896_new_n646
* NET   523 = abc_5896_new_n645
* NET   524 = abc_5896_new_n644
* NET   525 = abc_5896_new_n643
* NET   526 = abc_5896_new_n642
* NET   527 = abc_5896_new_n641
* NET   528 = abc_5896_new_n640
* NET   529 = abc_5896_new_n639
* NET   530 = abc_5896_new_n638
* NET   531 = abc_5896_new_n637
* NET   532 = abc_5896_new_n636
* NET   533 = abc_5896_new_n635
* NET   534 = abc_5896_new_n634
* NET   535 = abc_5896_new_n633
* NET   536 = abc_5896_new_n632
* NET   537 = abc_5896_new_n631
* NET   538 = abc_5896_new_n630
* NET   539 = abc_5896_new_n628
* NET   540 = abc_5896_new_n627
* NET   541 = abc_5896_new_n626
* NET   542 = abc_5896_new_n625
* NET   543 = abc_5896_new_n624
* NET   544 = abc_5896_new_n623
* NET   545 = abc_5896_new_n622
* NET   546 = abc_5896_new_n621
* NET   547 = abc_5896_new_n620
* NET   548 = abc_5896_new_n619
* NET   549 = abc_5896_new_n618
* NET   550 = abc_5896_new_n617
* NET   551 = abc_5896_new_n616
* NET   552 = abc_5896_new_n615
* NET   553 = abc_5896_new_n614
* NET   554 = abc_5896_new_n613
* NET   555 = abc_5896_new_n612
* NET   556 = abc_5896_new_n611
* NET   557 = abc_5896_new_n610
* NET   558 = abc_5896_new_n608
* NET   559 = abc_5896_new_n607
* NET   560 = abc_5896_new_n606
* NET   561 = abc_5896_new_n605
* NET   562 = abc_5896_new_n604
* NET   563 = abc_5896_new_n603
* NET   564 = abc_5896_new_n602
* NET   565 = abc_5896_new_n601
* NET   566 = abc_5896_new_n600
* NET   567 = abc_5896_new_n599
* NET   568 = abc_5896_new_n598
* NET   569 = abc_5896_new_n597
* NET   570 = abc_5896_new_n596
* NET   571 = abc_5896_new_n595
* NET   572 = abc_5896_new_n594
* NET   573 = abc_5896_new_n592
* NET   574 = abc_5896_new_n591
* NET   575 = abc_5896_new_n590
* NET   576 = abc_5896_new_n589
* NET   577 = abc_5896_new_n588
* NET   578 = abc_5896_new_n587
* NET   579 = abc_5896_new_n586
* NET   580 = abc_5896_new_n585
* NET   581 = abc_5896_new_n584
* NET   582 = abc_5896_new_n583
* NET   583 = abc_5896_new_n582
* NET   584 = abc_5896_new_n581
* NET   585 = abc_5896_new_n580
* NET   586 = abc_5896_new_n579
* NET   587 = abc_5896_new_n578
* NET   588 = abc_5896_new_n576
* NET   589 = abc_5896_new_n575
* NET   590 = abc_5896_new_n573
* NET   591 = abc_5896_new_n572
* NET   592 = abc_5896_new_n570
* NET   593 = abc_5896_new_n569
* NET   594 = abc_5896_new_n568
* NET   595 = abc_5896_new_n566
* NET   596 = abc_5896_new_n565
* NET   597 = abc_5896_new_n564
* NET   598 = abc_5896_new_n562
* NET   599 = abc_5896_new_n561
* NET   600 = abc_5896_new_n560
* NET   601 = abc_5896_new_n559
* NET   602 = abc_5896_new_n558
* NET   603 = abc_5896_new_n557
* NET   604 = abc_5896_new_n556
* NET   605 = abc_5896_new_n555
* NET   606 = abc_5896_new_n553
* NET   607 = abc_5896_new_n552
* NET   608 = abc_5896_new_n551
* NET   609 = abc_5896_new_n550
* NET   610 = abc_5896_new_n549
* NET   611 = abc_5896_new_n548
* NET   612 = abc_5896_new_n547
* NET   613 = abc_5896_new_n546
* NET   614 = abc_5896_new_n545
* NET   615 = abc_5896_new_n543
* NET   616 = abc_5896_new_n542
* NET   617 = abc_5896_new_n541
* NET   618 = abc_5896_new_n540
* NET   619 = abc_5896_new_n539
* NET   620 = abc_5896_new_n538
* NET   621 = abc_5896_new_n537
* NET   622 = abc_5896_new_n536
* NET   623 = abc_5896_new_n535
* NET   624 = abc_5896_new_n534
* NET   625 = abc_5896_new_n532
* NET   626 = abc_5896_new_n531
* NET   627 = abc_5896_new_n530
* NET   628 = abc_5896_new_n529
* NET   629 = abc_5896_new_n528
* NET   630 = abc_5896_new_n527
* NET   631 = abc_5896_new_n525
* NET   632 = abc_5896_new_n524
* NET   633 = abc_5896_new_n523
* NET   634 = abc_5896_new_n522
* NET   635 = abc_5896_new_n521
* NET   636 = abc_5896_new_n520
* NET   637 = abc_5896_new_n519
* NET   638 = abc_5896_new_n518
* NET   639 = abc_5896_new_n517
* NET   640 = abc_5896_new_n516
* NET   641 = abc_5896_new_n515
* NET   642 = abc_5896_new_n513
* NET   643 = abc_5896_new_n512
* NET   644 = abc_5896_new_n511
* NET   645 = abc_5896_new_n510
* NET   646 = abc_5896_new_n509
* NET   647 = abc_5896_new_n508
* NET   648 = abc_5896_new_n507
* NET   649 = abc_5896_new_n506
* NET   650 = abc_5896_new_n505
* NET   651 = abc_5896_new_n503
* NET   652 = abc_5896_new_n502
* NET   653 = abc_5896_new_n501
* NET   654 = abc_5896_new_n500
* NET   655 = abc_5896_new_n499
* NET   656 = abc_5896_new_n498
* NET   657 = abc_5896_new_n497
* NET   658 = abc_5896_new_n495
* NET   659 = abc_5896_new_n494
* NET   660 = abc_5896_new_n493
* NET   661 = abc_5896_new_n492
* NET   662 = abc_5896_new_n491
* NET   663 = abc_5896_new_n489
* NET   664 = abc_5896_new_n488
* NET   665 = abc_5896_new_n487
* NET   666 = abc_5896_new_n486
* NET   667 = abc_5896_new_n485
* NET   668 = abc_5896_new_n484
* NET   669 = abc_5896_new_n483
* NET   670 = abc_5896_new_n482
* NET   671 = abc_5896_new_n481
* NET   672 = abc_5896_new_n480
* NET   673 = abc_5896_new_n479
* NET   674 = abc_5896_new_n478
* NET   675 = abc_5896_new_n477
* NET   676 = abc_5896_new_n476
* NET   677 = abc_5896_new_n475
* NET   678 = abc_5896_new_n474
* NET   679 = abc_5896_new_n473
* NET   680 = abc_5896_new_n472
* NET   681 = abc_5896_new_n471
* NET   682 = abc_5896_new_n470
* NET   683 = abc_5896_new_n469
* NET   684 = abc_5896_new_n468
* NET   685 = abc_5896_new_n466
* NET   686 = abc_5896_new_n465
* NET   687 = abc_5896_new_n464
* NET   688 = abc_5896_new_n463
* NET   689 = abc_5896_new_n462
* NET   690 = abc_5896_new_n461
* NET   691 = abc_5896_new_n460
* NET   692 = abc_5896_new_n459
* NET   693 = abc_5896_new_n458
* NET   694 = abc_5896_new_n457
* NET   695 = abc_5896_new_n456
* NET   696 = abc_5896_new_n455
* NET   697 = abc_5896_new_n454
* NET   698 = abc_5896_new_n453
* NET   699 = abc_5896_new_n452
* NET   700 = abc_5896_new_n451
* NET   701 = abc_5896_new_n450
* NET   702 = abc_5896_new_n449
* NET   703 = abc_5896_new_n448
* NET   704 = abc_5896_new_n446
* NET   705 = abc_5896_new_n445
* NET   706 = abc_5896_new_n444
* NET   707 = abc_5896_new_n443
* NET   708 = abc_5896_new_n442
* NET   709 = abc_5896_new_n441
* NET   710 = abc_5896_new_n440
* NET   711 = abc_5896_new_n439
* NET   712 = abc_5896_new_n438
* NET   713 = abc_5896_new_n437
* NET   714 = abc_5896_new_n436
* NET   715 = abc_5896_new_n435
* NET   716 = abc_5896_new_n434
* NET   717 = abc_5896_new_n433
* NET   718 = abc_5896_new_n432
* NET   719 = abc_5896_new_n431
* NET   720 = abc_5896_new_n430
* NET   721 = abc_5896_new_n429
* NET   722 = abc_5896_new_n428
* NET   723 = abc_5896_new_n426
* NET   724 = abc_5896_new_n425
* NET   725 = abc_5896_new_n424
* NET   726 = abc_5896_new_n423
* NET   727 = abc_5896_new_n422
* NET   728 = abc_5896_new_n421
* NET   729 = abc_5896_new_n420
* NET   730 = abc_5896_new_n419
* NET   731 = abc_5896_new_n418
* NET   732 = abc_5896_new_n417
* NET   733 = abc_5896_new_n416
* NET   734 = abc_5896_new_n415
* NET   735 = abc_5896_new_n414
* NET   736 = abc_5896_new_n413
* NET   737 = abc_5896_new_n412
* NET   738 = abc_5896_new_n411
* NET   739 = abc_5896_new_n410
* NET   740 = abc_5896_new_n409
* NET   741 = abc_5896_new_n408
* NET   742 = abc_5896_new_n407
* NET   743 = abc_5896_new_n406
* NET   744 = abc_5896_new_n405
* NET   745 = abc_5896_new_n404
* NET   746 = abc_5896_new_n403
* NET   747 = abc_5896_new_n402
* NET   748 = abc_5896_new_n401
* NET   749 = abc_5896_new_n399
* NET   750 = abc_5896_new_n398
* NET   751 = abc_5896_new_n397
* NET   752 = abc_5896_new_n396
* NET   753 = abc_5896_new_n395
* NET   754 = abc_5896_new_n394
* NET   755 = abc_5896_new_n393
* NET   756 = abc_5896_new_n392
* NET   757 = abc_5896_new_n391
* NET   758 = abc_5896_new_n390
* NET   759 = abc_5896_new_n389
* NET   760 = abc_5896_new_n388
* NET   761 = abc_5896_new_n387
* NET   762 = abc_5896_new_n386
* NET   763 = abc_5896_new_n385
* NET   764 = abc_5896_new_n384
* NET   765 = abc_5896_new_n383
* NET   766 = abc_5896_new_n382
* NET   767 = abc_5896_new_n381
* NET   768 = abc_5896_new_n380
* NET   769 = abc_5896_new_n379
* NET   770 = abc_5896_new_n378
* NET   771 = abc_5896_new_n377
* NET   772 = abc_5896_new_n375
* NET   773 = abc_5896_new_n374
* NET   774 = abc_5896_new_n373
* NET   775 = abc_5896_new_n372
* NET   776 = abc_5896_new_n371
* NET   777 = abc_5896_new_n370
* NET   778 = abc_5896_new_n369
* NET   779 = abc_5896_new_n368
* NET   780 = abc_5896_new_n367
* NET   781 = abc_5896_new_n366
* NET   782 = abc_5896_new_n365
* NET   783 = abc_5896_new_n364
* NET   784 = abc_5896_new_n363
* NET   785 = abc_5896_new_n362
* NET   786 = abc_5896_new_n361
* NET   787 = abc_5896_new_n360
* NET   788 = abc_5896_new_n359
* NET   789 = abc_5896_new_n358
* NET   790 = abc_5896_new_n357
* NET   791 = abc_5896_new_n356
* NET   792 = abc_5896_new_n355
* NET   793 = abc_5896_new_n354
* NET   794 = abc_5896_new_n353
* NET   795 = abc_5896_new_n352
* NET   796 = abc_5896_new_n351
* NET   797 = abc_5896_new_n350
* NET   798 = abc_5896_new_n349
* NET   799 = abc_5896_new_n347
* NET   800 = abc_5896_new_n346
* NET   801 = abc_5896_new_n345
* NET   802 = abc_5896_new_n344
* NET   803 = abc_5896_new_n343
* NET   804 = abc_5896_new_n342
* NET   805 = abc_5896_new_n341
* NET   806 = abc_5896_new_n340
* NET   807 = abc_5896_new_n339
* NET   808 = abc_5896_new_n338
* NET   809 = abc_5896_new_n336
* NET   810 = abc_5896_new_n334
* NET   811 = abc_5896_new_n333
* NET   812 = abc_5896_new_n332
* NET   813 = abc_5896_new_n331
* NET   814 = abc_5896_new_n330
* NET   815 = abc_5896_new_n329
* NET   816 = abc_5896_new_n328
* NET   817 = abc_5896_new_n327
* NET   818 = abc_5896_new_n326
* NET   819 = abc_5896_new_n325
* NET   820 = abc_5896_new_n324
* NET   821 = abc_5896_new_n323
* NET   822 = abc_5896_new_n322
* NET   823 = abc_5896_new_n321
* NET   824 = abc_5896_new_n320
* NET   825 = abc_5896_new_n319
* NET   826 = abc_5896_new_n318
* NET   827 = abc_5896_new_n317
* NET   828 = abc_5896_new_n316
* NET   829 = abc_5896_new_n315
* NET   830 = abc_5896_new_n314
* NET   831 = abc_5896_new_n313
* NET   832 = abc_5896_new_n312
* NET   833 = abc_5896_new_n311
* NET   834 = abc_5896_new_n310
* NET   835 = abc_5896_new_n309
* NET   836 = abc_5896_new_n308
* NET   837 = abc_5896_new_n307
* NET   838 = abc_5896_new_n306
* NET   839 = abc_5896_new_n305
* NET   840 = abc_5896_new_n304
* NET   841 = abc_5896_new_n303
* NET   842 = abc_5896_new_n302
* NET   843 = abc_5896_new_n301
* NET   844 = abc_5896_new_n300
* NET   845 = abc_5896_new_n299
* NET   846 = abc_5896_new_n298
* NET   847 = abc_5896_new_n297
* NET   848 = abc_5896_new_n296
* NET   849 = abc_5896_new_n295
* NET   850 = abc_5896_new_n294
* NET   851 = abc_5896_new_n293
* NET   852 = abc_5896_new_n292
* NET   853 = abc_5896_new_n291
* NET   854 = abc_5896_new_n290
* NET   855 = abc_5896_new_n289
* NET   856 = abc_5896_new_n288
* NET   857 = abc_5896_new_n287
* NET   858 = abc_5896_new_n286
* NET   859 = abc_5896_new_n285
* NET   860 = abc_5896_new_n284
* NET   861 = abc_5896_new_n283
* NET   862 = abc_5896_new_n282
* NET   863 = abc_5896_new_n281
* NET   864 = abc_5896_new_n280
* NET   865 = abc_5896_new_n279
* NET   866 = abc_5896_new_n278
* NET   867 = abc_5896_new_n277
* NET   868 = abc_5896_new_n276
* NET   869 = abc_5896_new_n275
* NET   870 = abc_5896_new_n274
* NET   871 = abc_5896_new_n273
* NET   872 = abc_5896_new_n272
* NET   873 = abc_5896_new_n271
* NET   874 = abc_5896_new_n270
* NET   875 = abc_5896_new_n269
* NET   876 = abc_5896_new_n268
* NET   877 = abc_5896_new_n267
* NET   878 = abc_5896_new_n266
* NET   879 = abc_5896_new_n265
* NET   880 = abc_5896_new_n264
* NET   881 = abc_5896_new_n263
* NET   882 = abc_5896_new_n262
* NET   883 = abc_5896_new_n261
* NET   884 = abc_5896_new_n260
* NET   885 = abc_5896_new_n259
* NET   886 = abc_5896_new_n258
* NET   887 = abc_5896_new_n257
* NET   888 = abc_5896_new_n256
* NET   889 = abc_5896_new_n255
* NET   890 = abc_5896_new_n254
* NET   891 = abc_5896_new_n253
* NET   892 = abc_5896_new_n252
* NET   893 = abc_5896_new_n251
* NET   894 = abc_5896_new_n250
* NET   895 = abc_5896_new_n249
* NET   896 = abc_5896_new_n2487
* NET   897 = abc_5896_new_n2485
* NET   898 = abc_5896_new_n2484
* NET   899 = abc_5896_new_n2483
* NET   900 = abc_5896_new_n2481
* NET   901 = abc_5896_new_n2480
* NET   902 = abc_5896_new_n248
* NET   903 = abc_5896_new_n2478
* NET   904 = abc_5896_new_n2477
* NET   905 = abc_5896_new_n2476
* NET   906 = abc_5896_new_n2473
* NET   907 = abc_5896_new_n2471
* NET   908 = abc_5896_new_n2470
* NET   909 = abc_5896_new_n247
* NET   910 = abc_5896_new_n2469
* NET   911 = abc_5896_new_n2468
* NET   912 = abc_5896_new_n2467
* NET   913 = abc_5896_new_n2466
* NET   914 = abc_5896_new_n2465
* NET   915 = abc_5896_new_n2464
* NET   916 = abc_5896_new_n2463
* NET   917 = abc_5896_new_n2462
* NET   918 = abc_5896_new_n2461
* NET   919 = abc_5896_new_n2460
* NET   920 = abc_5896_new_n246
* NET   921 = abc_5896_new_n2459
* NET   922 = abc_5896_new_n2458
* NET   923 = abc_5896_new_n2457
* NET   924 = abc_5896_new_n2456
* NET   925 = abc_5896_new_n2455
* NET   926 = abc_5896_new_n2453
* NET   927 = abc_5896_new_n2452
* NET   928 = abc_5896_new_n2451
* NET   929 = abc_5896_new_n2450
* NET   930 = abc_5896_new_n245
* NET   931 = abc_5896_new_n2449
* NET   932 = abc_5896_new_n2448
* NET   933 = abc_5896_new_n2447
* NET   934 = abc_5896_new_n2446
* NET   935 = abc_5896_new_n2445
* NET   936 = abc_5896_new_n2444
* NET   937 = abc_5896_new_n2443
* NET   938 = abc_5896_new_n2442
* NET   939 = abc_5896_new_n2441
* NET   940 = abc_5896_new_n2440
* NET   941 = abc_5896_new_n244
* NET   942 = abc_5896_new_n2439
* NET   943 = abc_5896_new_n2438
* NET   944 = abc_5896_new_n2437
* NET   945 = abc_5896_new_n2436
* NET   946 = abc_5896_new_n2435
* NET   947 = abc_5896_new_n2434
* NET   948 = abc_5896_new_n2433
* NET   949 = abc_5896_new_n2432
* NET   950 = abc_5896_new_n2431
* NET   951 = abc_5896_new_n243
* NET   952 = abc_5896_new_n2429
* NET   953 = abc_5896_new_n2428
* NET   954 = abc_5896_new_n2427
* NET   955 = abc_5896_new_n2426
* NET   956 = abc_5896_new_n2425
* NET   957 = abc_5896_new_n2424
* NET   958 = abc_5896_new_n2423
* NET   959 = abc_5896_new_n2422
* NET   960 = abc_5896_new_n2421
* NET   961 = abc_5896_new_n2420
* NET   962 = abc_5896_new_n242
* NET   963 = abc_5896_new_n2419
* NET   964 = abc_5896_new_n2418
* NET   965 = abc_5896_new_n2417
* NET   966 = abc_5896_new_n2416
* NET   967 = abc_5896_new_n2415
* NET   968 = abc_5896_new_n2414
* NET   969 = abc_5896_new_n2413
* NET   970 = abc_5896_new_n2412
* NET   971 = abc_5896_new_n2411
* NET   972 = abc_5896_new_n2410
* NET   973 = abc_5896_new_n241
* NET   974 = abc_5896_new_n2409
* NET   975 = abc_5896_new_n2408
* NET   976 = abc_5896_new_n2407
* NET   977 = abc_5896_new_n2406
* NET   978 = abc_5896_new_n2405
* NET   979 = abc_5896_new_n2404
* NET   980 = abc_5896_new_n2403
* NET   981 = abc_5896_new_n2402
* NET   982 = abc_5896_new_n2401
* NET   983 = abc_5896_new_n240
* NET   984 = abc_5896_new_n2399
* NET   985 = abc_5896_new_n2398
* NET   986 = abc_5896_new_n2397
* NET   987 = abc_5896_new_n2396
* NET   988 = abc_5896_new_n2395
* NET   989 = abc_5896_new_n2394
* NET   990 = abc_5896_new_n2393
* NET   991 = abc_5896_new_n2392
* NET   992 = abc_5896_new_n2391
* NET   993 = abc_5896_new_n2390
* NET   994 = abc_5896_new_n239
* NET   995 = abc_5896_new_n2389
* NET   996 = abc_5896_new_n2388
* NET   997 = abc_5896_new_n2387
* NET   998 = abc_5896_new_n2386
* NET   999 = abc_5896_new_n2385
* NET  1000 = abc_5896_new_n2384
* NET  1001 = abc_5896_new_n2383
* NET  1002 = abc_5896_new_n2382
* NET  1003 = abc_5896_new_n2381
* NET  1004 = abc_5896_new_n2380
* NET  1005 = abc_5896_new_n238
* NET  1006 = abc_5896_new_n2379
* NET  1007 = abc_5896_new_n2378
* NET  1008 = abc_5896_new_n2377
* NET  1009 = abc_5896_new_n2376
* NET  1010 = abc_5896_new_n2375
* NET  1011 = abc_5896_new_n2374
* NET  1012 = abc_5896_new_n2373
* NET  1013 = abc_5896_new_n2372
* NET  1014 = abc_5896_new_n2371
* NET  1015 = abc_5896_new_n237
* NET  1016 = abc_5896_new_n2369
* NET  1017 = abc_5896_new_n2368
* NET  1018 = abc_5896_new_n2367
* NET  1019 = abc_5896_new_n2366
* NET  1020 = abc_5896_new_n2365
* NET  1021 = abc_5896_new_n2364
* NET  1022 = abc_5896_new_n2363
* NET  1023 = abc_5896_new_n2362
* NET  1024 = abc_5896_new_n2361
* NET  1025 = abc_5896_new_n2360
* NET  1026 = abc_5896_new_n236
* NET  1027 = abc_5896_new_n2359
* NET  1028 = abc_5896_new_n2358
* NET  1029 = abc_5896_new_n2357
* NET  1030 = abc_5896_new_n2356
* NET  1031 = abc_5896_new_n2355
* NET  1032 = abc_5896_new_n2354
* NET  1033 = abc_5896_new_n2353
* NET  1034 = abc_5896_new_n2352
* NET  1035 = abc_5896_new_n2351
* NET  1036 = abc_5896_new_n2350
* NET  1037 = abc_5896_new_n235
* NET  1038 = abc_5896_new_n2349
* NET  1039 = abc_5896_new_n2348
* NET  1040 = abc_5896_new_n2347
* NET  1041 = abc_5896_new_n2346
* NET  1042 = abc_5896_new_n2345
* NET  1043 = abc_5896_new_n2344
* NET  1044 = abc_5896_new_n2343
* NET  1045 = abc_5896_new_n2342
* NET  1046 = abc_5896_new_n2341
* NET  1047 = abc_5896_new_n2340
* NET  1048 = abc_5896_new_n234
* NET  1049 = abc_5896_new_n2339
* NET  1050 = abc_5896_new_n2338
* NET  1051 = abc_5896_new_n2336
* NET  1052 = abc_5896_new_n2335
* NET  1053 = abc_5896_new_n2334
* NET  1054 = abc_5896_new_n2333
* NET  1055 = abc_5896_new_n2332
* NET  1056 = abc_5896_new_n2331
* NET  1057 = abc_5896_new_n2330
* NET  1058 = abc_5896_new_n233
* NET  1059 = abc_5896_new_n2329
* NET  1060 = abc_5896_new_n2328
* NET  1061 = abc_5896_new_n2327
* NET  1062 = abc_5896_new_n2326
* NET  1063 = abc_5896_new_n2325
* NET  1064 = abc_5896_new_n2324
* NET  1065 = abc_5896_new_n2323
* NET  1066 = abc_5896_new_n2322
* NET  1067 = abc_5896_new_n2321
* NET  1068 = abc_5896_new_n2320
* NET  1069 = abc_5896_new_n232
* NET  1070 = abc_5896_new_n2319
* NET  1071 = abc_5896_new_n2318
* NET  1072 = abc_5896_new_n2317
* NET  1073 = abc_5896_new_n2316
* NET  1074 = abc_5896_new_n2315
* NET  1075 = abc_5896_new_n2314
* NET  1076 = abc_5896_new_n2313
* NET  1077 = abc_5896_new_n2312
* NET  1078 = abc_5896_new_n2311
* NET  1079 = abc_5896_new_n2310
* NET  1080 = abc_5896_new_n231
* NET  1081 = abc_5896_new_n2309
* NET  1082 = abc_5896_new_n2308
* NET  1083 = abc_5896_new_n2307
* NET  1084 = abc_5896_new_n2306
* NET  1085 = abc_5896_new_n2305
* NET  1086 = abc_5896_new_n2304
* NET  1087 = abc_5896_new_n2303
* NET  1088 = abc_5896_new_n2302
* NET  1089 = abc_5896_new_n2301
* NET  1090 = abc_5896_new_n2300
* NET  1091 = abc_5896_new_n230
* NET  1092 = abc_5896_new_n2299
* NET  1093 = abc_5896_new_n2297
* NET  1094 = abc_5896_new_n2296
* NET  1095 = abc_5896_new_n2295
* NET  1096 = abc_5896_new_n2294
* NET  1097 = abc_5896_new_n2293
* NET  1098 = abc_5896_new_n2292
* NET  1099 = abc_5896_new_n2291
* NET  1100 = abc_5896_new_n2290
* NET  1101 = abc_5896_new_n229
* NET  1102 = abc_5896_new_n2289
* NET  1103 = abc_5896_new_n2288
* NET  1104 = abc_5896_new_n2287
* NET  1105 = abc_5896_new_n2286
* NET  1106 = abc_5896_new_n2285
* NET  1107 = abc_5896_new_n2284
* NET  1108 = abc_5896_new_n2283
* NET  1109 = abc_5896_new_n2282
* NET  1110 = abc_5896_new_n2281
* NET  1111 = abc_5896_new_n2280
* NET  1112 = abc_5896_new_n228
* NET  1113 = abc_5896_new_n2279
* NET  1114 = abc_5896_new_n2278
* NET  1115 = abc_5896_new_n2277
* NET  1116 = abc_5896_new_n2276
* NET  1117 = abc_5896_new_n2275
* NET  1118 = abc_5896_new_n2274
* NET  1119 = abc_5896_new_n2273
* NET  1120 = abc_5896_new_n2272
* NET  1121 = abc_5896_new_n2271
* NET  1122 = abc_5896_new_n2270
* NET  1123 = abc_5896_new_n227
* NET  1124 = abc_5896_new_n2269
* NET  1125 = abc_5896_new_n2268
* NET  1126 = abc_5896_new_n2267
* NET  1127 = abc_5896_new_n2266
* NET  1128 = abc_5896_new_n2265
* NET  1129 = abc_5896_new_n2264
* NET  1130 = abc_5896_new_n2263
* NET  1131 = abc_5896_new_n2262
* NET  1132 = abc_5896_new_n2261
* NET  1133 = abc_5896_new_n2260
* NET  1134 = abc_5896_new_n226
* NET  1135 = abc_5896_new_n2258
* NET  1136 = abc_5896_new_n2257
* NET  1137 = abc_5896_new_n2256
* NET  1138 = abc_5896_new_n2255
* NET  1139 = abc_5896_new_n2254
* NET  1140 = abc_5896_new_n2253
* NET  1141 = abc_5896_new_n2252
* NET  1142 = abc_5896_new_n2251
* NET  1143 = abc_5896_new_n2250
* NET  1144 = abc_5896_new_n225
* NET  1145 = abc_5896_new_n2249
* NET  1146 = abc_5896_new_n2248
* NET  1147 = abc_5896_new_n2247
* NET  1148 = abc_5896_new_n2246
* NET  1149 = abc_5896_new_n2245
* NET  1150 = abc_5896_new_n2244
* NET  1151 = abc_5896_new_n2243
* NET  1152 = abc_5896_new_n2242
* NET  1153 = abc_5896_new_n2241
* NET  1154 = abc_5896_new_n2240
* NET  1155 = abc_5896_new_n224
* NET  1156 = abc_5896_new_n2239
* NET  1157 = abc_5896_new_n2238
* NET  1158 = abc_5896_new_n2237
* NET  1159 = abc_5896_new_n2236
* NET  1160 = abc_5896_new_n2235
* NET  1161 = abc_5896_new_n2234
* NET  1162 = abc_5896_new_n2233
* NET  1163 = abc_5896_new_n2232
* NET  1164 = abc_5896_new_n2231
* NET  1165 = abc_5896_new_n2230
* NET  1166 = abc_5896_new_n223
* NET  1167 = abc_5896_new_n2229
* NET  1168 = abc_5896_new_n2228
* NET  1169 = abc_5896_new_n2227
* NET  1170 = abc_5896_new_n2226
* NET  1171 = abc_5896_new_n2225
* NET  1172 = abc_5896_new_n2224
* NET  1173 = abc_5896_new_n2223
* NET  1174 = abc_5896_new_n2222
* NET  1175 = abc_5896_new_n2221
* NET  1176 = abc_5896_new_n2220
* NET  1177 = abc_5896_new_n222
* NET  1178 = abc_5896_new_n2219
* NET  1179 = abc_5896_new_n2218
* NET  1180 = abc_5896_new_n2217
* NET  1181 = abc_5896_new_n2216
* NET  1182 = abc_5896_new_n2214
* NET  1183 = abc_5896_new_n2213
* NET  1184 = abc_5896_new_n2212
* NET  1185 = abc_5896_new_n2211
* NET  1186 = abc_5896_new_n2210
* NET  1187 = abc_5896_new_n221
* NET  1188 = abc_5896_new_n2209
* NET  1189 = abc_5896_new_n2208
* NET  1190 = abc_5896_new_n2207
* NET  1191 = abc_5896_new_n2206
* NET  1192 = abc_5896_new_n2205
* NET  1193 = abc_5896_new_n2204
* NET  1194 = abc_5896_new_n2203
* NET  1195 = abc_5896_new_n2202
* NET  1196 = abc_5896_new_n2201
* NET  1197 = abc_5896_new_n2200
* NET  1198 = abc_5896_new_n220
* NET  1199 = abc_5896_new_n2199
* NET  1200 = abc_5896_new_n2198
* NET  1201 = abc_5896_new_n2197
* NET  1202 = abc_5896_new_n2196
* NET  1203 = abc_5896_new_n2195
* NET  1204 = abc_5896_new_n2194
* NET  1205 = abc_5896_new_n2193
* NET  1206 = abc_5896_new_n2192
* NET  1207 = abc_5896_new_n2191
* NET  1208 = abc_5896_new_n2190
* NET  1209 = abc_5896_new_n219
* NET  1210 = abc_5896_new_n2189
* NET  1211 = abc_5896_new_n2188
* NET  1212 = abc_5896_new_n2187
* NET  1213 = abc_5896_new_n2186
* NET  1214 = abc_5896_new_n2185
* NET  1215 = abc_5896_new_n2184
* NET  1216 = abc_5896_new_n2183
* NET  1217 = abc_5896_new_n2182
* NET  1218 = abc_5896_new_n2181
* NET  1219 = abc_5896_new_n2180
* NET  1220 = abc_5896_new_n218
* NET  1221 = abc_5896_new_n2179
* NET  1222 = abc_5896_new_n2178
* NET  1223 = abc_5896_new_n2177
* NET  1224 = abc_5896_new_n2176
* NET  1225 = abc_5896_new_n2175
* NET  1226 = abc_5896_new_n2174
* NET  1227 = abc_5896_new_n2173
* NET  1228 = abc_5896_new_n2172
* NET  1229 = abc_5896_new_n2171
* NET  1230 = abc_5896_new_n2170
* NET  1231 = abc_5896_new_n217
* NET  1232 = abc_5896_new_n2168
* NET  1233 = abc_5896_new_n2167
* NET  1234 = abc_5896_new_n2166
* NET  1235 = abc_5896_new_n2165
* NET  1236 = abc_5896_new_n2164
* NET  1237 = abc_5896_new_n2163
* NET  1238 = abc_5896_new_n2162
* NET  1239 = abc_5896_new_n2161
* NET  1240 = abc_5896_new_n2160
* NET  1241 = abc_5896_new_n216
* NET  1242 = abc_5896_new_n2159
* NET  1243 = abc_5896_new_n2158
* NET  1244 = abc_5896_new_n2157
* NET  1245 = abc_5896_new_n2156
* NET  1246 = abc_5896_new_n2155
* NET  1247 = abc_5896_new_n2154
* NET  1248 = abc_5896_new_n2153
* NET  1249 = abc_5896_new_n2152
* NET  1250 = abc_5896_new_n2151
* NET  1251 = abc_5896_new_n2150
* NET  1252 = abc_5896_new_n215
* NET  1253 = abc_5896_new_n2149
* NET  1254 = abc_5896_new_n2148
* NET  1255 = abc_5896_new_n2147
* NET  1256 = abc_5896_new_n2146
* NET  1257 = abc_5896_new_n2145
* NET  1258 = abc_5896_new_n2144
* NET  1259 = abc_5896_new_n2143
* NET  1260 = abc_5896_new_n2142
* NET  1261 = abc_5896_new_n2141
* NET  1262 = abc_5896_new_n2140
* NET  1263 = abc_5896_new_n214
* NET  1264 = abc_5896_new_n2139
* NET  1265 = abc_5896_new_n2138
* NET  1266 = abc_5896_new_n2137
* NET  1267 = abc_5896_new_n2136
* NET  1268 = abc_5896_new_n2135
* NET  1269 = abc_5896_new_n2134
* NET  1270 = abc_5896_new_n2133
* NET  1271 = abc_5896_new_n2131
* NET  1272 = abc_5896_new_n2130
* NET  1273 = abc_5896_new_n213
* NET  1274 = abc_5896_new_n2129
* NET  1275 = abc_5896_new_n2128
* NET  1276 = abc_5896_new_n2127
* NET  1277 = abc_5896_new_n2126
* NET  1278 = abc_5896_new_n2125
* NET  1279 = abc_5896_new_n2124
* NET  1280 = abc_5896_new_n2123
* NET  1281 = abc_5896_new_n2122
* NET  1282 = abc_5896_new_n2121
* NET  1283 = abc_5896_new_n2120
* NET  1284 = abc_5896_new_n212
* NET  1285 = abc_5896_new_n2119
* NET  1286 = abc_5896_new_n2118
* NET  1287 = abc_5896_new_n2117
* NET  1288 = abc_5896_new_n2116
* NET  1289 = abc_5896_new_n2115
* NET  1290 = abc_5896_new_n2114
* NET  1291 = abc_5896_new_n2113
* NET  1292 = abc_5896_new_n2112
* NET  1293 = abc_5896_new_n2111
* NET  1294 = abc_5896_new_n2110
* NET  1295 = abc_5896_new_n211
* NET  1296 = abc_5896_new_n2109
* NET  1297 = abc_5896_new_n2108
* NET  1298 = abc_5896_new_n2107
* NET  1299 = abc_5896_new_n2106
* NET  1300 = abc_5896_new_n2105
* NET  1301 = abc_5896_new_n2104
* NET  1302 = abc_5896_new_n2103
* NET  1303 = abc_5896_new_n2102
* NET  1304 = abc_5896_new_n2101
* NET  1305 = abc_5896_new_n2100
* NET  1306 = abc_5896_new_n210
* NET  1307 = abc_5896_new_n2099
* NET  1308 = abc_5896_new_n2098
* NET  1309 = abc_5896_new_n2097
* NET  1310 = abc_5896_new_n2096
* NET  1311 = abc_5896_new_n2095
* NET  1312 = abc_5896_new_n2094
* NET  1313 = abc_5896_new_n2093
* NET  1314 = abc_5896_new_n2092
* NET  1315 = abc_5896_new_n2090
* NET  1316 = abc_5896_new_n2089
* NET  1317 = abc_5896_new_n2088
* NET  1318 = abc_5896_new_n2087
* NET  1319 = abc_5896_new_n2086
* NET  1320 = abc_5896_new_n2085
* NET  1321 = abc_5896_new_n2084
* NET  1322 = abc_5896_new_n2083
* NET  1323 = abc_5896_new_n2082
* NET  1324 = abc_5896_new_n2081
* NET  1325 = abc_5896_new_n2080
* NET  1326 = abc_5896_new_n2079
* NET  1327 = abc_5896_new_n2078
* NET  1328 = abc_5896_new_n2077
* NET  1329 = abc_5896_new_n2076
* NET  1330 = abc_5896_new_n2075
* NET  1331 = abc_5896_new_n2074
* NET  1332 = abc_5896_new_n2073
* NET  1333 = abc_5896_new_n2072
* NET  1334 = abc_5896_new_n2071
* NET  1335 = abc_5896_new_n2070
* NET  1336 = abc_5896_new_n2069
* NET  1337 = abc_5896_new_n2068
* NET  1338 = abc_5896_new_n2067
* NET  1339 = abc_5896_new_n2066
* NET  1340 = abc_5896_new_n2065
* NET  1341 = abc_5896_new_n2064
* NET  1342 = abc_5896_new_n2063
* NET  1343 = abc_5896_new_n2062
* NET  1344 = abc_5896_new_n2061
* NET  1345 = abc_5896_new_n2060
* NET  1346 = abc_5896_new_n2059
* NET  1347 = abc_5896_new_n2058
* NET  1348 = abc_5896_new_n2057
* NET  1349 = abc_5896_new_n2056
* NET  1350 = abc_5896_new_n2055
* NET  1351 = abc_5896_new_n2054
* NET  1352 = abc_5896_new_n2053
* NET  1353 = abc_5896_new_n2052
* NET  1354 = abc_5896_new_n2051
* NET  1355 = abc_5896_new_n2050
* NET  1356 = abc_5896_new_n2049
* NET  1357 = abc_5896_new_n2048
* NET  1358 = abc_5896_new_n2047
* NET  1359 = abc_5896_new_n2046
* NET  1360 = abc_5896_new_n2045
* NET  1361 = abc_5896_new_n2044
* NET  1362 = abc_5896_new_n2043
* NET  1363 = abc_5896_new_n2041
* NET  1364 = abc_5896_new_n2040
* NET  1365 = abc_5896_new_n2039
* NET  1366 = abc_5896_new_n2038
* NET  1367 = abc_5896_new_n2037
* NET  1368 = abc_5896_new_n2036
* NET  1369 = abc_5896_new_n2035
* NET  1370 = abc_5896_new_n2034
* NET  1371 = abc_5896_new_n2033
* NET  1372 = abc_5896_new_n2032
* NET  1373 = abc_5896_new_n2031
* NET  1374 = abc_5896_new_n2030
* NET  1375 = abc_5896_new_n2029
* NET  1376 = abc_5896_new_n2028
* NET  1377 = abc_5896_new_n2027
* NET  1378 = abc_5896_new_n2026
* NET  1379 = abc_5896_new_n2025
* NET  1380 = abc_5896_new_n2024
* NET  1381 = abc_5896_new_n2023
* NET  1382 = abc_5896_new_n2022
* NET  1383 = abc_5896_new_n2021
* NET  1384 = abc_5896_new_n2020
* NET  1385 = abc_5896_new_n2019
* NET  1386 = abc_5896_new_n2018
* NET  1387 = abc_5896_new_n2017
* NET  1388 = abc_5896_new_n2016
* NET  1389 = abc_5896_new_n2015
* NET  1390 = abc_5896_new_n2014
* NET  1391 = abc_5896_new_n2013
* NET  1392 = abc_5896_new_n2012
* NET  1393 = abc_5896_new_n2011
* NET  1394 = abc_5896_new_n2010
* NET  1395 = abc_5896_new_n2009
* NET  1396 = abc_5896_new_n2008
* NET  1397 = abc_5896_new_n2007
* NET  1398 = abc_5896_new_n2006
* NET  1399 = abc_5896_new_n2005
* NET  1400 = abc_5896_new_n2004
* NET  1401 = abc_5896_new_n2003
* NET  1402 = abc_5896_new_n2002
* NET  1403 = abc_5896_new_n2001
* NET  1404 = abc_5896_new_n2000
* NET  1405 = abc_5896_new_n1999
* NET  1406 = abc_5896_new_n1998
* NET  1407 = abc_5896_new_n1997
* NET  1408 = abc_5896_new_n1996
* NET  1409 = abc_5896_new_n1995
* NET  1410 = abc_5896_new_n1994
* NET  1411 = abc_5896_new_n1993
* NET  1412 = abc_5896_new_n1992
* NET  1413 = abc_5896_new_n1990
* NET  1414 = abc_5896_new_n1989
* NET  1415 = abc_5896_new_n1988
* NET  1416 = abc_5896_new_n1987
* NET  1417 = abc_5896_new_n1986
* NET  1418 = abc_5896_new_n1985
* NET  1419 = abc_5896_new_n1984
* NET  1420 = abc_5896_new_n1983
* NET  1421 = abc_5896_new_n1982
* NET  1422 = abc_5896_new_n1981
* NET  1423 = abc_5896_new_n1980
* NET  1424 = abc_5896_new_n1979
* NET  1425 = abc_5896_new_n1978
* NET  1426 = abc_5896_new_n1977
* NET  1427 = abc_5896_new_n1976
* NET  1428 = abc_5896_new_n1975
* NET  1429 = abc_5896_new_n1974
* NET  1430 = abc_5896_new_n1973
* NET  1431 = abc_5896_new_n1972
* NET  1432 = abc_5896_new_n1971
* NET  1433 = abc_5896_new_n1970
* NET  1434 = abc_5896_new_n1969
* NET  1435 = abc_5896_new_n1968
* NET  1436 = abc_5896_new_n1967
* NET  1437 = abc_5896_new_n1966
* NET  1438 = abc_5896_new_n1965
* NET  1439 = abc_5896_new_n1964
* NET  1440 = abc_5896_new_n1963
* NET  1441 = abc_5896_new_n1962
* NET  1442 = abc_5896_new_n1961
* NET  1443 = abc_5896_new_n1960
* NET  1444 = abc_5896_new_n1959
* NET  1445 = abc_5896_new_n1958
* NET  1446 = abc_5896_new_n1957
* NET  1447 = abc_5896_new_n1956
* NET  1448 = abc_5896_new_n1955
* NET  1449 = abc_5896_new_n1954
* NET  1450 = abc_5896_new_n1953
* NET  1451 = abc_5896_new_n1952
* NET  1452 = abc_5896_new_n1951
* NET  1453 = abc_5896_new_n1950
* NET  1454 = abc_5896_new_n1949
* NET  1455 = abc_5896_new_n1948
* NET  1456 = abc_5896_new_n1947
* NET  1457 = abc_5896_new_n1945
* NET  1458 = abc_5896_new_n1944
* NET  1459 = abc_5896_new_n1943
* NET  1460 = abc_5896_new_n1942
* NET  1461 = abc_5896_new_n1941
* NET  1462 = abc_5896_new_n1940
* NET  1463 = abc_5896_new_n1939
* NET  1464 = abc_5896_new_n1938
* NET  1465 = abc_5896_new_n1937
* NET  1466 = abc_5896_new_n1936
* NET  1467 = abc_5896_new_n1935
* NET  1468 = abc_5896_new_n1934
* NET  1469 = abc_5896_new_n1933
* NET  1470 = abc_5896_new_n1932
* NET  1471 = abc_5896_new_n1931
* NET  1472 = abc_5896_new_n1930
* NET  1473 = abc_5896_new_n1929
* NET  1474 = abc_5896_new_n1928
* NET  1475 = abc_5896_new_n1927
* NET  1476 = abc_5896_new_n1926
* NET  1477 = abc_5896_new_n1925
* NET  1478 = abc_5896_new_n1924
* NET  1479 = abc_5896_new_n1923
* NET  1480 = abc_5896_new_n1922
* NET  1481 = abc_5896_new_n1921
* NET  1482 = abc_5896_new_n1920
* NET  1483 = abc_5896_new_n1919
* NET  1484 = abc_5896_new_n1918
* NET  1485 = abc_5896_new_n1917
* NET  1486 = abc_5896_new_n1916
* NET  1487 = abc_5896_new_n1915
* NET  1488 = abc_5896_new_n1914
* NET  1489 = abc_5896_new_n1913
* NET  1490 = abc_5896_new_n1912
* NET  1491 = abc_5896_new_n1911
* NET  1492 = abc_5896_new_n1910
* NET  1493 = abc_5896_new_n1909
* NET  1494 = abc_5896_new_n1908
* NET  1495 = abc_5896_new_n1907
* NET  1496 = abc_5896_new_n1906
* NET  1497 = abc_5896_new_n1905
* NET  1498 = abc_5896_new_n1904
* NET  1499 = abc_5896_new_n1902
* NET  1500 = abc_5896_new_n1901
* NET  1501 = abc_5896_new_n1900
* NET  1502 = abc_5896_new_n1899
* NET  1503 = abc_5896_new_n1898
* NET  1504 = abc_5896_new_n1897
* NET  1505 = abc_5896_new_n1896
* NET  1506 = abc_5896_new_n1895
* NET  1507 = abc_5896_new_n1894
* NET  1508 = abc_5896_new_n1893
* NET  1509 = abc_5896_new_n1892
* NET  1510 = abc_5896_new_n1891
* NET  1511 = abc_5896_new_n1890
* NET  1512 = abc_5896_new_n1889
* NET  1513 = abc_5896_new_n1888
* NET  1514 = abc_5896_new_n1887
* NET  1515 = abc_5896_new_n1886
* NET  1516 = abc_5896_new_n1885
* NET  1517 = abc_5896_new_n1884
* NET  1518 = abc_5896_new_n1883
* NET  1519 = abc_5896_new_n1882
* NET  1520 = abc_5896_new_n1881
* NET  1521 = abc_5896_new_n1880
* NET  1522 = abc_5896_new_n1878
* NET  1523 = abc_5896_new_n1877
* NET  1524 = abc_5896_new_n1876
* NET  1525 = abc_5896_new_n1875
* NET  1526 = abc_5896_new_n1874
* NET  1527 = abc_5896_new_n1873
* NET  1528 = abc_5896_new_n1872
* NET  1529 = abc_5896_new_n1871
* NET  1530 = abc_5896_new_n1870
* NET  1531 = abc_5896_new_n1869
* NET  1532 = abc_5896_new_n1868
* NET  1533 = abc_5896_new_n1867
* NET  1534 = abc_5896_new_n1866
* NET  1535 = abc_5896_new_n1865
* NET  1536 = abc_5896_new_n1864
* NET  1537 = abc_5896_new_n1863
* NET  1538 = abc_5896_new_n1862
* NET  1539 = abc_5896_new_n1861
* NET  1540 = abc_5896_new_n1860
* NET  1541 = abc_5896_new_n1859
* NET  1542 = abc_5896_new_n1858
* NET  1543 = abc_5896_new_n1857
* NET  1544 = abc_5896_new_n1856
* NET  1545 = abc_5896_new_n1854
* NET  1546 = abc_5896_new_n1853
* NET  1547 = abc_5896_new_n1852
* NET  1548 = abc_5896_new_n1851
* NET  1549 = abc_5896_new_n1850
* NET  1550 = abc_5896_new_n1849
* NET  1551 = abc_5896_new_n1848
* NET  1552 = abc_5896_new_n1847
* NET  1553 = abc_5896_new_n1846
* NET  1554 = abc_5896_new_n1845
* NET  1555 = abc_5896_new_n1844
* NET  1556 = abc_5896_new_n1843
* NET  1557 = abc_5896_new_n1842
* NET  1558 = abc_5896_new_n1841
* NET  1559 = abc_5896_new_n1840
* NET  1560 = abc_5896_new_n1839
* NET  1561 = abc_5896_new_n1838
* NET  1562 = abc_5896_new_n1837
* NET  1563 = abc_5896_new_n1836
* NET  1564 = abc_5896_new_n1835
* NET  1565 = abc_5896_new_n1834
* NET  1566 = abc_5896_new_n1833
* NET  1567 = abc_5896_new_n1832
* NET  1568 = abc_5896_new_n1831
* NET  1569 = abc_5896_new_n1830
* NET  1570 = abc_5896_new_n1829
* NET  1571 = abc_5896_new_n1828
* NET  1572 = abc_5896_new_n1827
* NET  1573 = abc_5896_new_n1825
* NET  1574 = abc_5896_new_n1824
* NET  1575 = abc_5896_new_n1823
* NET  1576 = abc_5896_new_n1822
* NET  1577 = abc_5896_new_n1821
* NET  1578 = abc_5896_new_n1820
* NET  1579 = abc_5896_new_n1819
* NET  1580 = abc_5896_new_n1818
* NET  1581 = abc_5896_new_n1817
* NET  1582 = abc_5896_new_n1816
* NET  1583 = abc_5896_new_n1815
* NET  1584 = abc_5896_new_n1814
* NET  1585 = abc_5896_new_n1813
* NET  1586 = abc_5896_new_n1812
* NET  1587 = abc_5896_new_n1811
* NET  1588 = abc_5896_new_n1810
* NET  1589 = abc_5896_new_n1809
* NET  1590 = abc_5896_new_n1808
* NET  1591 = abc_5896_new_n1807
* NET  1592 = abc_5896_new_n1806
* NET  1593 = abc_5896_new_n1805
* NET  1594 = abc_5896_new_n1804
* NET  1595 = abc_5896_new_n1803
* NET  1596 = abc_5896_new_n1802
* NET  1597 = abc_5896_new_n1801
* NET  1598 = abc_5896_new_n1800
* NET  1599 = abc_5896_new_n1799
* NET  1600 = abc_5896_new_n1798
* NET  1601 = abc_5896_new_n1797
* NET  1602 = abc_5896_new_n1796
* NET  1603 = abc_5896_new_n1795
* NET  1604 = abc_5896_new_n1794
* NET  1605 = abc_5896_new_n1793
* NET  1606 = abc_5896_new_n1792
* NET  1607 = abc_5896_new_n1791
* NET  1608 = abc_5896_new_n1789
* NET  1609 = abc_5896_new_n1788
* NET  1610 = abc_5896_new_n1787
* NET  1611 = abc_5896_new_n1786
* NET  1612 = abc_5896_new_n1785
* NET  1613 = abc_5896_new_n1784
* NET  1614 = abc_5896_new_n1783
* NET  1615 = abc_5896_new_n1782
* NET  1616 = abc_5896_new_n1781
* NET  1617 = abc_5896_new_n1780
* NET  1618 = abc_5896_new_n1779
* NET  1619 = abc_5896_new_n1778
* NET  1620 = abc_5896_new_n1777
* NET  1621 = abc_5896_new_n1776
* NET  1622 = abc_5896_new_n1775
* NET  1623 = abc_5896_new_n1774
* NET  1624 = abc_5896_new_n1773
* NET  1625 = abc_5896_new_n1772
* NET  1626 = abc_5896_new_n1771
* NET  1627 = abc_5896_new_n1770
* NET  1628 = abc_5896_new_n1769
* NET  1629 = abc_5896_new_n1768
* NET  1630 = abc_5896_new_n1767
* NET  1631 = abc_5896_new_n1766
* NET  1632 = abc_5896_new_n1765
* NET  1633 = abc_5896_new_n1764
* NET  1634 = abc_5896_new_n1763
* NET  1635 = abc_5896_new_n1762
* NET  1636 = abc_5896_new_n1761
* NET  1637 = abc_5896_new_n1760
* NET  1638 = abc_5896_new_n1759
* NET  1639 = abc_5896_new_n1758
* NET  1640 = abc_5896_new_n1757
* NET  1641 = abc_5896_new_n1756
* NET  1642 = abc_5896_new_n1755
* NET  1643 = abc_5896_new_n1754
* NET  1644 = abc_5896_new_n1753
* NET  1645 = abc_5896_new_n1751
* NET  1646 = abc_5896_new_n1750
* NET  1647 = abc_5896_new_n1749
* NET  1648 = abc_5896_new_n1748
* NET  1649 = abc_5896_new_n1747
* NET  1650 = abc_5896_new_n1746
* NET  1651 = abc_5896_new_n1745
* NET  1652 = abc_5896_new_n1744
* NET  1653 = abc_5896_new_n1743
* NET  1654 = abc_5896_new_n1742
* NET  1655 = abc_5896_new_n1741
* NET  1656 = abc_5896_new_n1740
* NET  1657 = abc_5896_new_n1739
* NET  1658 = abc_5896_new_n1738
* NET  1659 = abc_5896_new_n1737
* NET  1660 = abc_5896_new_n1736
* NET  1661 = abc_5896_new_n1735
* NET  1662 = abc_5896_new_n1734
* NET  1663 = abc_5896_new_n1733
* NET  1664 = abc_5896_new_n1732
* NET  1665 = abc_5896_new_n1731
* NET  1666 = abc_5896_new_n1730
* NET  1667 = abc_5896_new_n1729
* NET  1668 = abc_5896_new_n1728
* NET  1669 = abc_5896_new_n1727
* NET  1670 = abc_5896_new_n1726
* NET  1671 = abc_5896_new_n1725
* NET  1672 = abc_5896_new_n1724
* NET  1673 = abc_5896_new_n1723
* NET  1674 = abc_5896_new_n1722
* NET  1675 = abc_5896_new_n1721
* NET  1676 = abc_5896_new_n1720
* NET  1677 = abc_5896_new_n1719
* NET  1678 = abc_5896_new_n1718
* NET  1679 = abc_5896_new_n1717
* NET  1680 = abc_5896_new_n1716
* NET  1681 = abc_5896_new_n1715
* NET  1682 = abc_5896_new_n1714
* NET  1683 = abc_5896_new_n1713
* NET  1684 = abc_5896_new_n1712
* NET  1685 = abc_5896_new_n1711
* NET  1686 = abc_5896_new_n1710
* NET  1687 = abc_5896_new_n1709
* NET  1688 = abc_5896_new_n1707
* NET  1689 = abc_5896_new_n1706
* NET  1690 = abc_5896_new_n1705
* NET  1691 = abc_5896_new_n1704
* NET  1692 = abc_5896_new_n1703
* NET  1693 = abc_5896_new_n1702
* NET  1694 = abc_5896_new_n1701
* NET  1695 = abc_5896_new_n1700
* NET  1696 = abc_5896_new_n1699
* NET  1697 = abc_5896_new_n1698
* NET  1698 = abc_5896_new_n1697
* NET  1699 = abc_5896_new_n1696
* NET  1700 = abc_5896_new_n1695
* NET  1701 = abc_5896_new_n1694
* NET  1702 = abc_5896_new_n1693
* NET  1703 = abc_5896_new_n1692
* NET  1704 = abc_5896_new_n1691
* NET  1705 = abc_5896_new_n1690
* NET  1706 = abc_5896_new_n1689
* NET  1707 = abc_5896_new_n1688
* NET  1708 = abc_5896_new_n1687
* NET  1709 = abc_5896_new_n1686
* NET  1710 = abc_5896_new_n1685
* NET  1711 = abc_5896_new_n1684
* NET  1712 = abc_5896_new_n1683
* NET  1713 = abc_5896_new_n1682
* NET  1714 = abc_5896_new_n1681
* NET  1715 = abc_5896_new_n1680
* NET  1716 = abc_5896_new_n1679
* NET  1717 = abc_5896_new_n1678
* NET  1718 = abc_5896_new_n1677
* NET  1719 = abc_5896_new_n1676
* NET  1720 = abc_5896_new_n1675
* NET  1721 = abc_5896_new_n1674
* NET  1722 = abc_5896_new_n1673
* NET  1723 = abc_5896_new_n1672
* NET  1724 = abc_5896_new_n1671
* NET  1725 = abc_5896_new_n1670
* NET  1726 = abc_5896_new_n1669
* NET  1727 = abc_5896_new_n1668
* NET  1728 = abc_5896_new_n1667
* NET  1729 = abc_5896_new_n1666
* NET  1730 = abc_5896_new_n1665
* NET  1731 = abc_5896_new_n1663
* NET  1732 = abc_5896_new_n1662
* NET  1733 = abc_5896_new_n1661
* NET  1734 = abc_5896_new_n1660
* NET  1735 = abc_5896_new_n1659
* NET  1736 = abc_5896_new_n1658
* NET  1737 = abc_5896_new_n1657
* NET  1738 = abc_5896_new_n1656
* NET  1739 = abc_5896_new_n1655
* NET  1740 = abc_5896_new_n1654
* NET  1741 = abc_5896_new_n1653
* NET  1742 = abc_5896_new_n1652
* NET  1743 = abc_5896_new_n1651
* NET  1744 = abc_5896_new_n1650
* NET  1745 = abc_5896_new_n1649
* NET  1746 = abc_5896_new_n1648
* NET  1747 = abc_5896_new_n1647
* NET  1748 = abc_5896_new_n1646
* NET  1749 = abc_5896_new_n1645
* NET  1750 = abc_5896_new_n1644
* NET  1751 = abc_5896_new_n1643
* NET  1752 = abc_5896_new_n1642
* NET  1753 = abc_5896_new_n1641
* NET  1754 = abc_5896_new_n1640
* NET  1755 = abc_5896_new_n1639
* NET  1756 = abc_5896_new_n1638
* NET  1757 = abc_5896_new_n1637
* NET  1758 = abc_5896_new_n1636
* NET  1759 = abc_5896_new_n1635
* NET  1760 = abc_5896_new_n1634
* NET  1761 = abc_5896_new_n1633
* NET  1762 = abc_5896_new_n1632
* NET  1763 = abc_5896_new_n1631
* NET  1764 = abc_5896_new_n1630
* NET  1765 = abc_5896_new_n1629
* NET  1766 = abc_5896_new_n1628
* NET  1767 = abc_5896_new_n1627
* NET  1768 = abc_5896_new_n1626
* NET  1769 = abc_5896_new_n1625
* NET  1770 = abc_5896_new_n1624
* NET  1771 = abc_5896_new_n1623
* NET  1772 = abc_5896_new_n1622
* NET  1773 = abc_5896_new_n1621
* NET  1774 = abc_5896_new_n1619
* NET  1775 = abc_5896_new_n1618
* NET  1776 = abc_5896_new_n1617
* NET  1777 = abc_5896_new_n1616
* NET  1778 = abc_5896_new_n1615
* NET  1779 = abc_5896_new_n1614
* NET  1780 = abc_5896_new_n1613
* NET  1781 = abc_5896_new_n1612
* NET  1782 = abc_5896_new_n1611
* NET  1783 = abc_5896_new_n1610
* NET  1784 = abc_5896_new_n1609
* NET  1785 = abc_5896_new_n1608
* NET  1786 = abc_5896_new_n1607
* NET  1787 = abc_5896_new_n1606
* NET  1788 = abc_5896_new_n1605
* NET  1789 = abc_5896_new_n1604
* NET  1790 = abc_5896_new_n1603
* NET  1791 = abc_5896_new_n1602
* NET  1792 = abc_5896_new_n1601
* NET  1793 = abc_5896_new_n1600
* NET  1794 = abc_5896_new_n1599
* NET  1795 = abc_5896_new_n1598
* NET  1796 = abc_5896_new_n1597
* NET  1797 = abc_5896_new_n1596
* NET  1798 = abc_5896_new_n1595
* NET  1799 = abc_5896_new_n1594
* NET  1800 = abc_5896_new_n1593
* NET  1801 = abc_5896_new_n1592
* NET  1802 = abc_5896_new_n1591
* NET  1803 = abc_5896_new_n1590
* NET  1804 = abc_5896_new_n1589
* NET  1805 = abc_5896_new_n1588
* NET  1806 = abc_5896_new_n1587
* NET  1807 = abc_5896_new_n1586
* NET  1808 = abc_5896_new_n1585
* NET  1809 = abc_5896_new_n1584
* NET  1810 = abc_5896_new_n1583
* NET  1811 = abc_5896_new_n1582
* NET  1812 = abc_5896_new_n1581
* NET  1813 = abc_5896_new_n1580
* NET  1814 = abc_5896_new_n1579
* NET  1815 = abc_5896_new_n1578
* NET  1816 = abc_5896_new_n1577
* NET  1817 = abc_5896_new_n1576
* NET  1818 = abc_5896_new_n1575
* NET  1819 = abc_5896_new_n1574
* NET  1820 = abc_5896_new_n1573
* NET  1821 = abc_5896_new_n1572
* NET  1822 = abc_5896_new_n1571
* NET  1823 = abc_5896_new_n1570
* NET  1824 = abc_5896_new_n1568
* NET  1825 = abc_5896_new_n1567
* NET  1826 = abc_5896_new_n1566
* NET  1827 = abc_5896_new_n1565
* NET  1828 = abc_5896_new_n1564
* NET  1829 = abc_5896_new_n1563
* NET  1830 = abc_5896_new_n1562
* NET  1831 = abc_5896_new_n1561
* NET  1832 = abc_5896_new_n1560
* NET  1833 = abc_5896_new_n1559
* NET  1834 = abc_5896_new_n1558
* NET  1835 = abc_5896_new_n1557
* NET  1836 = abc_5896_new_n1556
* NET  1837 = abc_5896_new_n1555
* NET  1838 = abc_5896_new_n1554
* NET  1839 = abc_5896_new_n1553
* NET  1840 = abc_5896_new_n1552
* NET  1841 = abc_5896_new_n1551
* NET  1842 = abc_5896_new_n1550
* NET  1843 = abc_5896_new_n1549
* NET  1844 = abc_5896_new_n1548
* NET  1845 = abc_5896_new_n1547
* NET  1846 = abc_5896_new_n1546
* NET  1847 = abc_5896_new_n1545
* NET  1848 = abc_5896_new_n1544
* NET  1849 = abc_5896_new_n1543
* NET  1850 = abc_5896_new_n1542
* NET  1851 = abc_5896_new_n1541
* NET  1852 = abc_5896_new_n1540
* NET  1853 = abc_5896_new_n1539
* NET  1854 = abc_5896_new_n1538
* NET  1855 = abc_5896_new_n1537
* NET  1856 = abc_5896_new_n1536
* NET  1857 = abc_5896_new_n1535
* NET  1858 = abc_5896_new_n1534
* NET  1859 = abc_5896_new_n1533
* NET  1860 = abc_5896_new_n1532
* NET  1861 = abc_5896_new_n1531
* NET  1862 = abc_5896_new_n1530
* NET  1863 = abc_5896_new_n1529
* NET  1864 = abc_5896_new_n1528
* NET  1865 = abc_5896_new_n1527
* NET  1866 = abc_5896_new_n1526
* NET  1867 = abc_5896_new_n1525
* NET  1868 = abc_5896_new_n1524
* NET  1869 = abc_5896_new_n1523
* NET  1870 = abc_5896_new_n1521
* NET  1871 = abc_5896_new_n1520
* NET  1872 = abc_5896_new_n1519
* NET  1873 = abc_5896_new_n1518
* NET  1874 = abc_5896_new_n1517
* NET  1875 = abc_5896_new_n1516
* NET  1876 = abc_5896_new_n1515
* NET  1877 = abc_5896_new_n1514
* NET  1878 = abc_5896_new_n1513
* NET  1879 = abc_5896_new_n1512
* NET  1880 = abc_5896_new_n1511
* NET  1881 = abc_5896_new_n1510
* NET  1882 = abc_5896_new_n1509
* NET  1883 = abc_5896_new_n1508
* NET  1884 = abc_5896_new_n1507
* NET  1885 = abc_5896_new_n1506
* NET  1886 = abc_5896_new_n1505
* NET  1887 = abc_5896_new_n1504
* NET  1888 = abc_5896_new_n1503
* NET  1889 = abc_5896_new_n1502
* NET  1890 = abc_5896_new_n1501
* NET  1891 = abc_5896_new_n1500
* NET  1892 = abc_5896_new_n1499
* NET  1893 = abc_5896_new_n1498
* NET  1894 = abc_5896_new_n1497
* NET  1895 = abc_5896_new_n1496
* NET  1896 = abc_5896_new_n1495
* NET  1897 = abc_5896_new_n1494
* NET  1898 = abc_5896_new_n1493
* NET  1899 = abc_5896_new_n1492
* NET  1900 = abc_5896_new_n1491
* NET  1901 = abc_5896_new_n1490
* NET  1902 = abc_5896_new_n1489
* NET  1903 = abc_5896_new_n1488
* NET  1904 = abc_5896_new_n1487
* NET  1905 = abc_5896_new_n1486
* NET  1906 = abc_5896_new_n1485
* NET  1907 = abc_5896_new_n1484
* NET  1908 = abc_5896_new_n1483
* NET  1909 = abc_5896_new_n1482
* NET  1910 = abc_5896_new_n1481
* NET  1911 = abc_5896_new_n1480
* NET  1912 = abc_5896_new_n1479
* NET  1913 = abc_5896_new_n1478
* NET  1914 = abc_5896_new_n1477
* NET  1915 = abc_5896_new_n1476
* NET  1916 = abc_5896_new_n1475
* NET  1917 = abc_5896_new_n1474
* NET  1918 = abc_5896_new_n1473
* NET  1919 = abc_5896_new_n1472
* NET  1920 = abc_5896_new_n1470
* NET  1921 = abc_5896_new_n1469
* NET  1922 = abc_5896_new_n1468
* NET  1923 = abc_5896_new_n1467
* NET  1924 = abc_5896_new_n1466
* NET  1925 = abc_5896_new_n1465
* NET  1926 = abc_5896_new_n1464
* NET  1927 = abc_5896_new_n1463
* NET  1928 = abc_5896_new_n1462
* NET  1929 = abc_5896_new_n1461
* NET  1930 = abc_5896_new_n1460
* NET  1931 = abc_5896_new_n1459
* NET  1932 = abc_5896_new_n1458
* NET  1933 = abc_5896_new_n1457
* NET  1934 = abc_5896_new_n1456
* NET  1935 = abc_5896_new_n1455
* NET  1936 = abc_5896_new_n1454
* NET  1937 = abc_5896_new_n1453
* NET  1938 = abc_5896_new_n1452
* NET  1939 = abc_5896_new_n1451
* NET  1940 = abc_5896_new_n1450
* NET  1941 = abc_5896_new_n1449
* NET  1942 = abc_5896_new_n1448
* NET  1943 = abc_5896_new_n1447
* NET  1944 = abc_5896_new_n1446
* NET  1945 = abc_5896_new_n1445
* NET  1946 = abc_5896_new_n1444
* NET  1947 = abc_5896_new_n1443
* NET  1948 = abc_5896_new_n1442
* NET  1949 = abc_5896_new_n1441
* NET  1950 = abc_5896_new_n1440
* NET  1951 = abc_5896_new_n1439
* NET  1952 = abc_5896_new_n1438
* NET  1953 = abc_5896_new_n1437
* NET  1954 = abc_5896_new_n1436
* NET  1955 = abc_5896_new_n1435
* NET  1956 = abc_5896_new_n1434
* NET  1957 = abc_5896_new_n1433
* NET  1958 = abc_5896_new_n1432
* NET  1959 = abc_5896_new_n1431
* NET  1960 = abc_5896_new_n1430
* NET  1961 = abc_5896_new_n1429
* NET  1962 = abc_5896_new_n1428
* NET  1963 = abc_5896_new_n1427
* NET  1964 = abc_5896_new_n1426
* NET  1965 = abc_5896_new_n1425
* NET  1966 = abc_5896_new_n1424
* NET  1967 = abc_5896_new_n1423
* NET  1968 = abc_5896_new_n1421
* NET  1969 = abc_5896_new_n1420
* NET  1970 = abc_5896_new_n1419
* NET  1971 = abc_5896_new_n1418
* NET  1972 = abc_5896_new_n1417
* NET  1973 = abc_5896_new_n1416
* NET  1974 = abc_5896_new_n1415
* NET  1975 = abc_5896_new_n1414
* NET  1976 = abc_5896_new_n1413
* NET  1977 = abc_5896_new_n1412
* NET  1978 = abc_5896_new_n1411
* NET  1979 = abc_5896_new_n1410
* NET  1980 = abc_5896_new_n1409
* NET  1981 = abc_5896_new_n1408
* NET  1982 = abc_5896_new_n1407
* NET  1983 = abc_5896_new_n1406
* NET  1984 = abc_5896_new_n1405
* NET  1985 = abc_5896_new_n1404
* NET  1986 = abc_5896_new_n1403
* NET  1987 = abc_5896_new_n1402
* NET  1988 = abc_5896_new_n1401
* NET  1989 = abc_5896_new_n1400
* NET  1990 = abc_5896_new_n1399
* NET  1991 = abc_5896_new_n1398
* NET  1992 = abc_5896_new_n1397
* NET  1993 = abc_5896_new_n1396
* NET  1994 = abc_5896_new_n1395
* NET  1995 = abc_5896_new_n1394
* NET  1996 = abc_5896_new_n1393
* NET  1997 = abc_5896_new_n1392
* NET  1998 = abc_5896_new_n1391
* NET  1999 = abc_5896_new_n1390
* NET  2000 = abc_5896_new_n1389
* NET  2001 = abc_5896_new_n1388
* NET  2002 = abc_5896_new_n1387
* NET  2003 = abc_5896_new_n1386
* NET  2004 = abc_5896_new_n1385
* NET  2005 = abc_5896_new_n1384
* NET  2006 = abc_5896_new_n1383
* NET  2007 = abc_5896_new_n1382
* NET  2008 = abc_5896_new_n1381
* NET  2009 = abc_5896_new_n1380
* NET  2010 = abc_5896_new_n1379
* NET  2011 = abc_5896_new_n1378
* NET  2012 = abc_5896_new_n1377
* NET  2013 = abc_5896_new_n1376
* NET  2014 = abc_5896_new_n1374
* NET  2015 = abc_5896_new_n1373
* NET  2016 = abc_5896_new_n1372
* NET  2017 = abc_5896_new_n1371
* NET  2018 = abc_5896_new_n1370
* NET  2019 = abc_5896_new_n1369
* NET  2020 = abc_5896_new_n1368
* NET  2021 = abc_5896_new_n1367
* NET  2022 = abc_5896_new_n1366
* NET  2023 = abc_5896_new_n1365
* NET  2024 = abc_5896_new_n1364
* NET  2025 = abc_5896_new_n1363
* NET  2026 = abc_5896_new_n1362
* NET  2027 = abc_5896_new_n1361
* NET  2028 = abc_5896_new_n1360
* NET  2029 = abc_5896_new_n1359
* NET  2030 = abc_5896_new_n1358
* NET  2031 = abc_5896_new_n1357
* NET  2032 = abc_5896_new_n1356
* NET  2033 = abc_5896_new_n1355
* NET  2034 = abc_5896_new_n1354
* NET  2035 = abc_5896_new_n1353
* NET  2036 = abc_5896_new_n1352
* NET  2037 = abc_5896_new_n1351
* NET  2038 = abc_5896_new_n1350
* NET  2039 = abc_5896_new_n1349
* NET  2040 = abc_5896_new_n1348
* NET  2041 = abc_5896_new_n1347
* NET  2042 = abc_5896_new_n1346
* NET  2043 = abc_5896_new_n1345
* NET  2044 = abc_5896_new_n1344
* NET  2045 = abc_5896_new_n1343
* NET  2046 = abc_5896_new_n1342
* NET  2047 = abc_5896_new_n1341
* NET  2048 = abc_5896_new_n1340
* NET  2049 = abc_5896_new_n1339
* NET  2050 = abc_5896_new_n1338
* NET  2051 = abc_5896_new_n1337
* NET  2052 = abc_5896_new_n1336
* NET  2053 = abc_5896_new_n1335
* NET  2054 = abc_5896_new_n1334
* NET  2055 = abc_5896_new_n1333
* NET  2056 = abc_5896_new_n1332
* NET  2057 = abc_5896_new_n1331
* NET  2058 = abc_5896_new_n1330
* NET  2059 = abc_5896_new_n1329
* NET  2060 = abc_5896_new_n1328
* NET  2061 = abc_5896_new_n1327
* NET  2062 = abc_5896_new_n1326
* NET  2063 = abc_5896_new_n1325
* NET  2064 = abc_5896_new_n1323
* NET  2065 = abc_5896_new_n1322
* NET  2066 = abc_5896_new_n1321
* NET  2067 = abc_5896_new_n1320
* NET  2068 = abc_5896_new_n1319
* NET  2069 = abc_5896_new_n1318
* NET  2070 = abc_5896_new_n1317
* NET  2071 = abc_5896_new_n1316
* NET  2072 = abc_5896_new_n1315
* NET  2073 = abc_5896_new_n1314
* NET  2074 = abc_5896_new_n1313
* NET  2075 = abc_5896_new_n1312
* NET  2076 = abc_5896_new_n1311
* NET  2077 = abc_5896_new_n1310
* NET  2078 = abc_5896_new_n1309
* NET  2079 = abc_5896_new_n1308
* NET  2080 = abc_5896_new_n1307
* NET  2081 = abc_5896_new_n1306
* NET  2082 = abc_5896_new_n1305
* NET  2083 = abc_5896_new_n1304
* NET  2084 = abc_5896_new_n1303
* NET  2085 = abc_5896_new_n1302
* NET  2086 = abc_5896_new_n1301
* NET  2087 = abc_5896_new_n1300
* NET  2088 = abc_5896_new_n1299
* NET  2089 = abc_5896_new_n1298
* NET  2090 = abc_5896_new_n1297
* NET  2091 = abc_5896_new_n1296
* NET  2092 = abc_5896_new_n1295
* NET  2093 = abc_5896_new_n1294
* NET  2094 = abc_5896_new_n1293
* NET  2095 = abc_5896_new_n1292
* NET  2096 = abc_5896_new_n1291
* NET  2097 = abc_5896_new_n1290
* NET  2098 = abc_5896_new_n1289
* NET  2099 = abc_5896_new_n1288
* NET  2100 = abc_5896_new_n1287
* NET  2101 = abc_5896_new_n1286
* NET  2102 = abc_5896_new_n1285
* NET  2103 = abc_5896_new_n1284
* NET  2104 = abc_5896_new_n1283
* NET  2105 = abc_5896_new_n1282
* NET  2106 = abc_5896_new_n1281
* NET  2107 = abc_5896_new_n1280
* NET  2108 = abc_5896_new_n1279
* NET  2109 = abc_5896_new_n1278
* NET  2110 = abc_5896_new_n1276
* NET  2111 = abc_5896_new_n1275
* NET  2112 = abc_5896_new_n1274
* NET  2113 = abc_5896_new_n1273
* NET  2114 = abc_5896_new_n1272
* NET  2115 = abc_5896_new_n1271
* NET  2116 = abc_5896_new_n1270
* NET  2117 = abc_5896_new_n1269
* NET  2118 = abc_5896_new_n1268
* NET  2119 = abc_5896_new_n1267
* NET  2120 = abc_5896_new_n1266
* NET  2121 = abc_5896_new_n1265
* NET  2122 = abc_5896_new_n1264
* NET  2123 = abc_5896_new_n1263
* NET  2124 = abc_5896_new_n1262
* NET  2125 = abc_5896_new_n1261
* NET  2126 = abc_5896_new_n1260
* NET  2127 = abc_5896_new_n1259
* NET  2128 = abc_5896_new_n1258
* NET  2129 = abc_5896_new_n1257
* NET  2130 = abc_5896_new_n1256
* NET  2131 = abc_5896_new_n1255
* NET  2132 = abc_5896_new_n1254
* NET  2133 = abc_5896_new_n1253
* NET  2134 = abc_5896_new_n1252
* NET  2135 = abc_5896_new_n1251
* NET  2136 = abc_5896_new_n1250
* NET  2137 = abc_5896_new_n1249
* NET  2138 = abc_5896_new_n1248
* NET  2139 = abc_5896_new_n1247
* NET  2140 = abc_5896_new_n1246
* NET  2141 = abc_5896_new_n1245
* NET  2142 = abc_5896_new_n1244
* NET  2143 = abc_5896_new_n1243
* NET  2144 = abc_5896_new_n1242
* NET  2145 = abc_5896_new_n1241
* NET  2146 = abc_5896_new_n1240
* NET  2147 = abc_5896_new_n1239
* NET  2148 = abc_5896_new_n1238
* NET  2149 = abc_5896_new_n1237
* NET  2150 = abc_5896_new_n1236
* NET  2151 = abc_5896_new_n1235
* NET  2152 = abc_5896_new_n1234
* NET  2153 = abc_5896_new_n1233
* NET  2154 = abc_5896_new_n1232
* NET  2155 = abc_5896_new_n1231
* NET  2156 = abc_5896_new_n1230
* NET  2157 = abc_5896_new_n1229
* NET  2158 = abc_5896_new_n1228
* NET  2159 = abc_5896_new_n1227
* NET  2160 = abc_5896_new_n1226
* NET  2161 = abc_5896_new_n1225
* NET  2162 = abc_5896_new_n1224
* NET  2163 = abc_5896_new_n1222
* NET  2164 = abc_5896_new_n1221
* NET  2165 = abc_5896_new_n1220
* NET  2166 = abc_5896_new_n1219
* NET  2167 = abc_5896_new_n1218
* NET  2168 = abc_5896_new_n1217
* NET  2169 = abc_5896_new_n1216
* NET  2170 = abc_5896_new_n1215
* NET  2171 = abc_5896_new_n1214
* NET  2172 = abc_5896_new_n1213
* NET  2173 = abc_5896_new_n1212
* NET  2174 = abc_5896_new_n1211
* NET  2175 = abc_5896_new_n1210
* NET  2176 = abc_5896_new_n1209
* NET  2177 = abc_5896_new_n1208
* NET  2178 = abc_5896_new_n1207
* NET  2179 = abc_5896_new_n1206
* NET  2180 = abc_5896_new_n1205
* NET  2181 = abc_5896_new_n1204
* NET  2182 = abc_5896_new_n1203
* NET  2183 = abc_5896_new_n1202
* NET  2184 = abc_5896_new_n1201
* NET  2185 = abc_5896_new_n1200
* NET  2186 = abc_5896_new_n1199
* NET  2187 = abc_5896_new_n1198
* NET  2188 = abc_5896_new_n1197
* NET  2189 = abc_5896_new_n1196
* NET  2190 = abc_5896_new_n1195
* NET  2191 = abc_5896_new_n1194
* NET  2192 = abc_5896_new_n1193
* NET  2193 = abc_5896_new_n1192
* NET  2194 = abc_5896_new_n1191
* NET  2195 = abc_5896_new_n1190
* NET  2196 = abc_5896_new_n1189
* NET  2197 = abc_5896_new_n1188
* NET  2198 = abc_5896_new_n1187
* NET  2199 = abc_5896_new_n1186
* NET  2200 = abc_5896_new_n1185
* NET  2201 = abc_5896_new_n1184
* NET  2202 = abc_5896_new_n1183
* NET  2203 = abc_5896_new_n1182
* NET  2204 = abc_5896_new_n1181
* NET  2205 = abc_5896_new_n1180
* NET  2206 = abc_5896_new_n1179
* NET  2207 = abc_5896_new_n1178
* NET  2208 = abc_5896_new_n1177
* NET  2209 = abc_5896_new_n1176
* NET  2210 = abc_5896_new_n1175
* NET  2211 = abc_5896_new_n1174
* NET  2212 = abc_5896_new_n1172
* NET  2213 = abc_5896_new_n1171
* NET  2214 = abc_5896_new_n1170
* NET  2215 = abc_5896_new_n1169
* NET  2216 = abc_5896_new_n1168
* NET  2217 = abc_5896_new_n1167
* NET  2218 = abc_5896_new_n1166
* NET  2219 = abc_5896_new_n1165
* NET  2220 = abc_5896_new_n1164
* NET  2221 = abc_5896_new_n1163
* NET  2222 = abc_5896_new_n1162
* NET  2223 = abc_5896_new_n1160
* NET  2224 = abc_5896_new_n1159
* NET  2225 = abc_5896_new_n1158
* NET  2226 = abc_5896_new_n1157
* NET  2227 = abc_5896_new_n1156
* NET  2228 = abc_5896_new_n1155
* NET  2229 = abc_5896_new_n1154
* NET  2230 = abc_5896_new_n1153
* NET  2231 = abc_5896_new_n1152
* NET  2232 = abc_5896_new_n1151
* NET  2233 = abc_5896_new_n1150
* NET  2234 = abc_5896_new_n1149
* NET  2235 = abc_5896_new_n1148
* NET  2236 = abc_5896_new_n1147
* NET  2237 = abc_5896_new_n1146
* NET  2238 = abc_5896_new_n1145
* NET  2239 = abc_5896_new_n1143
* NET  2240 = abc_5896_new_n1142
* NET  2241 = abc_5896_new_n1141
* NET  2242 = abc_5896_new_n1140
* NET  2243 = abc_5896_new_n1139
* NET  2244 = abc_5896_new_n1138
* NET  2245 = abc_5896_new_n1137
* NET  2246 = abc_5896_new_n1136
* NET  2247 = abc_5896_new_n1135
* NET  2248 = abc_5896_new_n1134
* NET  2249 = abc_5896_new_n1133
* NET  2250 = abc_5896_new_n1132
* NET  2251 = abc_5896_new_n1131
* NET  2252 = abc_5896_new_n1130
* NET  2253 = abc_5896_new_n1129
* NET  2254 = abc_5896_new_n1127
* NET  2255 = abc_5896_new_n1126
* NET  2256 = abc_5896_new_n1125
* NET  2257 = abc_5896_new_n1124
* NET  2258 = abc_5896_new_n1123
* NET  2259 = abc_5896_new_n1122
* NET  2260 = abc_5896_new_n1121
* NET  2261 = abc_5896_new_n1120
* NET  2262 = abc_5896_new_n1119
* NET  2263 = abc_5896_new_n1118
* NET  2264 = abc_5896_new_n1117
* NET  2265 = abc_5896_new_n1116
* NET  2266 = abc_5896_new_n1115
* NET  2267 = abc_5896_new_n1114
* NET  2268 = abc_5896_new_n1113
* NET  2269 = abc_5896_new_n1112
* NET  2270 = abc_5896_new_n1111
* NET  2271 = abc_5896_new_n1109
* NET  2272 = abc_5896_new_n1108
* NET  2273 = abc_5896_new_n1107
* NET  2274 = abc_5896_new_n1106
* NET  2275 = abc_5896_new_n1105
* NET  2276 = abc_5896_new_n1104
* NET  2277 = abc_5896_new_n1103
* NET  2278 = abc_5896_new_n1102
* NET  2279 = abc_5896_new_n1101
* NET  2280 = abc_5896_new_n1100
* NET  2281 = abc_5896_new_n1099
* NET  2282 = abc_5896_new_n1098
* NET  2283 = abc_5896_new_n1097
* NET  2284 = abc_5896_new_n1096
* NET  2285 = abc_5896_new_n1095
* NET  2286 = abc_5896_new_n1094
* NET  2287 = abc_5896_new_n1092
* NET  2288 = abc_5896_new_n1091
* NET  2289 = abc_5896_new_n1090
* NET  2290 = abc_5896_new_n1089
* NET  2291 = abc_5896_new_n1088
* NET  2292 = abc_5896_new_n1087
* NET  2293 = abc_5896_new_n1086
* NET  2294 = abc_5896_new_n1085
* NET  2295 = abc_5896_new_n1084
* NET  2296 = abc_5896_new_n1083
* NET  2297 = abc_5896_new_n1082
* NET  2298 = abc_5896_new_n1081
* NET  2299 = abc_5896_new_n1080
* NET  2300 = abc_5896_new_n1079
* NET  2301 = abc_5896_new_n1078
* NET  2302 = abc_5896_new_n1077
* NET  2303 = abc_5896_new_n1076
* NET  2304 = abc_5896_new_n1074
* NET  2305 = abc_5896_new_n1073
* NET  2306 = abc_5896_new_n1072
* NET  2307 = abc_5896_new_n1071
* NET  2308 = abc_5896_new_n1070
* NET  2309 = abc_5896_new_n1069
* NET  2310 = abc_5896_new_n1068
* NET  2311 = abc_5896_new_n1067
* NET  2312 = abc_5896_new_n1066
* NET  2313 = abc_5896_new_n1065
* NET  2314 = abc_5896_new_n1064
* NET  2315 = abc_5896_new_n1063
* NET  2316 = abc_5896_new_n1062
* NET  2317 = abc_5896_new_n1061
* NET  2318 = abc_5896_new_n1060
* NET  2319 = abc_5896_new_n1059
* NET  2320 = abc_5896_new_n1058
* NET  2321 = abc_5896_new_n1057
* NET  2322 = abc_5896_new_n1055
* NET  2323 = abc_5896_new_n1054
* NET  2324 = abc_5896_new_n1053
* NET  2325 = abc_5896_new_n1052
* NET  2326 = abc_5896_new_n1051
* NET  2327 = abc_5896_new_n1050
* NET  2328 = abc_5896_new_n1049
* NET  2329 = abc_5896_new_n1048
* NET  2330 = abc_5896_new_n1047
* NET  2331 = abc_5896_new_n1046
* NET  2332 = abc_5896_new_n1045
* NET  2333 = abc_5896_new_n1044
* NET  2334 = abc_5896_new_n1043
* NET  2335 = abc_5896_new_n1042
* NET  2336 = abc_5896_new_n1041
* NET  2337 = abc_5896_new_n1040
* NET  2338 = abc_5896_new_n1039
* NET  2339 = abc_5896_new_n1038
* NET  2340 = abc_5896_new_n1037
* NET  2341 = abc_5896_new_n1036
* NET  2342 = abc_5896_new_n1035
* NET  2343 = abc_5896_new_n1034
* NET  2344 = abc_5896_new_n1033
* NET  2345 = abc_5896_new_n1032
* NET  2346 = abc_5896_new_n1031
* NET  2347 = abc_5896_new_n1029
* NET  2348 = abc_5896_new_n1028
* NET  2349 = abc_5896_new_n1027
* NET  2350 = abc_5896_new_n1026
* NET  2351 = abc_5896_new_n1025
* NET  2352 = abc_5896_new_n1024
* NET  2353 = abc_5896_new_n1023
* NET  2354 = abc_5896_new_n1022
* NET  2355 = abc_5896_new_n1021
* NET  2356 = abc_5896_new_n1020
* NET  2357 = abc_5896_new_n1019
* NET  2358 = abc_5896_new_n1018
* NET  2359 = abc_5896_new_n1017
* NET  2360 = abc_5896_new_n1016
* NET  2361 = abc_5896_new_n1015
* NET  2362 = abc_5896_new_n1014
* NET  2363 = abc_5896_new_n1013
* NET  2364 = abc_5896_new_n1012
* NET  2365 = abc_5896_new_n1010
* NET  2366 = abc_5896_new_n1009
* NET  2367 = abc_5896_new_n1008
* NET  2368 = abc_5896_new_n1007
* NET  2369 = abc_5896_new_n1006
* NET  2370 = abc_5896_new_n1005
* NET  2371 = abc_5896_new_n1004
* NET  2372 = abc_5896_new_n1003
* NET  2373 = abc_5896_new_n1002
* NET  2374 = abc_5896_new_n1001
* NET  2375 = abc_5896_new_n1000
* NET  2376 = a_p[7]
* NET  2377 = a_p[6]
* NET  2378 = a_p[5]
* NET  2379 = a_p[4]
* NET  2380 = a_p[3]
* NET  2381 = a_p[2]
* NET  2382 = a_p[1]
* NET  2383 = a_p[0]
* NET  2384 = a[9]
* NET  2385 = a[8]
* NET  2386 = a[7]
* NET  2387 = a[6]
* NET  2388 = a[5]
* NET  2389 = a[4]
* NET  2390 = a[3]
* NET  2391 = a[2]
* NET  2392 = a[15]
* NET  2393 = a[14]
* NET  2394 = a[13]
* NET  2395 = a[12]
* NET  2396 = a[11]
* NET  2397 = a[10]
* NET  2398 = a[1]
* NET  2399 = a[0]

xsubckt_2246_and2_x1 67 66 924 925 1543 and2_x1
xsubckt_2155_and21nor_x0 67 66 1020 1054 1071 1074 and21nor_x0
xsubckt_1806_and3_x1 67 66 1388 1390 1394 871 and3_x1
xsubckt_1547_and3_x1 67 66 1640 1641 1642 1643 and3_x1
xsubckt_1316_and21nor_x0 67 66 1866 861 2169 1867 and21nor_x0
xsubckt_74_inv_x0 67 66 75 860 inv_x0
xsubckt_214_or3_x1 67 66 725 726 727 732 or3_x1
xsubckt_934_or2_x1 67 66 101 2239 2286 or2_x1
xsubckt_2187_or21nand_x0 67 66 986 1019 1032 1033 or21nand_x0
xsubckt_2154_and21nor_x0 67 66 1021 780 1022 1043 and21nor_x0
xsubckt_2030_nexor2_x0 67 66 1161 80 1154 nexor2_x0
xsubckt_1326_and3_x1 67 66 1856 1963 1080 183 and3_x1
xsubckt_1300_or21nand_x0 67 66 1881 2171 1885 1882 or21nand_x0
xsubckt_347_or21nand_x0 67 66 603 680 672 604 or21nand_x0
xsubckt_1115_and3_x1 67 66 2063 794 877 185 and3_x1
xsubckt_1162_nand2_x0 67 66 2016 2017 2020 nand2_x0
xsubckt_1209_or21nand_x0 67 66 1970 1980 1973 1971 or21nand_x0
xsubckt_1278_and21nor_x0 67 66 1903 1912 1909 1904 and21nor_x0
xsubckt_2181_and4_x1 67 66 992 73 883 1123 72 and4_x1
xsubckt_2172_nexor2_x0 67 66 1008 76 1002 nexor2_x0
xsubckt_2046_nexor2_x0 67 66 1139 1156 1137 nexor2_x0
xsubckt_1841_nand3_x0 67 66 1354 1452 1080 183 nand3_x0
xsubckt_1714_or21nand_x0 67 66 1478 1481 1482 770 or21nand_x0
xsubckt_1686_nand2_x0 67 66 1505 1509 31 nand2_x0
xsubckt_1668_or21nand_x0 67 66 1522 1523 1535 1112 or21nand_x0
xsubckt_1577_and2_x1 67 66 1610 1611 1112 and2_x1
xsubckt_1524_nexor2_x0 67 66 1664 1669 1662 nexor2_x0
xsubckt_531_xor2_x0 67 66 82 83 432 xor2_x0
xsubckt_395_xor2_x0 67 66 46 57 561 xor2_x0
xsubckt_784_and21nor_x0 67 66 193 201 200 195 and21nor_x0
xsubckt_818_nand2_x0 67 66 2348 2349 583 nand2_x0
xsubckt_998_nand3_x0 67 66 2177 73 1123 72 nand3_x0
xsubckt_1277_or3_x1 67 66 1904 1906 1907 792 or3_x1
xsubckt_2028_or3_x1 67 66 1157 1163 1167 870 or3_x1
xsubckt_1953_and21nor_x0 67 66 1237 1238 1239 1875 and21nor_x0
xsubckt_1724_or21nand_x0 67 66 1468 1470 1477 1490 or21nand_x0
xsubckt_1650_or21nand_x0 67 66 1540 1542 1544 796 or21nand_x0
xsubckt_390_mux2_x1 67 66 983 567 578 566 mux2_x1
xsubckt_126_nexor2_x0 67 66 812 1123 809 nexor2_x0
xsubckt_53_inv_x0 67 66 41 881 inv_x0
xsubckt_774_and21nor_x0 67 66 95 586 204 203 and21nor_x0
xsubckt_791_nexor2_x0 67 66 2375 190 2374 nexor2_x0
xsubckt_2333_dff_x1 67 66 119 186 77 dff_x1
xsubckt_1836_nand3_x0 67 66 1359 1517 184 1091 nand3_x0
xsubckt_1478_nexor2_x0 67 66 1745 885 1707 nexor2_x0
xsubckt_1288_or21nand_x0 67 66 1893 1941 1942 1946 or21nand_x0
xsubckt_34_inv_x0 67 66 88 941 inv_x0
xsubckt_759_or21nand_x0 67 66 217 236 233 235 or21nand_x0
xsubckt_827_or21nand_x0 67 66 2340 859 578 582 or21nand_x0
xsubckt_1369_nand3_x0 67 66 1814 1815 1069 184 nand3_x0
xsubckt_24_inv_x0 67 66 182 1048 inv_x0
xsubckt_1071_nand3_x0 67 66 2106 2209 80 1069 nand3_x0
xsubckt_586_nor2_x0 67 66 379 380 386 nor2_x0
xsubckt_428_or2_x1 67 66 530 38 58 or2_x1
xsubckt_288_and4_x1 67 66 656 674 681 796 1241 and4_x1
xsubckt_308_nor2_x0 67 66 638 639 661 nor2_x0
xsubckt_1160_nexor2_x0 67 66 2071 6 2018 nexor2_x0
xsubckt_2136_mux2_x1 67 66 85 61 183 1041 mux2_x1
xsubckt_2086_nand2_x0 67 66 1094 1095 796 nand2_x0
xsubckt_1966_and3_x1 67 66 1224 1225 1226 768 and3_x1
xsubckt_1788_mux2_x1 67 66 951 1407 2209 1406 mux2_x1
xsubckt_1495_nexor2_x0 67 66 1692 1714 1690 nexor2_x0
xsubckt_408_xor2_x0 67 66 59 39 549 xor2_x0
xsubckt_44_inv_x0 67 66 83 890 inv_x0
xsubckt_229_nand3_x0 67 66 711 718 734 739 nand3_x0
xsubckt_265_and2_x1 67 66 677 793 2388 and2_x1
xsubckt_916_nand2_x0 67 66 2255 2256 2259 nand2_x0
xsubckt_2083_and21nor_x0 67 66 1097 1138 1154 1158 and21nor_x0
xsubckt_2021_nand2_x0 67 66 1164 1169 791 nand2_x0
xsubckt_1986_nand3_x0 67 66 1202 1212 1215 872 nand3_x0
xsubckt_1920_or2_x1 67 66 1272 1274 187 or2_x1
xsubckt_1639_and21nor_x0 67 66 1550 1556 1553 1551 and21nor_x0
xsubckt_1561_and21nor_x0 67 66 1626 1668 1675 1678 and21nor_x0
xsubckt_1400_nand4_x0 67 66 1783 73 889 1123 1134 nand4_x0
xsubckt_427_or21nand_x0 67 66 531 552 551 550 or21nand_x0
xsubckt_254_and21nor_x0 67 66 687 688 814 65 and21nor_x0
xsubckt_261_nand2_x0 67 66 681 682 2387 nand2_x0
xsubckt_1132_and21nor_x0 67 66 2046 2047 2062 59 and21nor_x0
xsubckt_2166_nand3_x0 67 66 1009 1011 1012 1013 nand3_x0
xsubckt_484_or21nand_x0 67 66 477 513 495 478 or21nand_x0
xsubckt_397_and2_x1 67 66 559 560 583 and2_x1
xsubckt_109_nor2_x0 67 66 825 2397 2396 nor2_x0
xsubckt_762_nexor2_x0 67 66 4 24 214 nexor2_x0
xsubckt_1228_nor3_x0 67 66 1952 1953 1954 792 nor3_x0
xsubckt_2223_mux2_x1 67 66 888 886 682 948 mux2_x1
xsubckt_1734_mux2_x1 67 66 2392 1492 1101 1458 mux2_x1
xsubckt_1446_nand4_x0 67 66 1738 1880 857 859 861 nand4_x0
xsubckt_516_nexor2_x0 67 66 447 450 446 nexor2_x0
xsubckt_728_xor2_x0 67 66 6 81 246 xor2_x0
xsubckt_823_xor2_x0 67 66 1 79 2344 xor2_x0
xsubckt_842_nand3_x0 67 66 2325 2326 2330 2363 nand3_x0
xsubckt_1152_nand2_x0 67 66 2026 2027 2172 nand2_x0
xsubckt_2156_or21nand_x0 67 66 1019 1055 1072 1073 or21nand_x0
xsubckt_2066_and21nor_x0 67 66 1116 87 794 1117 and21nor_x0
xsubckt_1943_nexor2_x0 67 66 1255 24 1248 nexor2_x0
xsubckt_1863_or21nand_x0 67 66 1332 1366 1382 1383 or21nand_x0
xsubckt_1708_nand2_x0 67 66 1484 88 185 nand2_x0
xsubckt_1674_nand2_x0 67 66 1517 89 185 nand2_x0
xsubckt_105_nand2_x0 67 66 829 831 2386 nand2_x0
xsubckt_226_and21nor_x0 67 66 714 717 719 779 and21nor_x0
xsubckt_296_and4_x1 67 66 649 650 816 817 90 and4_x1
xsubckt_684_nor2_x0 67 66 288 14 25 nor2_x0
xsubckt_699_xor2_x0 67 66 27 7 274 xor2_x0
xsubckt_822_nand2_x0 67 66 2345 1 79 nand2_x0
xsubckt_907_or21nand_x0 67 66 2264 577 2266 2265 or21nand_x0
xsubckt_1200_and2_x1 67 66 1979 2029 909 and2_x1
xsubckt_2315_dff_x1 67 66 139 186 87 dff_x1
xsubckt_2290_dff_x1 67 66 175 186 2399 dff_x1
xsubckt_2236_nand4_x0 67 66 934 73 881 1123 72 nand4_x0
xsubckt_1932_nand2_x0 67 66 1260 1261 804 nand2_x0
xsubckt_1740_nand3_x0 67 66 1453 1520 184 1091 nand3_x0
xsubckt_325_and4_x1 67 66 623 2386 2385 2384 2396 and4_x1
xsubckt_49_inv_x0 67 66 45 885 inv_x0
xsubckt_319_and21nor_x0 67 66 628 1263 636 641 and21nor_x0
xsubckt_881_or21nand_x0 67 66 2288 2289 2290 586 or21nand_x0
xsubckt_2356_dff_x1 67 66 98 186 7 dff_x1
xsubckt_2224_nand2_x0 67 66 947 949 74 nand2_x0
xsubckt_2198_or21nand_x0 67 66 975 981 979 976 or21nand_x0
xsubckt_1359_mux2_x1 67 66 1824 55 65 141 mux2_x1
xsubckt_1330_and4_x1 67 66 1852 1853 1854 1855 768 and4_x1
xsubckt_1014_and3_x1 67 66 2162 794 28 185 and3_x1
xsubckt_1205_and3_x1 67 66 1974 1975 1976 2177 and3_x1
xsubckt_2317_dff_x1 67 66 151 186 85 dff_x1
xsubckt_2292_dff_x1 67 66 167 186 2391 dff_x1
xsubckt_2107_nexor2_x0 67 66 1077 866 1072 nexor2_x0
xsubckt_1962_nand3_x0 67 66 1228 1407 184 1091 nand3_x0
xsubckt_1786_nand3_x0 67 66 1408 1489 184 1091 nand3_x0
xsubckt_1329_nand2_x0 67 66 1853 2208 81 nand2_x0
xsubckt_573_nor2_x0 67 66 392 45 85 nor2_x0
xsubckt_425_and21nor_x0 67 66 533 535 538 586 and21nor_x0
xsubckt_362_nand2_x0 67 66 591 593 184 nand2_x0
xsubckt_69_inv_x0 67 66 4 865 inv_x0
xsubckt_668_and2_x1 67 66 303 875 24 and2_x1
xsubckt_923_nexor2_x0 67 66 2250 2253 2249 nexor2_x0
xsubckt_924_and21nor_x0 67 66 2248 852 577 583 and21nor_x0
xsubckt_1031_nand2_x0 67 66 2145 2147 579 nand2_x0
xsubckt_1246_and3_x1 67 66 1934 2029 895 909 and3_x1
xsubckt_1614_and21nor_x0 67 66 1574 1576 1582 795 and21nor_x0
xsubckt_1405_or21nand_x0 67 66 1778 1827 1840 1841 or21nand_x0
xsubckt_1355_or21nand_x0 67 66 1827 1894 1896 1897 or21nand_x0
xsubckt_561_or21nand_x0 67 66 403 32 578 582 or21nand_x0
xsubckt_456_and2_x1 67 66 503 37 88 and2_x1
xsubckt_790_xor2_x0 67 66 3 81 2375 xor2_x0
xsubckt_996_nand2_x0 67 66 2179 73 1123 nand2_x0
xsubckt_1015_nand3_x0 67 66 2161 794 28 185 nand3_x0
xsubckt_1249_mux2_x1 67 66 1123 994 848 1931 mux2_x1
xsubckt_2342_dff_x1 67 66 128 186 37 dff_x1
xsubckt_2178_and2_x1 67 66 996 1622 2169 and2_x1
xsubckt_1885_and2_x1 67 66 1311 84 185 and2_x1
xsubckt_1843_nand3_x0 67 66 1352 748 88 183 nand3_x0
xsubckt_1671_nand2_x0 67 66 1520 57 185 nand2_x0
xsubckt_1515_nand3_x0 67 66 1671 1680 1686 894 nand3_x0
xsubckt_603_or21nand_x0 67 66 363 364 370 586 or21nand_x0
xsubckt_514_and2_x1 67 66 448 34 88 and2_x1
xsubckt_192_or2_x1 67 66 747 185 184 or2_x1
xsubckt_676_nand2_x0 67 66 296 30 15 nand2_x0
xsubckt_1213_and3_x1 67 66 1967 794 876 185 and3_x1
xsubckt_2019_and3_x1 67 66 1167 794 920 185 and3_x1
xsubckt_1928_nand4_x0 67 66 1265 83 185 184 183 nand4_x0
xsubckt_1926_nand2_x0 67 66 1267 2208 56 nand2_x0
xsubckt_1700_and21nor_x0 67 66 1492 1496 1494 1493 and21nor_x0
xsubckt_1634_and3_x1 67 66 1555 1616 851 852 and3_x1
xsubckt_437_xor2_x0 67 66 38 89 521 xor2_x0
xsubckt_435_nor2_x0 67 66 523 38 89 nor2_x0
xsubckt_1058_nand4_x0 67 66 2118 2119 2122 2123 2177 nand4_x0
xsubckt_2340_dff_x1 67 66 130 186 39 dff_x1
xsubckt_2184_or21nand_x0 67 66 989 996 993 990 or21nand_x0
xsubckt_2023_nand2_x0 67 66 1162 1168 791 nand2_x0
xsubckt_2005_and21nor_x0 67 66 109 1182 1195 1230 and21nor_x0
xsubckt_1818_and2_x1 67 66 1376 2175 27 and2_x1
xsubckt_1530_nand2_x0 67 66 1656 1657 2177 nand2_x0
xsubckt_1299_and3_x1 67 66 1882 1883 1884 2177 and3_x1
xsubckt_542_or21nand_x0 67 66 421 889 578 582 or21nand_x0
xsubckt_455_or2_x1 67 66 504 37 88 or2_x1
xsubckt_407_nand2_x0 67 66 550 59 39 nand2_x0
xsubckt_65_inv_x0 67 66 6 869 inv_x0
xsubckt_943_nand3_x0 67 66 2230 2246 2260 2261 nand3_x0
xsubckt_1003_and2_x1 67 66 2172 2176 1134 and2_x1
xsubckt_1145_nand2_x0 67 66 2033 2034 796 nand2_x0
xsubckt_1917_nand4_x0 67 66 1276 73 36 1123 72 nand4_x0
xsubckt_1770_and2_x1 67 66 1423 2175 28 and2_x1
xsubckt_1704_mux2_x1 67 66 57 56 185 1488 mux2_x1
xsubckt_1551_nand2_x0 67 66 1636 1638 84 nand2_x0
xsubckt_1351_or21nand_x0 67 66 1831 1890 1895 1899 or21nand_x0
xsubckt_841_nexor2_x0 67 66 74 75 2326 nexor2_x0
xsubckt_846_and21nor_x0 67 66 92 586 2333 2322 and21nor_x0
xsubckt_1250_nor2_x0 67 66 1930 1931 1932 nor2_x0
xsubckt_2278_and21nor_x0 67 66 178 896 813 840 and21nor_x0
xsubckt_2006_nand3_x0 67 66 1181 1358 184 1091 nand3_x0
xsubckt_1965_nand2_x0 67 66 1225 2208 89 nand2_x0
xsubckt_150_and2_x1 67 66 787 790 2398 and2_x1
xsubckt_175_or21nand_x0 67 66 763 767 769 2391 or21nand_x0
xsubckt_246_nand3_x0 67 66 695 701 709 721 nand3_x0
xsubckt_655_or2_x1 67 66 132 315 378 or2_x1
xsubckt_797_xor2_x0 67 66 3 78 2368 xor2_x0
xsubckt_1073_and3_x1 67 66 2104 2105 2106 2107 and3_x1
xsubckt_2277_nand2_x0 67 66 896 64 65 nand2_x0
xsubckt_2081_nexor2_x0 67 66 1102 1103 1099 nexor2_x0
xsubckt_609_nexor2_x0 67 66 359 360 358 nexor2_x0
xsubckt_447_nexor2_x0 67 66 514 516 512 nexor2_x0
xsubckt_122_and4_x1 67 66 812 816 817 72 90 and4_x1
xsubckt_112_and3_x1 67 66 822 825 826 1284 and3_x1
xsubckt_198_nand2_x0 67 66 741 743 2390 nand2_x0
xsubckt_1111_or21nand_x0 67 66 2066 2072 2069 2067 or21nand_x0
xsubckt_2322_dff_x1 67 66 122 186 31 dff_x1
xsubckt_2289_dff_x1 67 66 155 186 71 dff_x1
xsubckt_1862_and21nor_x0 67 66 1333 1365 1381 1384 and21nor_x0
xsubckt_1358_or21nand_x0 67 66 1824 796 1829 1825 or21nand_x0
xsubckt_1335_and2_x1 67 66 1847 1848 579 and2_x1
xsubckt_274_or21nand_x0 67 66 668 672 670 669 or21nand_x0
xsubckt_726_nor2_x0 67 66 248 6 81 nor2_x0
xsubckt_743_nexor2_x0 67 66 233 234 232 nexor2_x0
xsubckt_906_and21nor_x0 67 66 2265 853 577 583 and21nor_x0
xsubckt_1134_and3_x1 67 66 2044 2047 2062 59 and3_x1
xsubckt_2332_dff_x1 67 66 120 186 78 dff_x1
xsubckt_2141_or21nand_x0 67 66 1035 580 1040 1036 or21nand_x0
xsubckt_1847_nand2_x0 67 66 1348 1351 1353 nand2_x0
xsubckt_1746_and3_x1 67 66 1447 1517 1080 183 and3_x1
xsubckt_1712_nand3_x0 67 66 1480 2209 89 1069 nand3_x0
xsubckt_1586_nand2_x0 67 66 1602 1603 1604 nand2_x0
xsubckt_1554_nexor2_x0 67 66 1638 892 1633 nexor2_x0
xsubckt_1540_or21nand_x0 67 66 1646 1647 1649 1112 or21nand_x0
xsubckt_590_or21nand_x0 67 66 376 392 389 391 or21nand_x0
xsubckt_525_or21nand_x0 67 66 437 445 444 438 or21nand_x0
xsubckt_470_nexor2_x0 67 66 36 56 490 nexor2_x0
xsubckt_422_nand2_x0 67 66 536 87 88 nand2_x0
xsubckt_734_nor2_x0 67 66 241 242 243 nor2_x0
xsubckt_2014_or21nand_x0 67 66 1172 1176 1175 1173 or21nand_x0
xsubckt_1382_nexor2_x0 67 66 1806 941 1801 nexor2_x0
xsubckt_1373_and2_x1 67 66 1810 1811 791 and2_x1
xsubckt_853_or2_x1 67 66 2315 0 78 or2_x1
xsubckt_1085_and2_x1 67 66 2092 2093 2108 and2_x1
xsubckt_1170_mux2_x1 67 66 877 184 183 2009 mux2_x1
xsubckt_2150_nor2_x0 67 66 1025 1029 1031 nor2_x0
xsubckt_1884_nand3_x0 67 66 1312 2209 85 1069 nand3_x0
xsubckt_1839_nand3_x0 67 66 1356 2209 86 1069 nand3_x0
xsubckt_1606_nexor2_x0 67 66 1590 890 1582 nexor2_x0
xsubckt_95_inv_x0 67 66 68 839 inv_x0
xsubckt_28_inv_x0 67 66 56 1005 inv_x0
xsubckt_674_nexor2_x0 67 66 303 872 298 nexor2_x0
xsubckt_825_nexor2_x0 67 66 2343 2344 2342 nexor2_x0
xsubckt_901_nor2_x0 67 66 2270 11 75 nor2_x0
xsubckt_903_xor2_x0 67 66 11 75 2268 xor2_x0
xsubckt_1808_and21nor_x0 67 66 1386 1390 1394 871 and21nor_x0
xsubckt_1347_nand2_x0 67 66 1835 1843 962 nand2_x0
xsubckt_541_and2_x1 67 66 422 423 578 and2_x1
xsubckt_327_or2_x1 67 66 621 622 661 or2_x1
xsubckt_50_inv_x0 67 66 44 884 inv_x0
xsubckt_798_nexor2_x0 67 66 2368 2371 2367 nexor2_x0
xsubckt_871_nexor2_x0 67 66 13 77 2298 nexor2_x0
xsubckt_1035_and21nor_x0 67 66 2141 2148 2146 2142 and21nor_x0
xsubckt_1181_and21nor_x0 67 66 1998 2007 2004 1999 and21nor_x0
xsubckt_2226_nand2_x0 67 66 945 948 74 nand2_x0
xsubckt_2109_or21nand_x0 67 66 1070 1108 1100 1105 or21nand_x0
xsubckt_1972_and2_x1 67 66 1217 1218 1229 and2_x1
xsubckt_345_and3_x1 67 66 605 187 2395 2394 and3_x1
xsubckt_17_inv_x0 67 66 71 1123 inv_x0
xsubckt_746_or2_x1 67 66 229 5 80 or2_x1
xsubckt_908_and2_x1 67 66 2263 11 29 and2_x1
xsubckt_931_nand3_x0 67 66 2241 2243 2257 2262 nand3_x0
xsubckt_944_nand3_x0 67 66 2229 2245 2257 2262 nand3_x0
xsubckt_990_or21nand_x0 67 66 2185 2194 2190 2188 or21nand_x0
xsubckt_1108_and21nor_x0 67 66 2069 72 2070 2179 and21nor_x0
xsubckt_2177_and21nor_x0 67 66 997 999 1002 779 and21nor_x0
xsubckt_2036_nand2_x0 67 66 1148 1149 2177 nand2_x0
xsubckt_1784_nand3_x0 67 66 1410 767 57 184 nand3_x0
xsubckt_1710_mux2_x1 67 66 62 1485 2209 1482 mux2_x1
xsubckt_1599_nand3_x0 67 66 1589 1591 1592 1593 nand3_x0
xsubckt_556_or2_x1 67 66 408 32 86 or2_x1
xsubckt_360_or3_x1 67 66 592 182 185 187 or3_x1
xsubckt_334_and2_x1 67 66 171 615 616 and2_x1
xsubckt_67_inv_x0 67 66 5 867 inv_x0
xsubckt_2108_nexor2_x0 67 66 1077 78 1071 nexor2_x0
xsubckt_1646_nexor2_x0 67 66 29 61 1544 nexor2_x0
xsubckt_1589_nexor2_x0 67 66 1616 10 1599 nexor2_x0
xsubckt_1292_or21nand_x0 67 66 1889 1937 1943 1944 or21nand_x0
xsubckt_559_nexor2_x0 67 66 406 409 405 nexor2_x0
xsubckt_155_nexor2_x0 67 66 784 786 782 nexor2_x0
xsubckt_241_nexor2_x0 67 66 794 2388 700 nexor2_x0
xsubckt_2300_dff_x1 67 66 173 186 2397 dff_x1
xsubckt_2275_and2_x1 67 66 897 898 70 and2_x1
xsubckt_2113_nand2_x0 67 66 1065 1708 2169 nand2_x0
xsubckt_1509_nand2_x0 67 66 1677 1679 894 nand2_x0
xsubckt_564_nand2_x0 67 66 400 32 83 nand2_x0
xsubckt_443_nor2_x0 67 66 516 517 518 nor2_x0
xsubckt_418_or21nand_x0 67 66 539 583 547 540 or21nand_x0
xsubckt_303_nexor2_x0 67 66 643 2384 642 nexor2_x0
xsubckt_865_and21nor_x0 67 66 91 2304 2310 2317 and21nor_x0
xsubckt_911_and21nor_x0 67 66 2260 2277 2275 2276 and21nor_x0
xsubckt_942_or21nand_x0 67 66 2231 577 2233 2232 or21nand_x0
xsubckt_983_nand3_x0 67 66 2192 806 27 1091 nand3_x0
xsubckt_1130_and21nor_x0 67 66 2048 2057 2054 2049 and21nor_x0
xsubckt_1135_nand3_x0 67 66 2043 2047 2062 59 nand3_x0
xsubckt_1154_mux2_x1 67 66 59 71 73 2024 mux2_x1
xsubckt_2314_dff_x1 67 66 140 186 88 dff_x1
xsubckt_2291_dff_x1 67 66 174 186 2398 dff_x1
xsubckt_2199_nand3_x0 67 66 974 794 82 185 nand3_x0
xsubckt_2145_and3_x1 67 66 1031 1035 1038 77 and3_x1
xsubckt_1976_and2_x1 67 66 1213 1214 1218 and2_x1
xsubckt_1809_or21nand_x0 67 66 1385 1391 1395 27 or21nand_x0
xsubckt_620_nand2_x0 67 66 347 348 351 nand2_x0
xsubckt_75_inv_x0 67 66 1 859 inv_x0
xsubckt_273_nand2_x0 67 66 669 1101 2387 nand2_x0
xsubckt_712_nor2_x0 67 66 262 79 80 nor2_x0
xsubckt_1166_and3_x1 67 66 2013 794 875 185 and3_x1
xsubckt_1850_nand3_x0 67 66 1345 794 994 185 nand3_x0
xsubckt_1741_nand2_x0 67 66 1452 87 185 nand2_x0
xsubckt_284_and2_x1 67 66 659 660 665 and2_x1
xsubckt_834_or21nand_x0 67 66 2333 2341 2340 2334 or21nand_x0
xsubckt_1143_or21nand_x0 67 66 2035 2085 2087 2088 or21nand_x0
xsubckt_1436_and21nor_x0 67 66 1748 1798 1801 1805 and21nor_x0
xsubckt_591_or2_x1 67 66 375 44 84 or2_x1
xsubckt_15_inv_x0 67 66 90 1144 inv_x0
xsubckt_201_nexor2_x0 67 66 743 1166 738 nexor2_x0
xsubckt_267_nand3_x0 67 66 675 676 678 693 nand3_x0
xsubckt_2142_mux2_x1 67 66 84 1039 791 1034 mux2_x1
xsubckt_1996_nand2_x0 67 66 1191 1862 2172 nand2_x0
xsubckt_1909_and21nor_x0 67 66 1285 1327 1334 1337 and21nor_x0
xsubckt_1861_nexor2_x0 67 66 1340 877 1334 nexor2_x0
xsubckt_1814_nexor2_x0 67 66 1389 871 1380 nexor2_x0
xsubckt_1447_nexor2_x0 67 66 1796 0 1737 nexor2_x0
xsubckt_526_mux2_x1 67 66 437 451 587 125 mux2_x1
xsubckt_662_or2_x1 67 66 308 309 310 or2_x1
xsubckt_690_mux2_x1 67 66 283 298 587 105 mux2_x1
xsubckt_731_or21nand_x0 67 66 97 244 250 257 or21nand_x0
xsubckt_905_nexor2_x0 67 66 2267 2268 2266 nexor2_x0
xsubckt_1118_nand4_x0 67 66 2060 78 185 184 183 nand4_x0
xsubckt_2336_dff_x1 67 66 116 186 74 dff_x1
xsubckt_2133_nand3_x0 67 66 1044 1045 1046 779 nand3_x0
xsubckt_1987_nexor2_x0 67 66 1211 81 1201 nexor2_x0
xsubckt_1969_nand3_x0 67 66 1221 748 85 183 nand3_x0
xsubckt_1474_and21nor_x0 67 66 1711 1747 1755 1758 and21nor_x0
xsubckt_1324_and21nor_x0 67 66 1858 1864 1861 1859 and21nor_x0
xsubckt_587_nor2_x0 67 66 136 379 393 nor2_x0
xsubckt_365_or3_x1 67 66 589 182 183 187 or3_x1
xsubckt_35_inv_x0 67 66 38 930 inv_x0
xsubckt_754_nand2_x0 67 66 222 238 240 nand2_x0
xsubckt_1280_and2_x1 67 66 1901 1902 1918 and2_x1
xsubckt_2209_nand2_x0 67 66 963 969 860 nand2_x0
xsubckt_1785_and3_x1 67 66 1409 1489 184 1091 and3_x1
xsubckt_1598_and3_x1 67 66 1590 1591 1592 1593 and3_x1
xsubckt_1388_nand3_x0 67 66 1795 1880 859 861 nand3_x0
xsubckt_414_xor2_x0 67 66 39 56 543 xor2_x0
xsubckt_85_inv_x0 67 66 63 849 inv_x0
xsubckt_289_nand4_x0 67 66 655 674 681 796 1241 nand4_x0
xsubckt_847_xor2_x0 67 66 29 74 2321 xor2_x0
xsubckt_2327_dff_x1 67 66 111 186 25 dff_x1
xsubckt_2035_nand2_x0 67 66 1149 2175 80 nand2_x0
xsubckt_1857_nand3_x0 67 66 1338 1341 1345 26 nand3_x0
xsubckt_1500_nand2_x0 67 66 1686 1964 794 nand2_x0
xsubckt_1497_and2_x1 67 66 1688 1689 1693 and2_x1
xsubckt_439_or21nand_x0 67 66 519 520 582 586 or21nand_x0
xsubckt_310_and21nor_x0 67 66 636 828 656 814 and21nor_x0
xsubckt_946_nand3_x0 67 66 2227 2229 2236 2246 nand3_x0
xsubckt_1128_and3_x1 67 66 2050 2051 2052 791 and3_x1
xsubckt_61_inv_x0 67 66 28 873 inv_x0
xsubckt_649_and3_x1 67 66 320 321 328 338 and3_x1
xsubckt_958_or2_x1 67 66 2216 2217 2218 or2_x1
xsubckt_1117_nand3_x0 67 66 2061 2209 79 1069 nand3_x0
xsubckt_1266_nand4_x0 67 66 1915 75 185 184 183 nand4_x0
xsubckt_368_and2_x1 67 66 587 683 182 and2_x1
xsubckt_324_nand3_x0 67 66 624 656 825 828 nand3_x0
xsubckt_93_inv_x0 67 66 17 841 inv_x0
xsubckt_1042_nand3_x0 67 66 2134 2140 2161 62 nand3_x0
xsubckt_1075_and4_x1 67 66 2102 872 185 1080 183 and4_x1
xsubckt_1110_and2_x1 67 66 2067 2068 1101 and2_x1
xsubckt_1165_and2_x1 67 66 145 2014 2033 and2_x1
xsubckt_2311_dff_x1 67 66 143 186 57 dff_x1
xsubckt_2294_dff_x1 67 66 165 186 2389 dff_x1
xsubckt_2270_nand2_x0 67 66 901 2206 187 nand2_x0
xsubckt_1664_nand4_x0 67 66 1526 73 880 1123 1134 nand4_x0
xsubckt_1418_nand3_x0 67 66 1766 767 77 184 nand3_x0
xsubckt_1409_and2_x1 67 66 1774 1775 1779 and2_x1
xsubckt_216_mux2_x1 67 66 724 725 813 723 mux2_x1
xsubckt_751_nand2_x0 67 66 224 225 583 nand2_x0
xsubckt_2064_or21nand_x0 67 66 1118 1119 1120 1069 or21nand_x0
xsubckt_1941_nand3_x0 67 66 1250 1256 1258 24 nand3_x0
xsubckt_611_or21nand_x0 67 66 356 577 358 357 or21nand_x0
xsubckt_511_nexor2_x0 67 66 452 455 451 nexor2_x0
xsubckt_224_or21nand_x0 67 66 716 731 737 741 or21nand_x0
xsubckt_800_or21nand_x0 67 66 2365 2373 2372 2366 or21nand_x0
xsubckt_1191_and21nor_x0 67 66 1988 2036 2039 2042 and21nor_x0
xsubckt_1196_nexor2_x0 67 66 1985 1991 1983 nexor2_x0
xsubckt_1203_nand2_x0 67 66 1976 2175 58 nand2_x0
xsubckt_2074_or21nand_x0 67 66 1107 1115 1126 79 or21nand_x0
xsubckt_1956_nor2_x0 67 66 1234 1235 1236 nor2_x0
xsubckt_1869_nexor2_x0 67 66 1328 1334 1326 nexor2_x0
xsubckt_1790_and3_x1 67 66 1404 1405 1406 768 and3_x1
xsubckt_1685_and2_x1 67 66 1506 1509 31 and2_x1
xsubckt_1567_and21nor_x0 67 66 1620 71 73 84 and21nor_x0
xsubckt_1387_and3_x1 67 66 1796 1880 859 861 and3_x1
xsubckt_494_nand2_x0 67 66 467 35 89 nand2_x0
xsubckt_140_nand4_x0 67 66 797 798 816 817 90 nand4_x0
xsubckt_915_and21nor_x0 67 66 2256 2260 2261 582 and21nor_x0
xsubckt_961_nand3_x0 67 66 2213 2214 2215 583 nand3_x0
xsubckt_1063_and4_x1 67 66 2113 73 46 1123 1134 and4_x1
xsubckt_2262_nand2_x0 67 66 115 907 950 nand2_x0
xsubckt_1820_nand3_x0 67 66 1374 1375 1377 2177 nand3_x0
xsubckt_1345_nand3_x0 67 66 1837 1844 1857 89 nand3_x0
xsubckt_1293_nexor2_x0 67 66 1890 1895 1888 nexor2_x0
xsubckt_571_nand3_x0 67 66 394 395 683 182 nand3_x0
xsubckt_557_and2_x1 67 66 407 32 86 and2_x1
xsubckt_352_or21nand_x0 67 66 598 599 813 1112 or21nand_x0
xsubckt_271_and3_x1 67 66 671 679 697 703 and3_x1
xsubckt_283_nand3_x0 67 66 660 661 662 813 nand3_x0
xsubckt_686_xor2_x0 67 66 14 25 286 xor2_x0
xsubckt_1060_nexor2_x0 67 66 14 15 2116 nexor2_x0
xsubckt_2186_and21nor_x0 67 66 987 998 997 988 and21nor_x0
xsubckt_2050_nand2_x0 67 66 1133 1737 2172 nand2_x0
xsubckt_1830_nexor2_x0 67 66 1366 1379 1364 nexor2_x0
xsubckt_1538_nand4_x0 67 66 1648 73 884 1123 1134 nand4_x0
xsubckt_1526_nexor2_x0 67 66 1709 44 1660 nexor2_x0
xsubckt_1451_and21nor_x0 67 66 1733 1740 1736 1734 and21nor_x0
xsubckt_1331_nand3_x0 67 66 1851 748 77 183 nand3_x0
xsubckt_477_nexor2_x0 67 66 36 87 483 nexor2_x0
xsubckt_340_mux2_x1 67 66 821 611 813 609 mux2_x1
xsubckt_210_nand2_x0 67 66 729 731 737 nand2_x0
xsubckt_811_and2_x1 67 66 2355 2356 578 and2_x1
xsubckt_1231_or21nand_x0 67 66 1949 1960 1955 1952 or21nand_x0
xsubckt_1244_or21nand_x0 67 66 1936 1985 1991 1992 or21nand_x0
xsubckt_1893_and2_x1 67 66 1302 1303 804 and2_x1
xsubckt_1800_nand3_x0 67 66 1394 794 1015 185 nand3_x0
xsubckt_1325_nand3_x0 67 66 1857 794 870 185 nand3_x0
xsubckt_601_nexor2_x0 67 66 366 369 365 nexor2_x0
xsubckt_765_or21nand_x0 67 66 211 865 578 582 or21nand_x0
xsubckt_1116_nand3_x0 67 66 2062 794 877 185 nand3_x0
xsubckt_1120_and3_x1 67 66 2058 2059 2060 2061 and3_x1
xsubckt_1193_nand2_x0 67 66 1986 1987 796 nand2_x0
xsubckt_2218_and21nor_x0 67 66 953 955 961 795 and21nor_x0
xsubckt_1897_or21nand_x0 67 66 1298 1301 1299 1300 or21nand_x0
xsubckt_1709_mux2_x1 67 66 1026 1484 2209 1483 mux2_x1
xsubckt_1675_mux2_x1 67 66 849 1517 2209 1516 mux2_x1
xsubckt_1656_nexor2_x0 67 66 1561 880 1534 nexor2_x0
xsubckt_1651_and21nor_x0 67 66 1539 1564 1565 1568 and21nor_x0
xsubckt_602_and2_x1 67 66 364 365 583 and2_x1
xsubckt_141_and2_x1 67 66 796 187 1306 and2_x1
xsubckt_134_and2_x1 67 66 802 803 187 and2_x1
xsubckt_1126_nand3_x0 67 66 2052 806 24 1091 nand3_x0
xsubckt_1185_or21nand_x0 67 66 1994 1998 2013 58 or21nand_x0
xsubckt_2169_nand2_x0 67 66 1006 1007 76 nand2_x0
xsubckt_2001_and4_x1 67 66 1185 73 891 1123 72 and4_x1
xsubckt_1463_or21nand_x0 67 66 1722 1723 1724 1728 or21nand_x0
xsubckt_1333_or21nand_x0 67 66 1849 1856 1852 1850 or21nand_x0
xsubckt_433_and21nor_x0 67 66 525 578 527 526 and21nor_x0
xsubckt_39_inv_x0 67 66 36 895 inv_x0
xsubckt_0_inv_x0 67 66 2392 1306 inv_x0
xsubckt_181_nand2_x0 67 66 757 758 796 nand2_x0
xsubckt_767_nor2_x0 67 66 209 4 79 nor2_x0
xsubckt_864_and21nor_x0 67 66 2304 2305 583 587 and21nor_x0
xsubckt_1121_nand3_x0 67 66 2057 2059 2060 2061 nand3_x0
xsubckt_1175_and3_x1 67 66 2004 2005 2006 807 and3_x1
xsubckt_2049_mux2_x1 67 66 1135 22 65 108 mux2_x1
xsubckt_2025_and21nor_x0 67 66 1160 1162 1165 870 and21nor_x0
xsubckt_1975_and2_x1 67 66 1214 1229 791 and2_x1
xsubckt_1859_or21nand_x0 67 66 1336 1342 1346 26 or21nand_x0
xsubckt_1536_and21nor_x0 67 66 1650 72 1651 2179 and21nor_x0
xsubckt_1429_or2_x1 67 66 1755 1763 87 or2_x1
xsubckt_1309_nand2_x0 67 66 1872 1873 1876 nand2_x0
xsubckt_548_nand2_x0 67 66 415 416 583 nand2_x0
xsubckt_276_and3_x1 67 66 666 833 1220 1231 and3_x1
xsubckt_1005_and2_x1 67 66 2170 73 1134 and2_x1
xsubckt_2225_and2_x1 67 66 946 948 74 and2_x1
xsubckt_2182_and4_x1 67 66 991 73 853 1123 1134 and4_x1
xsubckt_1769_nand3_x0 67 66 1424 2076 2078 2169 nand3_x0
xsubckt_1729_nexor2_x0 67 66 1469 878 1463 nexor2_x0
xsubckt_1669_nand2_x0 67 66 147 1522 1572 nand2_x0
xsubckt_73_inv_x0 67 66 2 861 inv_x0
xsubckt_880_or21nand_x0 67 66 2289 2291 2292 583 or21nand_x0
xsubckt_2253_and2_x1 67 66 916 1528 2170 and2_x1
xsubckt_1985_and3_x1 67 66 1203 1212 1215 872 and3_x1
xsubckt_1952_and21nor_x0 67 66 1238 1878 2172 2178 and21nor_x0
xsubckt_524_nand2_x0 67 66 438 439 583 nand2_x0
xsubckt_401_xor2_x0 67 66 88 89 556 xor2_x0
xsubckt_322_or21nand_x0 67 66 625 627 630 1273 or21nand_x0
xsubckt_692_nand2_x0 67 66 281 80 81 nand2_x0
xsubckt_969_nand3_x0 67 66 2206 185 184 183 nand3_x0
xsubckt_977_nand2_x0 67 66 2198 2200 746 nand2_x0
xsubckt_1044_or21nand_x0 67 66 2132 2141 2162 1026 or21nand_x0
xsubckt_1224_and3_x1 67 66 1956 1957 1958 807 and3_x1
xsubckt_2173_nexor2_x0 67 66 1008 862 1001 nexor2_x0
xsubckt_2075_and3_x1 67 66 1106 1114 1125 868 and3_x1
xsubckt_1719_or21nand_x0 67 66 1473 58 1080 1091 or21nand_x0
xsubckt_1715_and21nor_x0 67 66 1477 1478 1486 808 and21nor_x0
xsubckt_530_nand2_x0 67 66 433 82 83 nand2_x0
xsubckt_394_nand2_x0 67 66 562 46 57 nand2_x0
xsubckt_258_and2_x1 67 66 684 1058 65 and2_x1
xsubckt_1198_nexor2_x0 67 66 2019 5 1981 nexor2_x0
xsubckt_2346_dff_x1 67 66 124 186 33 dff_x1
xsubckt_2207_nand4_x0 67 66 965 971 972 974 75 nand4_x0
xsubckt_1601_and4_x1 67 66 1587 1591 1592 1593 83 and4_x1
xsubckt_1424_nor2_x0 67 66 1760 1763 920 nor2_x0
xsubckt_1386_nexor2_x0 67 66 1799 1800 1797 nexor2_x0
xsubckt_610_and21nor_x0 67 66 357 883 577 583 and21nor_x0
xsubckt_467_or21nand_x0 67 66 493 511 508 510 or21nand_x0
xsubckt_262_and2_x1 67 66 680 683 2387 and2_x1
xsubckt_801_and21nor_x0 67 66 94 586 2365 191 and21nor_x0
xsubckt_812_or21nand_x0 67 66 2354 2 578 582 or21nand_x0
xsubckt_1149_nor4_x0 67 66 2029 38 39 46 47 nor4_x0
xsubckt_2167_mux2_x1 67 66 890 1010 791 1008 mux2_x1
xsubckt_1663_and21nor_x0 67 66 1527 72 1529 2179 and21nor_x0
xsubckt_1597_nand2_x0 67 66 1591 683 75 nand2_x0
xsubckt_1423_nand2_x0 67 66 1761 1763 920 nand2_x0
xsubckt_1304_or21nand_x0 67 66 1877 1134 1878 2180 or21nand_x0
xsubckt_1298_nand2_x0 67 66 1883 2175 56 nand2_x0
xsubckt_472_and2_x1 67 66 488 489 578 and2_x1
xsubckt_330_mux2_x1 67 66 823 620 813 618 mux2_x1
xsubckt_2_inv_x0 67 66 2395 1284 inv_x0
xsubckt_174_and21nor_x0 67 66 764 766 768 1177 and21nor_x0
xsubckt_2078_nand2_x0 67 66 1103 1109 1111 nand2_x0
xsubckt_534_nexor2_x0 67 66 432 435 429 nexor2_x0
xsubckt_498_or21nand_x0 67 66 463 893 578 582 or21nand_x0
xsubckt_111_nand2_x0 67 66 823 825 826 nand2_x0
xsubckt_238_nand2_x0 67 66 703 794 2388 nand2_x0
xsubckt_735_nand2_x0 67 66 240 78 79 nand2_x0
xsubckt_780_nand2_x0 67 66 197 76 77 nand2_x0
xsubckt_1138_and21nor_x0 67 66 2040 2047 2062 951 and21nor_x0
xsubckt_2191_and2_x1 67 66 982 841 65 and2_x1
xsubckt_2124_nexor2_x0 67 66 1055 1072 1053 nexor2_x0
xsubckt_2094_nand3_x0 67 66 1086 806 83 1091 nand3_x0
xsubckt_1467_and3_x1 67 66 1718 1720 1729 86 and3_x1
xsubckt_441_nor3_x0 67 66 518 537 554 555 nor3_x0
xsubckt_80_inv_x0 67 66 12 854 inv_x0
xsubckt_272_or2_x1 67 66 670 671 779 or2_x1
xsubckt_1864_nand2_x0 67 66 1331 1332 1335 nand2_x0
xsubckt_1619_mux2_x1 67 66 858 856 682 1570 mux2_x1
xsubckt_1588_and2_x1 67 66 1600 1616 852 and2_x1
xsubckt_1566_nexor2_x0 67 66 1661 883 1621 nexor2_x0
xsubckt_1366_nand3_x0 67 66 1817 748 76 183 nand3_x0
xsubckt_253_nexor2_x0 67 66 833 2388 688 nexor2_x0
xsubckt_900_nand2_x0 67 66 103 2271 2285 nand2_x0
xsubckt_2059_and21nor_x0 67 66 1124 892 184 183 and21nor_x0
xsubckt_1322_nand4_x0 67 66 1860 73 891 1123 1134 nand4_x0
xsubckt_450_nexor2_x0 67 66 37 57 509 nexor2_x0
xsubckt_448_nor2_x0 67 66 511 37 57 nor2_x0
xsubckt_663_nand3_x0 67 66 307 312 319 329 nand3_x0
xsubckt_2348_dff_x1 67 66 136 186 45 dff_x1
xsubckt_2231_nexor2_x0 67 66 942 944 939 nexor2_x0
xsubckt_2104_or21nand_x0 67 66 1075 1079 1082 78 or21nand_x0
xsubckt_1702_nand3_x0 67 66 1490 794 973 185 nand3_x0
xsubckt_555_or21nand_x0 67 66 409 427 424 426 or21nand_x0
xsubckt_487_nand2_x0 67 66 474 84 85 nand2_x0
xsubckt_36_inv_x0 67 66 87 920 inv_x0
xsubckt_1088_and21nor_x0 67 66 2089 2093 2108 973 and21nor_x0
xsubckt_2307_dff_x1 67 66 153 186 62 dff_x1
xsubckt_2265_and4_x1 67 66 177 767 70 182 184 and4_x1
xsubckt_2252_and2_x1 67 66 917 918 919 and2_x1
xsubckt_2026_or21nand_x0 67 66 1159 1163 1167 80 or21nand_x0
xsubckt_1889_nand4_x0 67 66 1307 1308 1309 1312 768 nand4_x0
xsubckt_1465_nand2_x0 67 66 1720 1722 791 nand2_x0
xsubckt_266_or21nand_x0 67 66 676 184 183 2388 or21nand_x0
xsubckt_2351_dff_x1 67 66 133 186 42 dff_x1
xsubckt_2249_or21nand_x0 67 66 921 940 944 945 or21nand_x0
xsubckt_2047_nand2_x0 67 66 1136 1137 796 nand2_x0
xsubckt_1936_or21nand_x0 67 66 1256 1269 1259 1257 or21nand_x0
xsubckt_1532_and3_x1 67 66 1654 1739 854 855 and3_x1
xsubckt_320_or21nand_x0 67 66 627 2397 635 640 or21nand_x0
xsubckt_748_xor2_x0 67 66 5 80 227 xor2_x0
xsubckt_770_nexor2_x0 67 66 207 210 206 nexor2_x0
xsubckt_786_and21nor_x0 67 66 191 192 194 586 and21nor_x0
xsubckt_962_nand2_x0 67 66 2212 2213 2216 nand2_x0
xsubckt_2210_nexor2_x0 67 66 970 75 961 nexor2_x0
xsubckt_1803_and21nor_x0 67 66 1391 1408 1396 1392 and21nor_x0
xsubckt_1542_and21nor_x0 67 66 151 1645 1665 1687 and21nor_x0
xsubckt_616_or2_x1 67 66 351 352 353 or2_x1
xsubckt_99_or3_x1 67 66 835 2391 2399 2398 or3_x1
xsubckt_704_and2_x1 67 66 269 7 24 and2_x1
xsubckt_807_or2_x1 67 66 2359 2 80 or2_x1
xsubckt_974_nand4_x0 67 66 2201 2203 2204 2205 768 nand4_x0
xsubckt_1255_nexor2_x0 67 66 1982 4 1925 nexor2_x0
xsubckt_1691_and3_x1 67 66 1500 1501 1502 1503 and3_x1
xsubckt_1327_nand4_x0 67 66 1855 74 185 184 183 nand4_x0
xsubckt_466_nexor2_x0 67 66 496 497 494 nexor2_x0
xsubckt_127_and2_x1 67 66 155 809 1112 and2_x1
xsubckt_120_and3_x1 67 66 814 816 817 90 and3_x1
xsubckt_766_and21nor_x0 67 66 210 229 226 228 and21nor_x0
xsubckt_879_and2_x1 67 66 2290 2291 2292 and2_x1
xsubckt_975_nand4_x0 67 66 2200 25 185 1080 183 nand4_x0
xsubckt_2176_nand2_x0 67 66 998 1000 1001 nand2_x0
xsubckt_2002_or3_x1 67 66 1184 1185 1186 187 or3_x1
xsubckt_1874_and3_x1 67 66 1321 1322 73 1123 and3_x1
xsubckt_1745_nand3_x0 67 66 1448 1450 1451 768 nand3_x0
xsubckt_1662_nexor2_x0 67 66 1555 8 1528 nexor2_x0
xsubckt_1410_mux2_x1 67 66 1774 54 65 140 mux2_x1
xsubckt_1342_and21nor_x0 67 66 1840 1844 1857 962 and21nor_x0
xsubckt_1306_and3_x1 67 66 1875 73 35 1123 and3_x1
xsubckt_496_nexor2_x0 67 66 466 469 465 nexor2_x0
xsubckt_451_or21nand_x0 67 66 508 531 529 530 or21nand_x0
xsubckt_286_mux2_x1 67 66 658 2378 65 162 mux2_x1
xsubckt_899_or21nand_x0 67 66 2271 2272 2278 586 or21nand_x0
xsubckt_967_nand2_x0 67 66 2208 184 183 nand2_x0
xsubckt_2319_dff_x1 67 66 149 186 83 dff_x1
xsubckt_1608_or21nand_x0 67 66 1580 1631 1633 1634 or21nand_x0
xsubckt_1284_or21nand_x0 67 66 1897 1903 1919 56 or21nand_x0
xsubckt_170_nand3_x0 67 66 768 185 1080 183 nand3_x0
xsubckt_316_and2_x1 67 66 173 631 632 and2_x1
xsubckt_1030_and2_x1 67 66 2146 2147 579 and2_x1
xsubckt_1144_nexor2_x0 67 66 2036 2038 2034 nexor2_x0
xsubckt_1261_and2_x1 67 66 143 1920 1938 and2_x1
xsubckt_1276_nor3_x0 67 66 1905 1906 1907 792 nor3_x0
xsubckt_1742_mux2_x1 67 66 973 1452 2209 1451 mux2_x1
xsubckt_631_nand2_x0 67 66 337 42 61 nand2_x0
xsubckt_244_nand2_x0 67 66 697 699 702 nand2_x0
xsubckt_317_and2_x1 67 66 630 637 2397 and2_x1
xsubckt_2100_nor2_x0 67 66 1079 1084 792 nor2_x0
xsubckt_2053_and4_x1 67 66 1130 73 857 1123 1134 and4_x1
xsubckt_1959_and2_x1 67 66 110 1232 1233 and2_x1
xsubckt_1927_nand2_x0 67 66 1266 83 185 nand2_x0
xsubckt_1676_nand3_x0 67 66 1515 2209 56 1069 nand3_x0
xsubckt_1516_nor2_x0 67 66 1670 1676 1678 nor2_x0
xsubckt_167_and2_x1 67 66 771 1080 183 and2_x1
xsubckt_270_and21nor_x0 67 66 672 703 697 679 and21nor_x0
xsubckt_1204_nand4_x0 67 66 1975 73 5 71 72 nand4_x0
xsubckt_2105_and3_x1 67 66 1074 1078 1081 78 and3_x1
xsubckt_2007_nand3_x0 67 66 1180 2209 82 1069 nand3_x0
xsubckt_1449_nand4_x0 67 66 1735 73 887 1123 1134 nand4_x0
xsubckt_536_nor2_x0 67 66 427 33 87 nor2_x0
xsubckt_84_inv_x0 67 66 8 850 inv_x0
xsubckt_806_or21nand_x0 67 66 2360 190 189 188 or21nand_x0
xsubckt_1159_nor4_x0 67 66 2019 6 7 14 15 nor4_x0
xsubckt_1648_or21nand_x0 67 66 1542 1547 1565 1569 or21nand_x0
xsubckt_1406_and21nor_x0 67 66 1777 1828 1839 1842 and21nor_x0
xsubckt_562_and21nor_x0 67 66 402 420 417 419 and21nor_x0
xsubckt_1232_and2_x1 67 66 1948 1949 1966 and2_x1
xsubckt_2341_dff_x1 67 66 129 186 38 dff_x1
xsubckt_2027_nor3_x0 67 66 1158 1163 1167 870 nor3_x0
xsubckt_1915_and21nor_x0 67 66 1278 1924 2172 2180 and21nor_x0
xsubckt_1605_nand4_x0 67 66 1583 1591 1592 1593 890 nand4_x0
xsubckt_1458_and21nor_x0 67 66 1727 805 78 183 and21nor_x0
xsubckt_1394_nexor2_x0 67 66 1869 889 1789 nexor2_x0
xsubckt_1022_and2_x1 67 66 2154 2155 746 and2_x1
xsubckt_1050_or21nand_x0 67 66 2126 2135 2133 2128 or21nand_x0
xsubckt_1234_or21nand_x0 67 66 1946 1950 1967 57 or21nand_x0
xsubckt_2331_dff_x1 67 66 107 186 79 dff_x1
xsubckt_1757_and2_x1 67 66 1436 1438 28 and2_x1
xsubckt_1673_and3_x1 67 66 1518 1519 1080 183 and3_x1
xsubckt_1578_or21nand_x0 67 66 1609 1625 1624 1610 or21nand_x0
xsubckt_1550_mux2_x1 67 66 75 1639 791 1637 mux2_x1
xsubckt_633_nexor2_x0 67 66 42 61 335 nexor2_x0
xsubckt_607_xor2_x0 67 66 43 83 360 xor2_x0
xsubckt_605_nor2_x0 67 66 362 43 83 nor2_x0
xsubckt_339_nand2_x0 67 66 610 612 613 nand2_x0
xsubckt_152_nexor2_x0 67 66 790 1198 785 nexor2_x0
xsubckt_124_and21nor_x0 67 66 810 1134 813 65 and21nor_x0
xsubckt_121_nand3_x0 67 66 813 816 817 90 nand3_x0
xsubckt_689_or21nand_x0 67 66 283 292 290 284 or21nand_x0
xsubckt_793_or21nand_x0 67 66 2372 863 578 582 or21nand_x0
xsubckt_836_nand2_x0 67 66 2331 2363 197 nand2_x0
xsubckt_869_nor2_x0 67 66 2300 13 77 nor2_x0
xsubckt_883_nor2_x0 67 66 104 2287 2301 nor2_x0
xsubckt_1141_nand2_x0 67 66 2037 2043 2045 nand2_x0
xsubckt_2347_dff_x1 67 66 123 186 32 dff_x1
xsubckt_2051_mux2_x1 67 66 1123 79 848 1132 mux2_x1
xsubckt_2024_mux2_x1 67 66 920 1168 791 1161 mux2_x1
xsubckt_1899_or2_x1 67 66 1296 1298 875 or2_x1
xsubckt_1477_nexor2_x0 67 66 1745 45 1708 nexor2_x0
xsubckt_1412_and3_x1 67 66 1772 794 866 185 and3_x1
xsubckt_457_xor2_x0 67 66 37 88 502 xor2_x0
xsubckt_382_or2_x1 67 66 573 574 575 or2_x1
xsubckt_730_or21nand_x0 67 66 244 245 582 586 or21nand_x0
xsubckt_785_or21nand_x0 67 66 192 202 199 196 or21nand_x0
xsubckt_804_xor2_x0 67 66 75 76 2362 xor2_x0
xsubckt_819_or21nand_x0 67 66 2347 2355 2354 2348 or21nand_x0
xsubckt_1024_nand3_x0 67 66 2152 748 875 183 nand3_x0
xsubckt_1807_nand3_x0 67 66 1387 1390 1394 871 nand3_x0
xsubckt_1546_nand3_x0 67 66 1641 767 74 184 nand3_x0
xsubckt_618_nand2_x0 67 66 349 352 353 nand2_x0
xsubckt_753_mux2_x1 67 66 223 237 587 96 mux2_x1
xsubckt_2073_and21nor_x0 67 66 1108 1114 1125 868 and21nor_x0
xsubckt_1616_and21nor_x0 67 66 149 1573 1577 1607 and21nor_x0
xsubckt_1383_nexor2_x0 67 66 1806 88 1800 nexor2_x0
xsubckt_37_inv_x0 67 66 37 909 inv_x0
xsubckt_1124_and3_x1 67 66 2054 2055 2056 807 and3_x1
xsubckt_2362_dff_x1 67 66 92 186 1 dff_x1
xsubckt_1736_and21nor_x0 67 66 121 1460 1458 1457 and21nor_x0
xsubckt_1611_nand2_x0 67 66 1577 1578 795 nand2_x0
xsubckt_520_nor2_x0 67 66 442 34 85 nor2_x0
xsubckt_431_nexor2_x0 67 66 528 531 527 nexor2_x0
xsubckt_399_mux2_x1 67 66 558 572 587 137 mux2_x1
xsubckt_234_nand2_x0 67 66 706 813 1112 nand2_x0
xsubckt_982_or21nand_x0 67 66 2193 2202 2198 2196 or21nand_x0
xsubckt_1216_and2_x1 67 66 1964 76 185 and2_x1
xsubckt_1583_nexor2_x0 67 66 1623 882 1605 nexor2_x0
xsubckt_1416_and21nor_x0 67 66 1768 79 1080 183 and21nor_x0
xsubckt_1415_and2_x1 67 66 1769 2209 856 and2_x1
xsubckt_1346_and21nor_x0 67 66 1836 1844 1857 89 and21nor_x0
xsubckt_572_and21nor_x0 67 66 393 430 412 394 and21nor_x0
xsubckt_553_nexor2_x0 67 66 61 82 411 nexor2_x0
xsubckt_507_and21nor_x0 67 66 455 477 476 475 and21nor_x0
xsubckt_22_inv_x0 67 66 185 1069 inv_x0
xsubckt_280_and21nor_x0 67 66 163 663 667 684 and21nor_x0
xsubckt_710_nand2_x0 67 66 98 264 265 nand2_x0
xsubckt_719_or2_x1 67 66 255 6 26 or2_x1
xsubckt_838_and2_x1 67 66 2329 74 75 and2_x1
xsubckt_950_and21nor_x0 67 66 2223 2224 2231 587 and21nor_x0
xsubckt_1047_or3_x1 67 66 2129 2130 2131 795 or3_x1
xsubckt_1169_nand3_x0 67 66 2010 2209 78 1069 nand3_x0
xsubckt_1267_mux2_x1 67 66 876 184 183 1914 mux2_x1
xsubckt_2099_nand3_x0 67 66 1081 794 894 185 nand3_x0
xsubckt_2043_or21nand_x0 67 66 1140 779 1151 1141 or21nand_x0
xsubckt_1983_and21nor_x0 67 66 1205 1212 1215 872 and21nor_x0
xsubckt_1900_and2_x1 67 66 1294 1298 25 and2_x1
xsubckt_1816_nexor2_x0 67 66 1380 1412 1378 nexor2_x0
xsubckt_1323_nand2_x0 67 66 1859 1860 779 nand2_x0
xsubckt_584_or21nand_x0 67 66 381 383 384 583 or21nand_x0
xsubckt_532_nexor2_x0 67 66 82 83 431 nexor2_x0
xsubckt_396_nexor2_x0 67 66 561 565 560 nexor2_x0
xsubckt_70_inv_x0 67 66 77 864 inv_x0
xsubckt_203_or21nand_x0 67 66 736 759 761 762 or21nand_x0
xsubckt_1046_and21nor_x0 67 66 2130 2132 2134 2182 and21nor_x0
xsubckt_2284_dff_x1 67 66 176 186 68 dff_x1
xsubckt_2165_and3_x1 67 66 1010 1011 1012 1013 and3_x1
xsubckt_2010_and4_x1 67 66 1176 1178 1179 1180 768 and4_x1
xsubckt_1667_or21nand_x0 67 66 1523 1541 1540 1524 or21nand_x0
xsubckt_1376_nand3_x0 67 66 1807 794 868 185 nand3_x0
xsubckt_1340_and3_x1 67 66 1842 1844 1857 962 and3_x1
xsubckt_612_and2_x1 67 66 355 43 61 and2_x1
xsubckt_128_and2_x1 67 66 808 184 1091 and2_x1
xsubckt_876_and2_x1 67 66 2293 13 74 and2_x1
xsubckt_898_and2_x1 67 66 2272 2273 583 and2_x1
xsubckt_989_and21nor_x0 67 66 2186 2193 2191 2187 and21nor_x0
xsubckt_1237_nexor2_x0 67 66 1948 57 1943 nexor2_x0
xsubckt_2092_and3_x1 67 66 1088 1089 1092 1171 and3_x1
xsubckt_2009_nand2_x0 67 66 1178 2208 88 nand2_x0
xsubckt_1289_nexor2_x0 67 66 1894 1896 1892 nexor2_x0
xsubckt_528_and21nor_x0 67 66 435 472 454 436 and21nor_x0
xsubckt_454_or21nand_x0 67 66 505 577 507 506 or21nand_x0
xsubckt_648_nand3_x0 67 66 321 337 349 354 nand3_x0
xsubckt_758_nexor2_x0 67 66 220 222 218 nexor2_x0
xsubckt_872_or21nand_x0 67 66 2297 2316 2314 2315 or21nand_x0
xsubckt_1008_and3_x1 67 66 2167 73 15 72 and3_x1
xsubckt_1260_and21nor_x0 67 66 1920 780 1935 1921 and21nor_x0
xsubckt_2350_dff_x1 67 66 134 186 43 dff_x1
xsubckt_2164_nand3_x0 67 66 1011 767 82 184 nand3_x0
xsubckt_2129_mux2_x1 67 66 1123 77 848 1049 mux2_x1
xsubckt_2058_nand3_x0 67 66 1125 794 902 185 nand3_x0
xsubckt_2029_nexor2_x0 67 66 1161 870 1156 nexor2_x0
xsubckt_1971_or21nand_x0 67 66 1218 1219 1222 1228 or21nand_x0
xsubckt_1727_and2_x1 67 66 1465 1468 30 and2_x1
xsubckt_1508_and21nor_x0 67 66 1678 1680 1686 85 and21nor_x0
xsubckt_1341_nand3_x0 67 66 1841 1844 1857 962 nand3_x0
xsubckt_88_inv_x0 67 66 53 846 inv_x0
xsubckt_13_inv_x0 67 66 2390 1166 inv_x0
xsubckt_188_nexor2_x0 67 66 837 1177 750 nexor2_x0
xsubckt_1833_and3_x1 67 66 1362 767 56 184 and3_x1
xsubckt_1562_and2_x1 67 66 1625 1626 1633 and2_x1
xsubckt_1525_and3_x1 67 66 1661 1745 884 885 and3_x1
xsubckt_597_and21nor_x0 67 66 369 383 384 385 and21nor_x0
xsubckt_415_nexor2_x0 67 66 543 546 542 nexor2_x0
xsubckt_162_nor2_x0 67 66 775 187 2398 nor2_x0
xsubckt_987_and2_x1 67 66 2188 2189 791 and2_x1
xsubckt_2352_dff_x1 67 66 132 186 41 dff_x1
xsubckt_1923_nand3_x0 67 66 1270 767 88 184 nand3_x0
xsubckt_1717_and3_x1 67 66 1475 767 59 184 and3_x1
xsubckt_1672_mux2_x1 67 66 58 57 185 1519 mux2_x1
xsubckt_1506_or21nand_x0 67 66 1680 580 1684 1682 or21nand_x0
xsubckt_1475_nexor2_x0 67 66 1712 1714 1710 nexor2_x0
xsubckt_637_and21nor_x0 67 66 331 332 339 587 and21nor_x0
xsubckt_495_xor2_x0 67 66 35 89 466 xor2_x0
xsubckt_392_nand2_x0 67 66 564 58 47 nand2_x0
xsubckt_173_and2_x1 67 66 765 766 768 and2_x1
xsubckt_844_or21nand_x0 67 66 2323 2332 2331 2327 or21nand_x0
xsubckt_992_and21nor_x0 67 66 2183 2185 2210 63 and21nor_x0
xsubckt_1189_nexor2_x0 67 66 1996 1015 1990 nexor2_x0
xsubckt_2256_nand4_x0 67 66 913 73 880 1123 72 nand4_x0
xsubckt_2214_or21nand_x0 67 66 957 779 958 975 or21nand_x0
xsubckt_1541_and21nor_x0 67 66 1645 780 1662 1646 and21nor_x0
xsubckt_1507_mux2_x1 67 66 76 1681 791 1679 mux2_x1
xsubckt_1398_and21nor_x0 67 66 1785 2172 1789 1786 and21nor_x0
xsubckt_380_and21nor_x0 67 66 575 576 581 47 and21nor_x0
xsubckt_264_nexor2_x0 67 66 683 1231 678 nexor2_x0
xsubckt_1251_or21nand_x0 67 66 1929 2171 1933 1930 or21nand_x0
xsubckt_1979_and21nor_x0 67 66 1210 1212 1215 81 and21nor_x0
xsubckt_1812_and21nor_x0 67 66 1382 1390 1394 27 and21nor_x0
xsubckt_1749_and2_x1 67 66 1444 1445 804 and2_x1
xsubckt_1630_nand2_x0 67 66 1559 2169 851 nand2_x0
xsubckt_1441_and21nor_x0 67 66 1743 71 73 87 and21nor_x0
xsubckt_1311_and21nor_x0 67 66 1870 780 1888 1871 and21nor_x0
xsubckt_782_nexor2_x0 67 66 76 77 195 nexor2_x0
xsubckt_2359_dff_x1 67 66 95 186 4 dff_x1
xsubckt_2254_mux2_x1 67 66 71 856 848 915 mux2_x1
xsubckt_2087_or21nand_x0 67 66 1093 796 1098 1094 or21nand_x0
xsubckt_1846_and21nor_x0 67 66 1349 1355 1354 1350 and21nor_x0
xsubckt_1587_and21nor_x0 67 66 1601 2172 1605 1602 and21nor_x0
xsubckt_1460_and3_x1 67 66 1725 748 858 183 and3_x1
xsubckt_379_nand4_x0 67 66 576 767 62 182 184 nand4_x0
xsubckt_305_nor3_x0 67 66 641 826 1144 2392 nor3_x0
xsubckt_752_and2_x1 67 66 223 224 230 and2_x1
xsubckt_1219_mux2_x1 67 66 875 184 183 1961 mux2_x1
xsubckt_1779_and21nor_x0 67 66 1414 780 1425 1415 and21nor_x0
xsubckt_1739_and3_x1 67 66 1454 1520 184 1091 and3_x1
xsubckt_1647_xor2_x0 67 66 29 61 1543 xor2_x0
xsubckt_558_xor2_x0 67 66 32 86 406 xor2_x0
xsubckt_490_nexor2_x0 67 66 473 477 471 nexor2_x0
xsubckt_190_mux2_x1 67 66 749 2383 65 167 mux2_x1
xsubckt_718_or21nand_x0 67 66 256 277 276 275 or21nand_x0
xsubckt_813_and21nor_x0 67 66 2353 2371 2370 2369 and21nor_x0
xsubckt_820_mux2_x1 67 66 2347 2361 587 93 mux2_x1
xsubckt_2122_or21nand_x0 67 66 1055 1096 1110 1111 or21nand_x0
xsubckt_2096_or21nand_x0 67 66 1084 808 1088 1085 or21nand_x0
xsubckt_1995_nexor2_x0 67 66 1194 1200 1192 nexor2_x0
xsubckt_1992_nand2_x0 67 66 1195 1196 796 nand2_x0
xsubckt_1798_or21nand_x0 67 66 1396 1404 1402 1399 or21nand_x0
xsubckt_1444_or21nand_x0 67 66 1740 2171 1744 1741 or21nand_x0
xsubckt_1435_nand2_x0 67 66 1749 1750 796 nand2_x0
xsubckt_76_inv_x0 67 66 74 858 inv_x0
xsubckt_1090_nexor2_x0 67 66 2092 973 2087 nexor2_x0
xsubckt_2119_and2_x1 67 66 1059 1060 779 and2_x1
xsubckt_1980_or21nand_x0 67 66 1208 1213 1216 872 or21nand_x0
xsubckt_1635_nexor2_x0 67 66 1600 9 1554 nexor2_x0
xsubckt_625_and2_x1 67 66 343 42 82 and2_x1
xsubckt_538_xor2_x0 67 66 33 87 425 xor2_x0
xsubckt_837_and21nor_x0 67 66 2330 2362 193 198 and21nor_x0
xsubckt_948_and2_x1 67 66 2225 2226 583 and2_x1
xsubckt_1272_and3_x1 67 66 1909 1910 1911 807 and3_x1
xsubckt_1486_nand2_x0 67 66 1699 1700 2178 nand2_x0
xsubckt_588_and3_x1 67 66 378 683 61 182 and3_x1
xsubckt_338_and2_x1 67 66 611 612 613 and2_x1
xsubckt_56_inv_x0 67 66 30 878 inv_x0
xsubckt_187_and2_x1 67 66 751 752 757 and2_x1
xsubckt_213_and2_x1 67 66 726 1101 2390 and2_x1
xsubckt_994_nor3_x0 67 66 2181 2183 2184 1101 nor3_x0
xsubckt_1140_and2_x1 67 66 2038 2043 2045 and2_x1
xsubckt_1190_or21nand_x0 67 66 1989 2035 2040 2041 or21nand_x0
xsubckt_1217_nand2_x0 67 66 1963 76 185 nand2_x0
xsubckt_1883_and3_x1 67 66 1313 1484 184 1091 and3_x1
xsubckt_1876_nand4_x0 67 66 1319 73 5 1123 1134 nand4_x0
xsubckt_440_or21nand_x0 67 66 129 519 525 532 or21nand_x0
xsubckt_217_mux2_x1 67 66 723 2382 65 166 mux2_x1
xsubckt_657_xor2_x0 67 66 40 61 313 xor2_x0
xsubckt_986_nand3_x0 67 66 2189 767 873 184 nand3_x0
xsubckt_2357_dff_x1 67 66 97 186 6 dff_x1
xsubckt_1989_and21nor_x0 67 66 1199 1246 1248 1251 and21nor_x0
xsubckt_1967_and3_x1 67 66 1223 1310 1080 183 and3_x1
xsubckt_1697_nand4_x0 67 66 1495 73 983 1123 72 nand4_x0
xsubckt_1544_or2_x1 67 66 1643 745 856 or2_x1
xsubckt_1456_nand3_x0 67 66 1729 794 864 185 nand3_x0
xsubckt_87_inv_x0 67 66 31 847 inv_x0
xsubckt_227_nand2_x0 67 66 713 714 715 nand2_x0
xsubckt_685_nand2_x0 67 66 287 14 25 nand2_x0
xsubckt_803_nand2_x0 67 66 2363 75 76 nand2_x0
xsubckt_2220_and21nor_x0 67 66 117 952 956 982 and21nor_x0
xsubckt_2076_nand3_x0 67 66 1105 1114 1125 868 nand3_x0
xsubckt_2057_and3_x1 67 66 1126 794 902 185 and3_x1
xsubckt_1977_nand2_x0 67 66 1212 1214 1218 nand2_x0
xsubckt_1948_or21nand_x0 67 66 1243 1285 1292 1293 or21nand_x0
xsubckt_1470_or21nand_x0 67 66 1715 1721 1730 86 or21nand_x0
xsubckt_376_nand2_x0 67 66 579 767 184 nand2_x0
xsubckt_665_nand3_x0 67 66 305 306 307 583 nand3_x0
xsubckt_860_nor2_x0 67 66 2308 0 75 nor2_x0
xsubckt_862_xor2_x0 67 66 0 75 2306 xor2_x0
xsubckt_1038_or21nand_x0 67 66 2138 2141 2162 62 or21nand_x0
xsubckt_1095_or2_x1 67 66 2082 2083 795 or2_x1
xsubckt_2193_mux2_x1 67 66 71 860 848 980 mux2_x1
xsubckt_1698_and2_x1 67 66 1494 1495 2173 and2_x1
xsubckt_1575_and2_x1 67 66 1612 1613 1101 and2_x1
xsubckt_1480_mux2_x1 67 66 71 902 848 1705 mux2_x1
xsubckt_1320_nexor2_x0 67 66 1880 2 1862 nexor2_x0
xsubckt_594_nexor2_x0 67 66 373 376 372 nexor2_x0
xsubckt_643_or21nand_x0 67 66 326 345 343 344 or21nand_x0
xsubckt_677_or2_x1 67 66 295 28 14 or2_x1
xsubckt_802_and2_x1 67 66 2364 192 197 and2_x1
xsubckt_1147_or21nand_x0 67 66 2031 2081 2086 2090 or21nand_x0
xsubckt_2312_dff_x1 67 66 142 186 56 dff_x1
xsubckt_2297_dff_x1 67 66 162 186 2386 dff_x1
xsubckt_1652_or21nand_x0 67 66 1538 1563 1566 1567 or21nand_x0
xsubckt_1286_nexor2_x0 67 66 1901 56 1895 nexor2_x0
xsubckt_619_and21nor_x0 67 66 348 352 353 582 and21nor_x0
xsubckt_565_xor2_x0 67 66 32 83 399 xor2_x0
xsubckt_123_nand4_x0 67 66 811 816 817 72 90 nand4_x0
xsubckt_722_nexor2_x0 67 66 253 256 252 nexor2_x0
xsubckt_757_nexor2_x0 67 66 77 78 219 nexor2_x0
xsubckt_778_nand2_x0 67 66 199 221 240 nand2_x0
xsubckt_893_and21nor_x0 67 66 2277 2291 2292 2293 and21nor_x0
xsubckt_1490_and2_x1 67 66 1695 1696 1703 and2_x1
xsubckt_1466_and21nor_x0 67 66 1719 791 1722 1730 and21nor_x0
xsubckt_176_nand3_x0 67 66 762 766 768 2391 nand3_x0
xsubckt_259_nor3_x0 67 66 683 185 184 183 nor3_x0
xsubckt_1851_and2_x1 67 66 1344 1361 791 and2_x1
xsubckt_1849_and3_x1 67 66 1346 794 994 185 and3_x1
xsubckt_1334_nand3_x0 67 66 1848 806 866 1091 nand3_x0
xsubckt_529_nor2_x0 67 66 434 82 83 nor2_x0
xsubckt_482_and21nor_x0 67 66 127 586 480 479 and21nor_x0
xsubckt_671_and21nor_x0 67 66 300 30 578 301 and21nor_x0
xsubckt_673_mux2_x1 67 66 299 302 587 106 mux2_x1
xsubckt_840_xor2_x0 67 66 74 75 2327 xor2_x0
xsubckt_851_and3_x1 67 66 2317 2318 2319 587 and3_x1
xsubckt_935_and2_x1 67 66 2238 9 29 and2_x1
xsubckt_1796_nand2_x0 67 66 1398 1400 804 nand2_x0
xsubckt_1689_nand3_x0 67 66 1502 73 1037 72 nand3_x0
xsubckt_1594_or21nand_x0 67 66 1594 2180 1601 1595 or21nand_x0
xsubckt_1549_mux2_x1 67 66 860 1640 791 1638 mux2_x1
xsubckt_617_and2_x1 67 66 350 352 353 and2_x1
xsubckt_474_and21nor_x0 67 66 486 504 501 503 and21nor_x0
xsubckt_149_or2_x1 67 66 788 790 1198 or2_x1
xsubckt_27_inv_x0 67 66 58 1015 inv_x0
xsubckt_233_nand3_x0 67 66 707 708 712 713 nand3_x0
xsubckt_680_and2_x1 67 66 292 577 874 and2_x1
xsubckt_912_or2_x1 67 66 2259 2260 2261 or2_x1
xsubckt_1102_and4_x1 67 66 2075 2076 2078 2176 1134 and4_x1
xsubckt_1188_nexor2_x0 67 66 1996 58 1991 nexor2_x0
xsubckt_2271_or21nand_x0 67 66 900 1144 815 901 or21nand_x0
xsubckt_2215_nand2_x0 67 66 956 957 795 nand2_x0
xsubckt_1728_nand2_x0 67 66 1464 1468 30 nand2_x0
xsubckt_1713_and21nor_x0 67 66 1479 1480 1483 771 and21nor_x0
xsubckt_1678_or21nand_x0 67 66 1513 1514 1518 807 or21nand_x0
xsubckt_630_or2_x1 67 66 338 42 61 or2_x1
xsubckt_133_nexor2_x0 67 66 806 183 803 nexor2_x0
xsubckt_1023_nand2_x0 67 66 2153 2155 746 nand2_x0
xsubckt_2335_dff_x1 67 66 117 186 75 dff_x1
xsubckt_1888_nand2_x0 67 66 1308 2208 57 nand2_x0
xsubckt_623_or21nand_x0 67 66 345 362 359 361 or21nand_x0
xsubckt_568_or21nand_x0 67 66 396 404 403 397 or21nand_x0
xsubckt_656_or21nand_x0 67 66 314 326 327 329 or21nand_x0
xsubckt_1339_mux2_x1 67 66 870 1845 791 1843 mux2_x1
xsubckt_694_nexor2_x0 67 66 80 81 279 nexor2_x0
xsubckt_882_nor2_x0 67 66 2287 2288 2294 nor2_x0
xsubckt_1049_or21nand_x0 67 66 2127 2186 2211 63 or21nand_x0
xsubckt_2298_dff_x1 67 66 161 186 2385 dff_x1
xsubckt_1907_nand2_x0 67 66 1287 1289 1292 nand2_x0
xsubckt_535_nor2_x0 67 66 428 429 586 nor2_x0
xsubckt_503_nexor2_x0 67 66 459 462 458 nexor2_x0
xsubckt_269_and3_x1 67 66 673 674 675 796 and3_x1
xsubckt_954_nexor2_x0 67 66 8 29 2220 nexor2_x0
xsubckt_1028_or21nand_x0 67 66 2148 2157 2153 2151 or21nand_x0
xsubckt_1148_nexor2_x0 67 66 2032 2037 2030 nexor2_x0
xsubckt_2240_and21nor_x0 67 66 929 780 939 931 and21nor_x0
xsubckt_2188_nexor2_x0 67 66 986 1002 985 nexor2_x0
xsubckt_2140_and2_x1 67 66 1036 1042 791 and2_x1
xsubckt_1777_nand2_x0 67 66 1416 1417 1101 nand2_x0
xsubckt_1753_and21nor_x0 67 66 1440 1441 1453 1456 and21nor_x0
xsubckt_1559_nor2_x0 67 66 1628 1629 779 nor2_x0
xsubckt_600_xor2_x0 67 66 44 61 366 xor2_x0
xsubckt_97_nor2_x0 67 66 837 2399 2398 nor2_x0
xsubckt_206_or21nand_x0 67 66 733 736 737 796 or21nand_x0
xsubckt_239_nand2_x0 67 66 702 793 1220 nand2_x0
xsubckt_701_mux2_x1 67 66 7 273 578 272 mux2_x1
xsubckt_2276_nand2_x0 67 66 180 897 899 nand2_x0
xsubckt_2067_and3_x1 67 66 1115 1116 1118 1121 and3_x1
xsubckt_1848_and21nor_x0 67 66 1347 1348 1359 1362 and21nor_x0
xsubckt_1825_and2_x1 67 66 1369 1370 779 and2_x1
xsubckt_1703_nand2_x0 67 66 1489 56 185 nand2_x0
xsubckt_1690_or2_x1 67 66 1501 31 73 or2_x1
xsubckt_634_or21nand_x0 67 66 334 355 350 336 or21nand_x0
xsubckt_501_and2_x1 67 66 460 35 86 and2_x1
xsubckt_404_nexor2_x0 67 66 554 556 553 nexor2_x0
xsubckt_215_nexor2_x0 67 66 836 2390 724 nexor2_x0
xsubckt_642_nexor2_x0 67 66 41 61 327 nexor2_x0
xsubckt_850_or21nand_x0 67 66 2318 2329 2324 2320 or21nand_x0
xsubckt_956_and2_x1 67 66 2218 2219 578 and2_x1
xsubckt_2358_dff_x1 67 66 96 186 5 dff_x1
xsubckt_2158_nand2_x0 67 66 1017 1018 796 nand2_x0
xsubckt_2146_nand3_x0 67 66 1030 1035 1038 77 nand3_x0
xsubckt_2123_and21nor_x0 67 66 1054 1097 1109 1113 and21nor_x0
xsubckt_1940_and3_x1 67 66 1251 1256 1258 24 and3_x1
xsubckt_1636_or21nand_x0 67 66 1553 1134 1554 2180 or21nand_x0
xsubckt_1590_nexor2_x0 67 66 1616 852 1598 nexor2_x0
xsubckt_1315_and21nor_x0 67 66 1867 71 73 89 and21nor_x0
xsubckt_540_nexor2_x0 67 66 424 425 423 nexor2_x0
xsubckt_157_and2_x1 67 66 780 187 2392 and2_x1
xsubckt_795_or2_x1 67 66 2370 3 78 or2_x1
xsubckt_909_nand2_x0 67 66 2262 11 29 nand2_x0
xsubckt_971_nand3_x0 67 66 2204 2209 876 1069 nand3_x0
xsubckt_2242_nexor2_x0 67 66 928 944 927 nexor2_x0
xsubckt_2068_nand3_x0 67 66 1114 1116 1118 1121 nand3_x0
xsubckt_2061_or21nand_x0 67 66 1121 1122 1124 185 or21nand_x0
xsubckt_1988_nexor2_x0 67 66 1211 872 1200 nexor2_x0
xsubckt_1683_and2_x1 67 66 1508 1509 847 and2_x1
xsubckt_1488_nand4_x0 67 66 1697 73 885 1123 1134 nand4_x0
xsubckt_110_and2_x1 67 66 824 825 826 and2_x1
xsubckt_2309_dff_x1 67 66 145 186 59 dff_x1
xsubckt_2163_nand2_x0 67 66 1012 794 84 nand2_x0
xsubckt_2127_mux2_x1 67 66 1051 20 65 120 mux2_x1
xsubckt_2085_nexor2_x0 67 66 1097 1104 1095 nexor2_x0
xsubckt_1840_nand3_x0 67 66 1355 1356 1357 768 nand3_x0
xsubckt_1823_nand2_x0 67 66 1371 1372 1374 nand2_x0
xsubckt_1539_nand2_x0 67 66 1647 1648 1101 nand2_x0
xsubckt_1414_and3_x1 67 66 1770 748 860 183 and3_x1
xsubckt_1344_and3_x1 67 66 1838 1844 1857 89 and3_x1
xsubckt_570_or21nand_x0 67 66 395 83 61 82 or21nand_x0
xsubckt_505_or21nand_x0 67 66 456 464 463 457 or21nand_x0
xsubckt_249_nand3_x0 67 66 692 693 695 796 nand3_x0
xsubckt_268_or21nand_x0 67 66 674 694 677 679 or21nand_x0
xsubckt_282_or21nand_x0 67 66 661 672 680 780 or21nand_x0
xsubckt_693_xor2_x0 67 66 80 81 280 xor2_x0
xsubckt_952_or21nand_x0 67 66 2222 2234 2235 2237 or21nand_x0
xsubckt_1123_nand3_x0 67 66 2055 748 872 183 nand3_x0
xsubckt_2250_nand2_x0 67 66 919 921 1544 nand2_x0
xsubckt_1901_nand2_x0 67 66 1293 1298 25 nand2_x0
xsubckt_1462_and21nor_x0 67 66 1723 185 860 807 and21nor_x0
xsubckt_1404_or21nand_x0 67 66 1779 779 1797 1780 or21nand_x0
xsubckt_136_nand3_x0 67 66 800 801 813 1187 nand3_x0
xsubckt_659_nexor2_x0 67 66 313 314 311 nexor2_x0
xsubckt_848_nexor2_x0 67 66 29 74 2320 nexor2_x0
xsubckt_2310_dff_x1 67 66 144 186 58 dff_x1
xsubckt_2295_dff_x1 67 66 164 186 2388 dff_x1
xsubckt_2055_or3_x1 67 66 1128 1129 1130 780 or3_x1
xsubckt_1944_and21nor_x0 67 66 1247 1289 1292 1297 and21nor_x0
xsubckt_1391_and21nor_x0 67 66 1792 72 1793 2179 and21nor_x0
xsubckt_1349_or2_x1 67 66 1833 1840 1842 or2_x1
xsubckt_575_nexor2_x0 67 66 45 85 390 nexor2_x0
xsubckt_574_nand2_x0 67 66 391 45 85 nand2_x0
xsubckt_508_or2_x1 67 66 454 83 84 or2_x1
xsubckt_499_or21nand_x0 67 66 462 486 485 484 or21nand_x0
xsubckt_409_nexor2_x0 67 66 549 552 548 nexor2_x0
xsubckt_367_and21nor_x0 67 66 157 803 594 588 and21nor_x0
xsubckt_332_nand2_x0 67 66 616 617 2395 nand2_x0
xsubckt_100_and2_x1 67 66 834 835 2390 and2_x1
xsubckt_197_and2_x1 67 66 742 743 2390 and2_x1
xsubckt_260_or3_x1 67 66 682 185 184 183 or3_x1
xsubckt_312_and21nor_x0 67 66 634 636 637 641 and21nor_x0
xsubckt_745_or21nand_x0 67 66 230 577 232 231 or21nand_x0
xsubckt_1065_mux2_x1 67 66 1306 2112 1101 2111 mux2_x1
xsubckt_2364_dff_x1 67 66 104 186 13 dff_x1
xsubckt_1622_nand2_x0 67 66 1567 1571 82 nand2_x0
xsubckt_1574_nand4_x0 67 66 1613 73 883 1123 1134 nand4_x0
xsubckt_1137_nand3_x0 67 66 2041 2047 2062 951 nand3_x0
xsubckt_1844_and2_x1 67 66 1351 1352 804 and2_x1
xsubckt_159_and2_x1 67 66 778 803 2399 and2_x1
xsubckt_257_nand2_x0 67 66 164 685 686 nand2_x0
xsubckt_1173_nand4_x0 67 66 2006 868 185 1080 183 nand4_x0
xsubckt_1230_and21nor_x0 67 66 1950 1959 1956 1951 and21nor_x0
xsubckt_2366_dff_x1 67 66 102 186 11 dff_x1
xsubckt_2258_and3_x1 67 66 911 912 913 1101 and3_x1
xsubckt_2247_or21nand_x0 67 66 923 925 1543 796 or21nand_x0
xsubckt_2197_and3_x1 67 66 976 977 978 779 and3_x1
xsubckt_1756_mux2_x1 67 66 59 1439 791 1437 mux2_x1
xsubckt_1754_or21nand_x0 67 66 1439 1442 1454 1455 or21nand_x0
xsubckt_1570_and21nor_x0 67 66 1617 2172 1621 1618 and21nor_x0
xsubckt_1343_nand2_x0 67 66 1839 1843 89 nand2_x0
xsubckt_1296_nexor2_x0 67 66 1934 893 1885 nexor2_x0
xsubckt_223_and21nor_x0 67 66 717 730 738 742 and21nor_x0
xsubckt_747_and2_x1 67 66 228 5 80 and2_x1
xsubckt_1079_and3_x1 67 66 2098 806 25 1091 and3_x1
xsubckt_1201_nexor2_x0 67 66 2029 37 1978 nexor2_x0
xsubckt_1764_or21nand_x0 67 66 1429 1505 1462 1466 or21nand_x0
xsubckt_1632_and3_x1 67 66 1557 1558 1559 2177 and3_x1
xsubckt_1417_or4_x1 67 66 1767 1768 1769 1770 1771 or4_x1
xsubckt_1337_and21nor_x0 67 66 1845 1849 1847 1846 and21nor_x0
xsubckt_513_or2_x1 67 66 449 34 88 or2_x1
xsubckt_481_and2_x1 67 66 479 494 587 and2_x1
xsubckt_62_inv_x0 67 66 81 872 inv_x0
xsubckt_2324_dff_x1 67 66 114 186 28 dff_x1
xsubckt_2120_or21nand_x0 67 66 1057 2174 1061 1059 or21nand_x0
xsubckt_1964_nand3_x0 67 66 1226 2209 83 1069 nand3_x0
xsubckt_1774_and3_x1 67 66 1419 1420 73 1123 and3_x1
xsubckt_1401_and2_x1 67 66 1782 1783 779 and2_x1
xsubckt_1379_nand3_x0 67 66 1804 1807 1809 88 nand3_x0
xsubckt_1307_nand4_x0 67 66 1874 73 35 1123 1134 nand4_x0
xsubckt_504_nand2_x0 67 66 457 458 583 nand2_x0
xsubckt_741_nexor2_x0 67 66 5 25 234 nexor2_x0
xsubckt_904_or21nand_x0 67 66 2267 2284 2282 2283 or21nand_x0
xsubckt_1061_nand3_x0 67 66 2115 2116 73 1123 nand3_x0
xsubckt_1279_or21nand_x0 67 66 1902 1913 1908 1905 or21nand_x0
xsubckt_2301_dff_x1 67 66 172 186 2396 dff_x1
xsubckt_2257_nand4_x0 67 66 912 73 850 1123 1134 nand4_x0
xsubckt_1303_nexor2_x0 67 66 1926 863 1878 nexor2_x0
xsubckt_585_or21nand_x0 67 66 380 381 382 586 or21nand_x0
xsubckt_464_xor2_x0 67 66 85 86 496 xor2_x0
xsubckt_375_and2_x1 67 66 580 767 184 and2_x1
xsubckt_211_and21nor_x0 67 66 728 730 738 779 and21nor_x0
xsubckt_1142_and21nor_x0 67 66 2036 2084 2086 2089 and21nor_x0
xsubckt_1174_nand3_x0 67 66 2005 748 870 183 nand3_x0
xsubckt_2326_dff_x1 67 66 112 186 26 dff_x1
xsubckt_2017_nand3_x0 67 66 1169 767 86 184 nand3_x0
xsubckt_1929_nand4_x0 67 66 1264 1265 1267 1268 768 nand4_x0
xsubckt_1472_nexor2_x0 67 66 1719 86 1713 nexor2_x0
xsubckt_523_nexor2_x0 67 66 440 443 439 nexor2_x0
xsubckt_458_and21nor_x0 67 66 501 524 522 523 and21nor_x0
xsubckt_363_or2_x1 67 66 590 593 184 or2_x1
xsubckt_695_nexor2_x0 67 66 280 282 278 nexor2_x0
xsubckt_896_xor2_x0 67 66 12 29 2274 xor2_x0
xsubckt_1039_and3_x1 67 66 2137 2140 2161 1026 and3_x1
xsubckt_1268_and3_x1 67 66 1913 1914 1915 1917 and3_x1
xsubckt_2205_and2_x1 67 66 967 969 75 and2_x1
xsubckt_2080_or21nand_x0 67 66 1100 1153 1154 1159 or21nand_x0
xsubckt_1951_mux2_x1 67 66 1240 1886 2169 1239 mux2_x1
xsubckt_1737_and3_x1 67 66 1456 767 58 184 and3_x1
xsubckt_608_or21nand_x0 67 66 359 376 374 375 or21nand_x0
xsubckt_446_or21nand_x0 67 66 513 518 517 514 or21nand_x0
xsubckt_438_nexor2_x0 67 66 521 524 520 nexor2_x0
xsubckt_868_and21nor_x0 67 66 2301 2324 2321 2302 and21nor_x0
xsubckt_949_nand2_x0 67 66 2224 2225 2227 nand2_x0
xsubckt_1131_or21nand_x0 67 66 2047 2058 2053 2050 or21nand_x0
xsubckt_629_or21nand_x0 67 66 339 577 341 340 or21nand_x0
xsubckt_293_nexor2_x0 67 66 652 2385 651 nexor2_x0
xsubckt_796_and2_x1 67 66 2369 3 78 and2_x1
xsubckt_1955_or21nand_x0 67 66 1235 1237 2174 1101 or21nand_x0
xsubckt_60_inv_x0 67 66 14 874 inv_x0
xsubckt_772_or21nand_x0 67 66 204 212 211 205 or21nand_x0
xsubckt_981_and21nor_x0 67 66 2194 2201 2199 2195 and21nor_x0
xsubckt_1177_and3_x1 67 66 2002 806 81 1091 and3_x1
xsubckt_2308_dff_x1 67 66 146 186 60 dff_x1
xsubckt_2206_and4_x1 67 66 966 971 972 974 75 and4_x1
xsubckt_2093_nand3_x0 67 66 1087 767 84 184 nand3_x0
xsubckt_2045_and21nor_x0 67 66 1138 1199 1206 1210 and21nor_x0
xsubckt_2033_nexor2_x0 67 66 1153 1154 1151 nexor2_x0
xsubckt_1633_or21nand_x0 67 66 1556 2171 1560 1557 or21nand_x0
xsubckt_1403_and2_x1 67 66 1780 1781 795 and2_x1
xsubckt_582_and21nor_x0 67 66 383 402 400 401 and21nor_x0
xsubckt_378_nand3_x0 67 66 577 767 182 184 nand3_x0
xsubckt_137_or21nand_x0 67 66 799 802 814 2399 or21nand_x0
xsubckt_919_or21nand_x0 67 66 2253 2270 2267 2269 or21nand_x0
xsubckt_938_nexor2_x0 67 66 9 29 2235 nexor2_x0
xsubckt_1155_and2_x1 67 66 2023 2024 2025 and2_x1
xsubckt_1242_nand2_x0 67 66 1938 1939 796 nand2_x0
xsubckt_2299_dff_x1 67 66 160 186 2384 dff_x1
xsubckt_1503_nand3_x0 67 66 1683 767 860 184 nand3_x0
xsubckt_580_and2_x1 67 66 385 45 82 and2_x1
xsubckt_117_or2_x1 67 66 817 818 1306 or2_x1
xsubckt_298_nand3_x0 67 66 647 648 674 681 nand3_x0
xsubckt_650_nand3_x0 67 66 319 321 328 338 nand3_x0
xsubckt_963_mux2_x1 67 66 29 2212 586 99 mux2_x1
xsubckt_1113_and21nor_x0 67 66 2064 780 2079 2065 and21nor_x0
xsubckt_2102_and21nor_x0 67 66 1077 791 1084 1083 and21nor_x0
xsubckt_1661_nexor2_x0 67 66 1555 850 1529 nexor2_x0
xsubckt_1479_nand4_x0 67 66 1706 73 13 71 72 nand4_x0
xsubckt_621_nand2_x0 67 66 346 347 356 nand2_x0
xsubckt_416_nand2_x0 67 66 541 553 587 nand2_x0
xsubckt_661_or21nand_x0 67 66 309 40 578 582 or21nand_x0
xsubckt_2269_and2_x1 67 66 179 903 70 and2_x1
xsubckt_1973_and3_x1 67 66 1216 794 941 185 and3_x1
xsubckt_1780_and21nor_x0 67 66 1413 1428 796 65 and21nor_x0
xsubckt_1747_nand3_x0 67 66 1446 1517 1080 183 nand3_x0
xsubckt_1735_or21nand_x0 67 66 1457 1459 795 1112 or21nand_x0
xsubckt_1422_and2_x1 67 66 1762 1763 920 and2_x1
xsubckt_372_and3_x1 67 66 583 794 182 185 and3_x1
xsubckt_42_inv_x0 67 66 84 892 inv_x0
xsubckt_1274_and3_x1 67 66 1907 806 79 1091 and3_x1
xsubckt_2268_or2_x1 67 66 903 904 905 or2_x1
xsubckt_1945_or21nand_x0 67 66 1246 1290 1291 1296 or21nand_x0
xsubckt_1942_nexor2_x0 67 66 1255 876 1249 nexor2_x0
xsubckt_1931_nand3_x0 67 66 1261 748 86 183 nand3_x0
xsubckt_1914_mux2_x1 67 66 1280 1933 2169 1279 mux2_x1
xsubckt_1750_nand2_x0 67 66 1443 1445 804 nand2_x0
xsubckt_1721_and21nor_x0 67 66 1471 185 1472 1475 and21nor_x0
xsubckt_1476_and2_x1 67 66 1709 1745 885 and2_x1
xsubckt_592_and2_x1 67 66 374 44 84 and2_x1
xsubckt_313_or21nand_x0 67 66 633 635 638 640 or21nand_x0
xsubckt_717_nand2_x0 67 66 257 258 259 nand2_x0
xsubckt_816_xor2_x0 67 66 2 77 2350 xor2_x0
xsubckt_1225_nand3_x0 67 66 1955 1957 1958 807 nand3_x0
xsubckt_2111_nexor2_x0 67 66 1070 1071 1067 nexor2_x0
xsubckt_2015_nand2_x0 67 66 1171 86 1091 nand2_x0
xsubckt_1881_and21nor_x0 67 66 112 1315 1329 65 and21nor_x0
xsubckt_1638_nand2_x0 67 66 1551 1552 779 nand2_x0
xsubckt_1352_nexor2_x0 67 66 1832 1833 1830 nexor2_x0
xsubckt_566_nexor2_x0 67 66 399 402 398 nexor2_x0
xsubckt_444_nand2_x0 67 66 515 86 87 nand2_x0
xsubckt_412_or2_x1 67 66 545 39 56 or2_x1
xsubckt_335_and4_x1 67 66 614 656 825 828 1284 and4_x1
xsubckt_4_inv_x0 67 66 2397 1263 inv_x0
xsubckt_208_and21nor_x0 67 66 731 755 761 764 and21nor_x0
xsubckt_658_nexor2_x0 67 66 40 61 312 nexor2_x0
xsubckt_940_nexor2_x0 67 66 2234 2236 2233 nexor2_x0
xsubckt_985_nand2_x0 67 66 2190 2192 579 nand2_x0
xsubckt_2328_dff_x1 67 66 110 186 24 dff_x1
xsubckt_2283_dff_x1 67 66 177 186 73 dff_x1
xsubckt_2032_and21nor_x0 67 66 1152 1204 1194 1203 and21nor_x0
xsubckt_1890_nand3_x0 67 66 1305 1407 1080 183 nand3_x0
xsubckt_1631_nand2_x0 67 66 1558 2175 888 nand2_x0
xsubckt_1569_nand2_x0 67 66 1618 1619 2177 nand2_x0
xsubckt_639_and2_x1 67 66 330 41 61 and2_x1
xsubckt_547_nexor2_x0 67 66 417 418 416 nexor2_x0
xsubckt_135_nand2_x0 67 66 801 803 187 nand2_x0
xsubckt_16_inv_x0 67 66 72 1134 inv_x0
xsubckt_654_and21nor_x0 67 66 315 316 323 587 and21nor_x0
xsubckt_845_and21nor_x0 67 66 2322 2323 2325 586 and21nor_x0
xsubckt_921_and2_x1 67 66 2251 10 74 and2_x1
xsubckt_2248_and21nor_x0 67 66 922 942 943 946 and21nor_x0
xsubckt_1999_and3_x1 67 66 1188 1189 1191 2179 and3_x1
xsubckt_1603_nand2_x0 67 66 1585 1589 83 nand2_x0
xsubckt_1494_and21nor_x0 67 66 1691 1752 1759 1762 and21nor_x0
xsubckt_1332_and2_x1 67 66 1850 1851 804 and2_x1
xsubckt_341_mux2_x1 67 66 822 610 813 608 mux2_x1
xsubckt_1057_nand3_x0 67 66 2119 2121 2176 1134 nand3_x0
xsubckt_1076_and3_x1 67 66 2101 748 876 183 and3_x1
xsubckt_2353_dff_x1 67 66 131 186 40 dff_x1
xsubckt_1905_or21nand_x0 67 66 1289 1333 1334 1338 or21nand_x0
xsubckt_1615_and21nor_x0 67 66 1573 1574 1575 65 and21nor_x0
xsubckt_139_xor2_x0 67 66 2399 2398 798 xor2_x0
xsubckt_47_inv_x0 67 66 32 887 inv_x0
xsubckt_230_and21nor_x0 67 66 710 739 734 718 and21nor_x0
xsubckt_256_nand2_x0 67 66 685 2380 65 nand2_x0
xsubckt_889_xor2_x0 67 66 12 76 2281 xor2_x0
xsubckt_1025_and2_x1 67 66 2151 2152 804 and2_x1
xsubckt_1238_nexor2_x0 67 66 1948 994 1942 nexor2_x0
xsubckt_2128_nand3_x0 67 66 1050 1652 1653 2172 nand3_x0
xsubckt_1903_nexor2_x0 67 66 1298 875 1291 nexor2_x0
xsubckt_1782_and21nor_x0 67 66 1412 1426 1432 1436 and21nor_x0
xsubckt_1464_and2_x1 67 66 1721 1722 791 and2_x1
xsubckt_606_nand2_x0 67 66 361 43 83 nand2_x0
xsubckt_517_and2_x1 67 66 445 446 578 and2_x1
xsubckt_349_and21nor_x0 67 66 601 1295 614 602 and21nor_x0
xsubckt_26_inv_x0 67 66 62 1026 inv_x0
xsubckt_706_nexor2_x0 67 66 268 271 267 nexor2_x0
xsubckt_2003_or21nand_x0 67 66 1183 1184 1188 1112 or21nand_x0
xsubckt_1701_and3_x1 67 66 1491 794 973 185 and3_x1
xsubckt_1680_and21nor_x0 67 66 1511 951 184 183 and21nor_x0
xsubckt_1644_or21nand_x0 67 66 1545 1546 795 1112 or21nand_x0
xsubckt_459_nexor2_x0 67 66 501 502 500 nexor2_x0
xsubckt_250_nand2_x0 67 66 691 1101 2388 nand2_x0
xsubckt_852_or21nand_x0 67 66 2316 2346 2343 2345 or21nand_x0
xsubckt_917_nand2_x0 67 66 2254 2255 2264 nand2_x0
xsubckt_980_nand2_x0 67 66 2195 2197 804 nand2_x0
xsubckt_993_or21nand_x0 67 66 2182 2186 2211 849 or21nand_x0
xsubckt_2367_dff_x1 67 66 101 186 10 dff_x1
xsubckt_2273_nand2_x0 67 66 899 838 65 nand2_x0
xsubckt_1930_nand3_x0 67 66 1262 1358 1080 183 nand3_x0
xsubckt_1775_and21nor_x0 67 66 1418 1422 1421 1419 and21nor_x0
xsubckt_1692_or21nand_x0 67 66 1499 1500 187 1112 or21nand_x0
xsubckt_1681_and21nor_x0 67 66 1510 185 1511 1512 and21nor_x0
xsubckt_1581_and2_x1 67 66 1607 843 65 and2_x1
xsubckt_1281_and3_x1 67 66 1900 1902 1918 56 and3_x1
xsubckt_6_inv_x0 67 66 2386 1241 inv_x0
xsubckt_727_nand2_x0 67 66 247 6 81 nand2_x0
xsubckt_794_or21nand_x0 67 66 2371 210 209 208 or21nand_x0
xsubckt_999_and2_x1 67 66 2176 73 71 and2_x1
xsubckt_1040_nand3_x0 67 66 2136 2140 2161 1026 nand3_x0
xsubckt_2183_nor3_x0 67 66 990 991 992 187 nor3_x0
xsubckt_2168_mux2_x1 67 66 83 1009 791 1007 mux2_x1
xsubckt_2126_and21nor_x0 67 66 1051 1066 1056 1052 and21nor_x0
xsubckt_2041_or21nand_x0 67 66 1142 2174 1146 1143 or21nand_x0
xsubckt_1960_and2_x1 67 66 1230 842 65 and2_x1
xsubckt_1824_nand4_x0 67 66 1370 73 6 1123 1134 nand4_x0
xsubckt_1556_or21nand_x0 67 66 1631 1674 1663 1671 or21nand_x0
xsubckt_1523_or21nand_x0 67 66 1663 1711 1713 1717 or21nand_x0
xsubckt_1310_nand2_x0 67 66 1871 1872 1112 nand2_x0
xsubckt_1308_and2_x1 67 66 1873 1874 1101 and2_x1
xsubckt_537_nand2_x0 67 66 426 33 87 nand2_x0
xsubckt_106_nor2_x0 67 66 828 2385 2384 nor2_x0
xsubckt_72_inv_x0 67 66 76 862 inv_x0
xsubckt_172_or2_x1 67 66 766 185 183 or2_x1
xsubckt_178_nexor2_x0 67 66 765 1177 760 nexor2_x0
xsubckt_191_nor2_x0 67 66 748 185 184 nor2_x0
xsubckt_669_xor2_x0 67 66 25 24 302 xor2_x0
xsubckt_821_nor2_x0 67 66 2346 1 79 nor2_x0
xsubckt_902_nand2_x0 67 66 2269 11 75 nand2_x0
xsubckt_2318_dff_x1 67 66 150 186 84 dff_x1
xsubckt_2039_nand4_x0 67 66 1145 73 859 1123 1134 nand4_x0
xsubckt_2022_and21nor_x0 67 66 1163 1181 1172 1164 and21nor_x0
xsubckt_1827_or21nand_x0 67 66 1367 779 1378 1368 or21nand_x0
xsubckt_1531_and21nor_x0 67 66 1655 2172 1659 1656 and21nor_x0
xsubckt_576_or21nand_x0 67 66 389 409 407 408 or21nand_x0
xsubckt_509_nand2_x0 67 66 453 83 84 nand2_x0
xsubckt_400_nand2_x0 67 66 557 88 89 nand2_x0
xsubckt_947_nand4_x0 67 66 2226 2230 2235 2245 2262 nand4_x0
xsubckt_2217_or2_x1 67 66 954 955 961 or2_x1
xsubckt_1819_and21nor_x0 67 66 1375 2172 2018 1376 and21nor_x0
xsubckt_1392_and3_x1 67 66 1791 1887 889 891 and3_x1
xsubckt_311_or21nand_x0 67 66 635 827 655 813 or21nand_x0
xsubckt_776_or2_x1 67 66 201 219 238 or2_x1
xsubckt_2235_nand4_x0 67 66 935 73 851 1123 1134 nand4_x0
xsubckt_2012_nand3_x0 67 66 1174 748 84 183 nand3_x0
xsubckt_1426_and2_x1 67 66 1758 1763 87 and2_x1
xsubckt_344_and2_x1 67 66 170 606 607 and2_x1
xsubckt_709_nand2_x0 67 66 264 278 587 nand2_x0
xsubckt_1210_nand2_x0 67 66 1969 1970 1112 nand2_x0
xsubckt_2052_and21nor_x0 67 66 1131 2169 1744 1132 and21nor_x0
xsubckt_1620_nand2_x0 67 66 1569 1570 82 nand2_x0
xsubckt_1534_or21nand_x0 67 66 1652 13 1738 12 or21nand_x0
xsubckt_403_or21nand_x0 67 66 554 89 57 56 or21nand_x0
xsubckt_10_inv_x0 67 66 2398 1198 inv_x0
xsubckt_186_and21nor_x0 67 66 752 780 754 753 and21nor_x0
xsubckt_645_and21nor_x0 67 66 324 881 577 583 and21nor_x0
xsubckt_750_nexor2_x0 67 66 226 227 225 nexor2_x0
xsubckt_2062_and3_x1 67 66 1120 83 1080 183 and3_x1
xsubckt_2031_or21nand_x0 67 66 1153 1205 1193 1202 or21nand_x0
xsubckt_1993_and21nor_x0 67 66 1194 1243 1249 1254 and21nor_x0
xsubckt_1789_nand3_x0 67 66 1405 2209 87 1069 nand3_x0
xsubckt_1640_or2_x1 67 66 1549 1550 796 or2_x1
xsubckt_1370_nand3_x0 67 66 1813 806 864 1091 nand3_x0
xsubckt_697_nor2_x0 67 66 276 27 7 nor2_x0
xsubckt_773_and2_x1 67 66 203 218 587 and2_x1
xsubckt_856_nexor2_x0 67 66 2313 2316 2312 nexor2_x0
xsubckt_1096_and21nor_x0 67 66 2081 2128 2136 2139 and21nor_x0
xsubckt_2360_dff_x1 67 66 94 186 3 dff_x1
xsubckt_2245_or21nand_x0 67 66 925 928 943 947 or21nand_x0
xsubckt_2192_and2_x1 67 66 981 1599 2172 and2_x1
xsubckt_1998_and21nor_x0 67 66 1189 2169 1868 1190 and21nor_x0
xsubckt_1950_nand2_x0 67 66 1240 2175 876 nand2_x0
xsubckt_1763_and21nor_x0 67 66 1430 1506 1463 1467 and21nor_x0
xsubckt_1481_and2_x1 67 66 1704 1705 1706 and2_x1
xsubckt_624_or2_x1 67 66 344 42 82 or2_x1
xsubckt_92_inv_x0 67 66 23 842 inv_x0
xsubckt_711_or21nand_x0 67 66 263 282 279 281 or21nand_x0
xsubckt_1253_nand2_x0 67 66 1927 1928 1101 nand2_x0
xsubckt_1262_and3_x1 67 66 1919 794 872 185 and3_x1
xsubckt_2323_dff_x1 67 66 121 186 30 dff_x1
xsubckt_2288_dff_x1 67 66 156 186 72 dff_x1
xsubckt_2118_nand4_x0 67 66 1060 73 855 1123 1134 nand4_x0
xsubckt_2110_and21nor_x0 67 66 1068 1107 1102 1106 and21nor_x0
xsubckt_1898_nor2_x0 67 66 1297 1298 875 nor2_x0
xsubckt_1670_and3_x1 67 66 1521 794 1026 185 and3_x1
xsubckt_1353_and21nor_x0 67 66 1829 780 1830 1858 and21nor_x0
xsubckt_469_and2_x1 67 66 491 36 56 and2_x1
xsubckt_147_mux2_x1 67 66 1080 793 185 790 mux2_x1
xsubckt_277_nand4_x0 67 66 665 816 817 830 90 nand4_x0
xsubckt_651_nand4_x0 67 66 318 322 327 337 354 nand4_x0
xsubckt_941_and21nor_x0 67 66 2232 851 577 583 and21nor_x0
xsubckt_1034_nand2_x0 67 66 2142 2144 791 nand2_x0
xsubckt_1036_or21nand_x0 67 66 2140 2149 2145 2143 or21nand_x0
xsubckt_1182_or21nand_x0 67 66 1997 2008 2003 2000 or21nand_x0
xsubckt_1265_nand2_x0 67 66 1916 75 185 nand2_x0
xsubckt_2221_nand2_x0 67 66 950 16 65 nand2_x0
xsubckt_2042_and2_x1 67 66 1141 1142 795 and2_x1
xsubckt_1880_or21nand_x0 67 66 1315 1101 1326 1316 or21nand_x0
xsubckt_1855_mux2_x1 67 66 994 1347 791 1340 mux2_x1
xsubckt_1336_and3_x1 67 66 1846 767 79 184 and3_x1
xsubckt_209_or21nand_x0 67 66 730 756 760 763 or21nand_x0
xsubckt_294_mux2_x1 67 66 651 2377 65 161 mux2_x1
xsubckt_300_or21nand_x0 67 66 645 2392 1101 1252 or21nand_x0
xsubckt_653_or2_x1 67 66 316 317 320 or2_x1
xsubckt_968_and3_x1 67 66 2207 185 184 183 and3_x1
xsubckt_1101_or3_x1 67 66 2076 39 46 47 or3_x1
xsubckt_1236_nand3_x0 67 66 1944 1949 1966 57 nand3_x0
xsubckt_2106_nand3_x0 67 66 1073 1078 1081 78 nand3_x0
xsubckt_1878_nor2_x0 67 66 1317 1318 1320 nor2_x0
xsubckt_1397_nand2_x0 67 66 1786 1787 2177 nand2_x0
xsubckt_386_or2_x1 67 66 570 60 46 or2_x1
xsubckt_314_nand2_x0 67 66 632 634 2397 nand2_x0
xsubckt_672_nexor2_x0 67 66 300 15 299 nexor2_x0
xsubckt_1067_and21nor_x0 67 66 153 2110 2129 65 and21nor_x0
xsubckt_1125_nand3_x0 67 66 2053 2055 2056 807 nand3_x0
xsubckt_2048_and2_x1 67 66 1135 1136 1140 and2_x1
xsubckt_1994_or21nand_x0 67 66 1193 1244 1248 1253 or21nand_x0
xsubckt_1433_or21nand_x0 67 66 1751 1778 1801 1802 or21nand_x0
xsubckt_626_nexor2_x0 67 66 42 82 342 nexor2_x0
xsubckt_355_or21nand_x0 67 66 596 613 2394 1306 or21nand_x0
xsubckt_108_and21nor_x0 67 66 826 2386 831 827 and21nor_x0
xsubckt_301_and2_x1 67 66 644 645 813 and2_x1
xsubckt_724_and21nor_x0 67 66 250 578 252 251 and21nor_x0
xsubckt_1197_and2_x1 67 66 1982 2019 867 and2_x1
xsubckt_2157_nexor2_x0 67 66 1020 1027 1018 nexor2_x0
xsubckt_1852_nand2_x0 67 66 1343 1361 791 nand2_x0
xsubckt_1655_and2_x1 67 66 1535 1536 1537 and2_x1
xsubckt_1560_or21nand_x0 67 66 1627 1667 1676 1677 or21nand_x0
xsubckt_1469_and21nor_x0 67 66 1716 1720 1729 902 and21nor_x0
xsubckt_1314_nexor2_x0 67 66 1887 34 1868 nexor2_x0
xsubckt_419_nand2_x0 67 66 130 539 541 nand2_x0
xsubckt_255_or21nand_x0 67 66 686 696 689 687 or21nand_x0
xsubckt_866_or21nand_x0 67 66 2303 75 29 74 or21nand_x0
xsubckt_936_nand2_x0 67 66 2237 9 29 nand2_x0
xsubckt_959_nand3_x0 67 66 2215 2220 2227 2237 nand3_x0
xsubckt_1133_or21nand_x0 67 66 2045 2048 2063 951 or21nand_x0
xsubckt_2121_and2_x1 67 66 1056 1057 795 and2_x1
xsubckt_2095_and2_x1 67 66 1085 1086 1087 and2_x1
xsubckt_1938_and21nor_x0 67 66 1254 1256 1258 876 and21nor_x0
xsubckt_1317_and2_x1 67 66 1865 1866 2177 and2_x1
xsubckt_953_xor2_x0 67 66 8 29 2221 xor2_x0
xsubckt_1048_and21nor_x0 67 66 2128 2185 2210 849 and21nor_x0
xsubckt_2329_dff_x1 67 66 109 186 81 dff_x1
xsubckt_2282_dff_x1 67 66 179 186 182 dff_x1
xsubckt_1937_nand2_x0 67 66 1255 1256 1258 nand2_x0
xsubckt_1781_and2_x1 67 66 114 1413 1414 and2_x1
xsubckt_1613_or2_x1 67 66 1575 1576 1582 or2_x1
xsubckt_545_xor2_x0 67 66 33 84 418 xor2_x0
xsubckt_452_nexor2_x0 67 66 508 509 507 nexor2_x0
xsubckt_687_nexor2_x0 67 66 286 289 285 nexor2_x0
xsubckt_2238_and21nor_x0 67 66 932 938 936 933 and21nor_x0
xsubckt_1990_or21nand_x0 67 66 1197 1247 1249 1250 or21nand_x0
xsubckt_1891_nand2_x0 67 66 1304 1305 1307 nand2_x0
xsubckt_1687_nexor2_x0 67 66 1509 31 1504 nexor2_x0
xsubckt_1665_and2_x1 67 66 1525 1526 1101 and2_x1
xsubckt_1491_and21nor_x0 67 66 1694 1695 1699 796 and21nor_x0
xsubckt_1482_or21nand_x0 67 66 1703 2171 1707 1704 or21nand_x0
xsubckt_1437_or21nand_x0 67 66 1747 1799 1800 1804 or21nand_x0
xsubckt_1428_nor2_x0 67 66 1756 1763 87 nor2_x0
xsubckt_491_and2_x1 67 66 470 471 587 and2_x1
xsubckt_38_inv_x0 67 66 86 902 inv_x0
xsubckt_1_inv_x0 67 66 2394 1295 inv_x0
xsubckt_698_nand2_x0 67 66 275 27 7 nand2_x0
xsubckt_2280_dff_x1 67 66 178 186 90 dff_x1
xsubckt_2147_and21nor_x0 67 66 1029 1035 1038 77 and21nor_x0
xsubckt_1487_and3_x1 67 66 1698 73 885 1123 and3_x1
xsubckt_596_and21nor_x0 67 66 370 578 372 371 and21nor_x0
xsubckt_151_nexor2_x0 67 66 790 2398 786 nexor2_x0
xsubckt_20_inv_x0 67 66 183 1091 inv_x0
xsubckt_291_nand4_x0 67 66 653 816 817 829 90 nand4_x0
xsubckt_705_xor2_x0 67 66 7 24 268 xor2_x0
xsubckt_1164_and21nor_x0 67 66 2014 780 2030 2015 and21nor_x0
xsubckt_2077_and2_x1 67 66 1104 1109 1111 and2_x1
xsubckt_1623_nexor2_x0 67 66 1571 82 1566 nexor2_x0
xsubckt_788_nor2_x0 67 66 189 3 81 nor2_x0
xsubckt_814_nor2_x0 67 66 2352 2 77 nor2_x0
xsubckt_897_nexor2_x0 67 66 2274 2277 2273 nexor2_x0
xsubckt_1925_nand3_x0 67 66 1268 2209 84 1069 nand3_x0
xsubckt_1312_and2_x1 67 66 142 1870 1891 and2_x1
xsubckt_406_nor2_x0 67 66 551 59 39 nor2_x0
xsubckt_391_and2_x1 67 66 565 58 47 and2_x1
xsubckt_383_mux2_x1 67 66 573 584 587 138 mux2_x1
xsubckt_40_inv_x0 67 66 85 894 inv_x0
xsubckt_2320_dff_x1 67 66 148 186 82 dff_x1
xsubckt_2179_mux2_x1 67 66 71 862 848 995 mux2_x1
xsubckt_1982_nand3_x0 67 66 1206 1212 1215 81 nand3_x0
xsubckt_1947_and21nor_x0 67 66 1244 1283 1291 1294 and21nor_x0
xsubckt_1935_and2_x1 67 66 1257 1270 791 and2_x1
xsubckt_1759_and2_x1 67 66 1434 1437 28 and2_x1
xsubckt_364_and21nor_x0 67 66 158 590 591 65 and21nor_x0
xsubckt_321_nand3_x0 67 66 626 628 629 2396 nand3_x0
xsubckt_304_mux2_x1 67 66 642 2376 65 160 mux2_x1
xsubckt_683_nand2_x0 67 66 289 26 15 nand2_x0
xsubckt_799_nand2_x0 67 66 2366 2367 583 nand2_x0
xsubckt_870_nand2_x0 67 66 2299 13 77 nand2_x0
xsubckt_1037_and21nor_x0 67 66 2139 2140 2161 1026 and21nor_x0
xsubckt_1136_and3_x1 67 66 2042 2047 2062 951 and3_x1
xsubckt_1194_or21nand_x0 67 66 1985 2031 2044 2045 or21nand_x0
xsubckt_2334_dff_x1 67 66 118 186 76 dff_x1
xsubckt_2233_mux2_x1 67 66 1123 74 848 937 mux2_x1
xsubckt_1805_nand2_x0 67 66 1389 1390 1394 nand2_x0
xsubckt_1761_nexor2_x0 67 66 1438 873 1432 nexor2_x0
xsubckt_1755_mux2_x1 67 66 951 1440 791 1438 mux2_x1
xsubckt_1301_and4_x1 67 66 1880 2019 863 865 867 and4_x1
xsubckt_628_and21nor_x0 67 66 340 882 577 583 and21nor_x0
xsubckt_521_nand2_x0 67 66 441 34 85 nand2_x0
xsubckt_295_and21nor_x0 67 66 650 831 2386 2385 and21nor_x0
xsubckt_679_xor2_x0 67 66 28 14 293 xor2_x0
xsubckt_700_nexor2_x0 67 66 274 277 273 nexor2_x0
xsubckt_756_xor2_x0 67 66 77 78 220 xor2_x0
xsubckt_887_or2_x1 67 66 2283 12 76 or2_x1
xsubckt_972_nand2_x0 67 66 2203 2208 847 nand2_x0
xsubckt_1019_and4_x1 67 66 2157 2158 2159 2160 768 and4_x1
xsubckt_1264_nand3_x0 67 66 1917 2209 76 1069 nand3_x0
xsubckt_2208_and2_x1 67 66 964 969 860 and2_x1
xsubckt_2171_nand2_x0 67 66 1003 1008 76 nand2_x0
xsubckt_2137_mux2_x1 67 66 82 1041 804 1040 mux2_x1
xsubckt_1908_nand3_x0 67 66 1286 1287 1288 796 nand3_x0
xsubckt_1831_nand2_x0 67 66 1363 1364 796 nand2_x0
xsubckt_1682_and21nor_x0 67 66 1509 1510 1513 1521 and21nor_x0
xsubckt_1555_nexor2_x0 67 66 1638 84 1632 nexor2_x0
xsubckt_1520_nexor2_x0 67 66 1668 1670 1666 nexor2_x0
xsubckt_476_nand2_x0 67 66 484 36 87 nand2_x0
xsubckt_471_nexor2_x0 67 66 490 493 489 nexor2_x0
xsubckt_200_or2_x1 67 66 739 743 1166 or2_x1
xsubckt_202_nexor2_x0 67 66 743 2390 737 nexor2_x0
xsubckt_205_nand2_x0 67 66 734 736 737 nand2_x0
xsubckt_309_or2_x1 67 66 637 639 661 or2_x1
xsubckt_830_xor2_x0 67 66 1 76 2337 xor2_x0
xsubckt_1214_nand3_x0 67 66 1966 794 876 185 nand3_x0
xsubckt_2134_and21nor_x0 67 66 1043 1050 1047 1044 and21nor_x0
xsubckt_329_nand2_x0 67 66 619 621 624 nand2_x0
xsubckt_144_or2_x1 67 66 793 184 183 or2_x1
xsubckt_31_inv_x0 67 66 60 973 inv_x0
xsubckt_8_inv_x0 67 66 2388 1220 inv_x0
xsubckt_1176_nand3_x0 67 66 2003 2005 2006 807 nand3_x0
xsubckt_2355_dff_x1 67 66 105 186 14 dff_x1
xsubckt_2266_and4_x1 67 66 905 185 184 183 187 and4_x1
xsubckt_2239_or2_x1 67 66 931 932 796 or2_x1
xsubckt_1837_nand2_x0 67 66 1358 85 185 nand2_x0
xsubckt_1621_and2_x1 67 66 1568 1571 82 and2_x1
xsubckt_1521_nand2_x0 67 66 1665 1666 796 nand2_x0
xsubckt_1338_nand2_x0 67 66 1844 1845 791 nand2_x0
xsubckt_359_or21nand_x0 67 66 593 187 182 185 or21nand_x0
xsubckt_333_and21nor_x0 67 66 615 1284 618 65 and21nor_x0
xsubckt_125_and2_x1 67 66 156 810 811 and2_x1
xsubckt_81_inv_x0 67 66 11 853 inv_x0
xsubckt_218_and21nor_x0 67 66 722 747 1091 1209 and21nor_x0
xsubckt_235_nexor2_x0 67 66 834 2389 705 nexor2_x0
xsubckt_702_or21nand_x0 67 66 271 289 288 287 or21nand_x0
xsubckt_738_nexor2_x0 67 66 239 241 237 nexor2_x0
xsubckt_783_nand3_x0 67 66 194 195 200 201 nand3_x0
xsubckt_792_and2_x1 67 66 2373 2374 578 and2_x1
xsubckt_937_xor2_x0 67 66 9 29 2236 xor2_x0
xsubckt_2103_and21nor_x0 67 66 1076 1078 1081 866 and21nor_x0
xsubckt_2011_and3_x1 67 66 1175 1266 1080 183 and3_x1
xsubckt_1718_nand3_x0 67 66 1474 767 59 184 nand3_x0
xsubckt_1390_nexor2_x0 67 66 1863 859 1793 nexor2_x0
xsubckt_512_or21nand_x0 67 66 450 469 468 467 or21nand_x0
xsubckt_138_and3_x1 67 66 175 799 800 1112 and3_x1
xsubckt_1066_or2_x1 67 66 2110 2111 2124 or2_x1
xsubckt_1153_nand2_x0 67 66 2025 2169 869 nand2_x0
xsubckt_2285_dff_x1 67 66 159 186 185 dff_x1
xsubckt_1911_nexor2_x0 67 66 1285 1292 1282 nexor2_x0
xsubckt_445_xor2_x0 67 66 86 87 514 xor2_x0
xsubckt_164_nand2_x0 67 66 773 774 781 nand2_x0
xsubckt_808_and2_x1 67 66 2358 2 80 and2_x1
xsubckt_1259_nand2_x0 67 66 1921 1922 1112 nand2_x0
xsubckt_2354_dff_x1 67 66 106 186 15 dff_x1
xsubckt_1984_or21nand_x0 67 66 1204 1213 1216 81 or21nand_x0
xsubckt_1558_nexor2_x0 67 66 1631 1633 1629 nexor2_x0
xsubckt_1492_or21nand_x0 67 66 1693 779 1710 1694 or21nand_x0
xsubckt_567_nand2_x0 67 66 397 398 583 nand2_x0
xsubckt_1077_nor3_x0 67 66 2100 2101 2102 808 nor3_x0
xsubckt_240_nexor2_x0 67 66 794 1220 701 nexor2_x0
xsubckt_997_and3_x1 67 66 2178 73 1123 72 and3_x1
xsubckt_1109_nand4_x0 67 66 2068 73 39 1123 1134 nand4_x0
xsubckt_1913_nand2_x0 67 66 1280 2175 875 nand2_x0
xsubckt_1744_and3_x1 67 66 1449 1450 1451 768 and3_x1
xsubckt_1290_nand2_x0 67 66 1891 1892 796 nand2_x0
xsubckt_55_inv_x0 67 66 15 879 inv_x0
xsubckt_682_or21nand_x0 67 66 290 291 577 582 or21nand_x0
xsubckt_831_and21nor_x0 67 66 2336 2353 2351 2352 and21nor_x0
xsubckt_1016_nand2_x0 67 66 2160 2207 870 nand2_x0
xsubckt_1021_nand4_x0 67 66 2155 24 185 1080 183 nand4_x0
xsubckt_1146_and21nor_x0 67 66 2032 2080 2087 2091 and21nor_x0
xsubckt_1252_nand4_x0 67 66 1928 73 36 1123 1134 nand4_x0
xsubckt_2149_or2_x1 67 66 1027 1029 1031 or2_x1
xsubckt_1732_nand2_x0 67 66 1460 1461 780 nand2_x0
xsubckt_387_and2_x1 67 66 569 60 46 and2_x1
xsubckt_90_inv_x0 67 66 50 844 inv_x0
xsubckt_1020_nand4_x0 67 66 2156 2158 2159 2160 768 nand4_x0
xsubckt_1580_nor2_x0 67 66 150 1608 1644 nor2_x0
xsubckt_1498_mux2_x1 67 66 1688 52 65 152 mux2_x1
xsubckt_1356_nexor2_x0 67 66 1828 1834 1826 nexor2_x0
xsubckt_550_and21nor_x0 67 66 124 586 414 428 and21nor_x0
xsubckt_485_or2_x1 67 66 476 84 85 or2_x1
xsubckt_374_nand4_x0 67 66 581 794 58 182 185 nand4_x0
xsubckt_736_xor2_x0 67 66 78 79 239 xor2_x0
xsubckt_824_or21nand_x0 67 66 2343 2360 2358 2359 or21nand_x0
xsubckt_859_and21nor_x0 67 66 2309 2339 2336 2338 and21nor_x0
xsubckt_867_nand3_x0 67 66 2302 2303 683 182 nand3_x0
xsubckt_1054_nand2_x0 67 66 2122 2175 62 nand2_x0
xsubckt_1150_nexor2_x0 67 66 2077 38 2028 nexor2_x0
xsubckt_2368_dff_x1 67 66 100 186 9 dff_x1
xsubckt_2212_or21nand_x0 67 66 959 999 1002 1003 or21nand_x0
xsubckt_2115_nand2_x0 67 66 1063 1064 2177 nand2_x0
xsubckt_1776_nand4_x0 67 66 1417 73 7 1123 1134 nand4_x0
xsubckt_1643_nexor2_x0 67 66 1547 1566 1546 nexor2_x0
xsubckt_1455_and3_x1 67 66 1730 794 864 185 and3_x1
xsubckt_1420_and3_x1 67 66 1764 1765 1766 791 and3_x1
xsubckt_148_nor2_x0 67 66 789 790 1198 nor2_x0
xsubckt_855_nexor2_x0 67 66 0 78 2313 nexor2_x0
xsubckt_929_nexor2_x0 67 66 10 29 2243 nexor2_x0
xsubckt_1068_and3_x1 67 66 2109 794 871 185 and3_x1
xsubckt_1086_and3_x1 67 66 2091 2093 2108 60 and3_x1
xsubckt_1179_nor3_x0 67 66 2000 2001 2002 792 nor3_x0
xsubckt_2316_dff_x1 67 66 152 186 86 dff_x1
xsubckt_2293_dff_x1 67 66 166 186 2390 dff_x1
xsubckt_2185_nand2_x0 67 66 988 989 795 nand2_x0
xsubckt_1725_and2_x1 67 66 1467 1469 30 and2_x1
xsubckt_1659_nand3_x0 67 66 1531 1532 1533 2177 nand3_x0
xsubckt_1568_and21nor_x0 67 66 1619 853 2169 1620 and21nor_x0
xsubckt_1519_or21nand_x0 67 66 1667 1692 1714 1715 or21nand_x0
xsubckt_1427_nand2_x0 67 66 1757 1763 87 nand2_x0
xsubckt_1375_and3_x1 67 66 1808 794 868 185 and3_x1
xsubckt_779_and2_x1 67 66 198 76 77 and2_x1
xsubckt_2000_and4_x1 67 66 1186 73 861 1123 1134 and4_x1
xsubckt_1813_or21nand_x0 67 66 1381 1391 1395 871 or21nand_x0
xsubckt_1649_and2_x1 67 66 1541 1542 1544 and2_x1
xsubckt_348_nor2_x0 67 66 602 603 796 nor2_x0
xsubckt_146_nand2_x0 67 66 791 794 185 nand2_x0
xsubckt_1543_and2_x1 67 66 1644 844 65 and2_x1
xsubckt_1283_and21nor_x0 67 66 1898 1902 1918 1005 and21nor_x0
xsubckt_369_nand2_x0 67 66 586 683 182 nand2_x0
xsubckt_243_nexor2_x0 67 66 699 700 698 nexor2_x0
xsubckt_926_or2_x1 67 66 2246 10 29 or2_x1
xsubckt_970_nand2_x0 67 66 2205 2207 872 nand2_x0
xsubckt_1114_and2_x1 67 66 146 2064 2082 and2_x1
xsubckt_2065_and3_x1 67 66 1117 61 184 183 and3_x1
xsubckt_1997_and2_x1 67 66 1190 2175 81 and2_x1
xsubckt_1886_nand2_x0 67 66 1310 84 185 nand2_x0
xsubckt_1629_nexor2_x0 67 66 1606 41 1560 nexor2_x0
xsubckt_1576_or21nand_x0 67 66 1611 1617 1614 1612 or21nand_x0
xsubckt_434_and21nor_x0 67 66 524 546 545 544 and21nor_x0
xsubckt_222_nexor2_x0 67 66 744 1209 718 nexor2_x0
xsubckt_873_nexor2_x0 67 66 2297 2298 2296 nexor2_x0
xsubckt_874_or21nand_x0 67 66 2295 13 578 582 or21nand_x0
xsubckt_2190_or21nand_x0 67 66 118 984 987 1014 or21nand_x0
xsubckt_1838_mux2_x1 67 66 1015 1358 2209 1357 mux2_x1
xsubckt_1743_nand3_x0 67 66 1450 2209 88 1069 nand3_x0
xsubckt_577_nexor2_x0 67 66 389 390 388 nexor2_x0
xsubckt_429_and2_x1 67 66 529 38 58 and2_x1
xsubckt_336_nand4_x0 67 66 613 656 825 828 1284 nand4_x0
xsubckt_101_and21nor_x0 67 66 833 835 2390 2389 and21nor_x0
xsubckt_77_inv_x0 67 66 0 857 inv_x0
xsubckt_245_and2_x1 67 66 696 698 780 and2_x1
xsubckt_285_nexor2_x0 67 66 659 1241 658 nexor2_x0
xsubckt_854_and2_x1 67 66 2314 0 78 and2_x1
xsubckt_955_nexor2_x0 67 66 2221 2222 2219 nexor2_x0
xsubckt_995_and2_x1 67 66 2180 73 1123 and2_x1
xsubckt_1103_and4_x1 67 66 2074 73 7 71 72 and4_x1
xsubckt_1227_and3_x1 67 66 1953 767 81 184 and3_x1
xsubckt_1229_or3_x1 67 66 1951 1953 1954 792 or3_x1
xsubckt_2144_and21nor_x0 67 66 1032 1035 1038 864 and21nor_x0
xsubckt_2060_and2_x1 67 66 1122 82 1080 and2_x1
xsubckt_1804_or21nand_x0 67 66 1390 1409 1397 1393 or21nand_x0
xsubckt_1706_nand3_x0 67 66 1486 1488 1080 183 nand3_x0
xsubckt_1627_nexor2_x0 67 66 1564 1566 1562 nexor2_x0
xsubckt_1321_or21nand_x0 67 66 1861 1134 1862 2180 or21nand_x0
xsubckt_595_or21nand_x0 67 66 371 44 578 582 or21nand_x0
xsubckt_393_nor2_x0 67 66 563 46 57 nor2_x0
xsubckt_326_nand2_x0 67 66 622 623 2397 nand2_x0
xsubckt_696_and21nor_x0 67 66 277 297 295 294 and21nor_x0
xsubckt_2321_dff_x1 67 66 147 186 61 dff_x1
xsubckt_2174_or21nand_x0 67 66 1000 1024 1029 1030 or21nand_x0
xsubckt_2114_nand2_x0 67 66 1064 2175 78 nand2_x0
xsubckt_1579_nor2_x0 67 66 1608 1609 1628 nor2_x0
xsubckt_1357_nand2_x0 67 66 1825 1826 796 nand2_x0
xsubckt_636_nand3_x0 67 66 332 333 334 583 nand3_x0
xsubckt_518_or21nand_x0 67 66 444 34 578 582 or21nand_x0
xsubckt_489_and2_x1 67 66 472 473 477 and2_x1
xsubckt_473_or21nand_x0 67 66 487 895 578 582 or21nand_x0
xsubckt_180_nexor2_x0 67 66 759 761 758 nexor2_x0
xsubckt_720_and2_x1 67 66 254 6 26 and2_x1
xsubckt_1052_and21nor_x0 67 66 2124 2125 2126 779 and21nor_x0
xsubckt_1129_nand3_x0 67 66 2049 2051 2052 791 nand3_x0
xsubckt_1243_and21nor_x0 67 66 1937 1984 1990 1993 and21nor_x0
xsubckt_1922_and2_x1 67 66 111 1271 1112 and2_x1
xsubckt_1802_nand2_x0 67 66 1392 1410 791 nand2_x0
xsubckt_1378_and3_x1 67 66 1805 1807 1809 88 and3_x1
xsubckt_389_nexor2_x0 67 66 568 571 567 nexor2_x0
xsubckt_957_or21nand_x0 67 66 2217 8 578 582 or21nand_x0
xsubckt_1161_nand2_x0 67 66 2017 2018 2178 nand2_x0
xsubckt_2345_dff_x1 67 66 125 186 34 dff_x1
xsubckt_1365_and2_x1 67 66 1818 1819 1820 and2_x1
xsubckt_622_mux2_x1 67 66 61 346 586 134 mux2_x1
xsubckt_613_nand2_x0 67 66 354 43 61 nand2_x0
xsubckt_569_mux2_x1 67 66 396 410 587 123 mux2_x1
xsubckt_549_or21nand_x0 67 66 414 422 421 415 or21nand_x0
xsubckt_129_nand2_x0 67 66 807 184 1091 nand2_x0
xsubckt_51_inv_x0 67 66 43 883 inv_x0
xsubckt_177_nexor2_x0 67 66 765 2391 761 nexor2_x0
xsubckt_1010_or21nand_x0 67 66 2165 73 849 1101 or21nand_x0
xsubckt_2125_and2_x1 67 66 1052 1053 796 and2_x1
xsubckt_1571_and4_x1 67 66 1616 1739 853 854 855 and4_x1
xsubckt_1448_or21nand_x0 67 66 1736 1134 1737 2180 or21nand_x0
xsubckt_1443_and2_x1 67 66 1741 1742 2177 and2_x1
xsubckt_1318_or21nand_x0 67 66 1864 2171 1868 1865 or21nand_x0
xsubckt_1313_and2_x1 67 66 1869 1887 891 and2_x1
xsubckt_614_xor2_x0 67 66 43 61 353 xor2_x0
xsubckt_43_inv_x0 67 66 34 891 inv_x0
xsubckt_817_nexor2_x0 67 66 2350 2353 2349 nexor2_x0
xsubckt_1751_and21nor_x0 67 66 1442 1448 1446 1443 and21nor_x0
xsubckt_1572_nexor2_x0 67 66 1654 853 1615 nexor2_x0
xsubckt_328_and2_x1 67 66 620 621 624 and2_x1
xsubckt_48_inv_x0 67 66 61 886 inv_x0
xsubckt_189_mux2_x1 67 66 750 751 813 749 mux2_x1
xsubckt_221_nexor2_x0 67 66 744 2389 719 nexor2_x0
xsubckt_716_and21nor_x0 67 66 258 260 263 586 and21nor_x0
xsubckt_805_nexor2_x0 67 66 2362 2364 2361 nexor2_x0
xsubckt_886_or21nand_x0 67 66 2284 2300 2297 2299 or21nand_x0
xsubckt_1139_or21nand_x0 67 66 2039 2048 2063 59 or21nand_x0
xsubckt_1795_and2_x1 67 66 1399 1400 804 and2_x1
xsubckt_1695_mux2_x1 67 66 1498 2116 2172 1497 mux2_x1
xsubckt_1693_and21nor_x0 67 66 122 187 1504 1499 and21nor_x0
xsubckt_1626_and21nor_x0 67 66 1563 1580 1583 1586 and21nor_x0
xsubckt_1319_and2_x1 67 66 1863 1880 861 and2_x1
xsubckt_388_xor2_x0 67 66 60 46 568 xor2_x0
xsubckt_370_and2_x1 67 66 585 994 56 and2_x1
xsubckt_23_inv_x0 67 66 2379 1058 inv_x0
xsubckt_306_or3_x1 67 66 640 826 1144 2392 or3_x1
xsubckt_892_and21nor_x0 67 66 2278 578 2280 2279 and21nor_x0
xsubckt_939_or21nand_x0 67 66 2234 2253 2251 2252 or21nand_x0
xsubckt_2305_dff_x1 67 66 168 186 2392 dff_x1
xsubckt_1771_and21nor_x0 67 66 1422 2172 2070 1423 and21nor_x0
xsubckt_1282_nand3_x0 67 66 1899 1902 1918 56 nand3_x0
xsubckt_46_inv_x0 67 66 82 888 inv_x0
xsubckt_195_and2_x1 67 66 744 747 1091 and2_x1
xsubckt_787_and21nor_x0 67 66 190 217 216 215 and21nor_x0
xsubckt_2339_dff_x1 67 66 137 186 46 dff_x1
xsubckt_2237_nand3_x0 67 66 933 934 935 779 nand3_x0
xsubckt_1835_and3_x1 67 66 1360 1517 184 1091 and3_x1
xsubckt_1826_and21nor_x0 67 66 1368 1369 1371 796 and21nor_x0
xsubckt_1483_and2_x1 67 66 1702 1739 855 and2_x1
xsubckt_483_or21nand_x0 67 66 478 87 85 86 or21nand_x0
xsubckt_54_inv_x0 67 66 40 880 inv_x0
xsubckt_964_and3_x1 67 66 2211 794 30 185 and3_x1
xsubckt_1212_and2_x1 67 66 144 1968 1986 and2_x1
xsubckt_2202_and3_x1 67 66 970 971 972 974 and3_x1
xsubckt_1904_and21nor_x0 67 66 1290 1332 1335 1339 and21nor_x0
xsubckt_1711_and3_x1 67 66 1481 2209 89 1069 and3_x1
xsubckt_1499_and2_x1 67 66 1687 845 65 and2_x1
xsubckt_922_nexor2_x0 67 66 10 74 2250 nexor2_x0
xsubckt_1207_nand4_x0 67 66 1972 73 37 1123 1134 nand4_x0
xsubckt_1485_nexor2_x0 67 66 1739 855 1700 nexor2_x0
xsubckt_1430_nexor2_x0 67 66 1763 87 1754 nexor2_x0
xsubckt_89_inv_x0 67 66 51 845 inv_x0
xsubckt_12_inv_x0 67 66 2391 1177 inv_x0
xsubckt_225_nand2_x0 67 66 715 716 718 nand2_x0
xsubckt_1235_and3_x1 67 66 1945 1949 1966 57 and3_x1
xsubckt_1240_or21nand_x0 67 66 1940 1989 1990 1994 or21nand_x0
xsubckt_1257_and21nor_x0 67 66 1923 2178 1925 1927 and21nor_x0
xsubckt_2194_or21nand_x0 67 66 979 2168 1605 980 or21nand_x0
xsubckt_2089_nand3_x0 67 66 1092 748 82 183 nand3_x0
xsubckt_1924_and3_x1 67 66 1269 1452 184 1091 and3_x1
xsubckt_1919_and21nor_x0 67 66 1274 1279 1278 1275 and21nor_x0
xsubckt_1887_nand4_x0 67 66 1309 84 185 184 183 nand4_x0
xsubckt_1454_and21nor_x0 67 66 139 1731 1749 1773 and21nor_x0
xsubckt_1421_and21nor_x0 67 66 1763 1764 1767 1772 and21nor_x0
xsubckt_563_nor2_x0 67 66 401 32 83 nor2_x0
xsubckt_343_and21nor_x0 67 66 606 1295 609 65 and21nor_x0
xsubckt_263_nexor2_x0 67 66 683 2387 679 nexor2_x0
xsubckt_292_and2_x1 67 66 652 653 654 and2_x1
xsubckt_832_nexor2_x0 67 66 2336 2337 2335 nexor2_x0
xsubckt_1156_and2_x1 67 66 2022 2023 2026 and2_x1
xsubckt_2101_or2_x1 67 66 1078 1084 792 or2_x1
xsubckt_2056_and21nor_x0 67 66 1127 1133 1131 1128 and21nor_x0
xsubckt_1642_or21nand_x0 67 66 1547 1576 1587 1588 or21nand_x0
xsubckt_1517_or2_x1 67 66 1669 1676 1678 or2_x1
xsubckt_424_or2_x1 67 66 534 535 538 or2_x1
xsubckt_58_inv_x0 67 66 24 876 inv_x0
xsubckt_182_and21nor_x0 67 66 756 778 786 789 and21nor_x0
xsubckt_251_and2_x1 67 66 690 691 813 and2_x1
xsubckt_888_and2_x1 67 66 2282 12 76 and2_x1
xsubckt_991_and3_x1 67 66 2184 2185 2210 63 and3_x1
xsubckt_1271_nand4_x0 67 66 1910 864 185 1080 183 nand4_x0
xsubckt_2325_dff_x1 67 66 113 186 27 dff_x1
xsubckt_1557_and21nor_x0 67 66 1630 1673 1664 1672 and21nor_x0
xsubckt_1522_and21nor_x0 67 66 1664 1712 1714 1718 and21nor_x0
xsubckt_1468_nand3_x0 67 66 1717 1720 1729 86 nand3_x0
xsubckt_1001_and3_x1 67 66 2174 73 1123 1134 and3_x1
xsubckt_1172_nand3_x0 67 66 2007 2009 2010 2011 nand3_x0
xsubckt_2267_and21nor_x0 67 66 904 184 767 1048 and21nor_x0
xsubckt_2159_or21nand_x0 67 66 1016 796 1021 1017 or21nand_x0
xsubckt_2020_nand3_x0 67 66 1165 794 920 185 nand3_x0
xsubckt_1842_nand2_x0 67 66 1353 1354 1355 nand2_x0
xsubckt_1533_nand3_x0 67 66 1653 1739 854 855 nand3_x0
xsubckt_1381_or21nand_x0 67 66 1802 1808 1810 88 or21nand_x0
xsubckt_41_inv_x0 67 66 35 893 inv_x0
xsubckt_928_xor2_x0 67 66 10 29 2244 xor2_x0
xsubckt_1064_and21nor_x0 67 66 2112 2118 2114 2113 and21nor_x0
xsubckt_1528_and21nor_x0 67 66 1658 71 73 85 and21nor_x0
xsubckt_688_nand2_x0 67 66 284 285 583 nand2_x0
xsubckt_884_and3_x1 67 66 2286 683 29 182 and3_x1
xsubckt_895_nand2_x0 67 66 2275 12 29 nand2_x0
xsubckt_1195_and21nor_x0 67 66 1984 2032 2043 2046 and21nor_x0
xsubckt_2344_dff_x1 67 66 126 186 35 dff_x1
xsubckt_1817_nand2_x0 67 66 1377 2028 2169 nand2_x0
xsubckt_593_xor2_x0 67 66 44 84 373 xor2_x0
xsubckt_353_and21nor_x0 67 66 169 813 600 598 and21nor_x0
xsubckt_25_inv_x0 67 66 47 1037 inv_x0
xsubckt_660_and2_x1 67 66 310 311 578 and2_x1
xsubckt_960_or21nand_x0 67 66 2214 2238 2228 2221 or21nand_x0
xsubckt_1211_and21nor_x0 67 66 1968 780 1983 1969 and21nor_x0
xsubckt_2161_nand2_x0 67 66 1014 18 65 nand2_x0
xsubckt_1821_nand2_x0 67 66 1373 38 72 nand2_x0
xsubckt_1625_or21nand_x0 67 66 1564 1581 1584 1585 or21nand_x0
xsubckt_1413_and4_x1 67 66 1771 858 185 1080 183 and4_x1
xsubckt_143_nor2_x0 67 66 794 184 183 nor2_x0
xsubckt_113_nand3_x0 67 66 821 825 826 1284 nand3_x0
xsubckt_839_nand2_x0 67 66 2328 74 75 nand2_x0
xsubckt_891_or21nand_x0 67 66 2279 12 578 582 or21nand_x0
xsubckt_2306_dff_x1 67 66 154 186 63 dff_x1
xsubckt_1978_mux2_x1 67 66 941 1217 791 1211 mux2_x1
xsubckt_1684_nand2_x0 67 66 1507 1509 847 nand2_x0
xsubckt_1438_nexor2_x0 67 66 1748 1753 1746 nexor2_x0
xsubckt_1402_or21nand_x0 67 66 1781 1792 1785 1782 or21nand_x0
xsubckt_1396_and21nor_x0 67 66 1787 859 2169 1788 and21nor_x0
xsubckt_515_xor2_x0 67 66 34 88 447 xor2_x0
xsubckt_290_or21nand_x0 67 66 654 656 657 813 or21nand_x0
xsubckt_315_and21nor_x0 67 66 631 1263 633 65 and21nor_x0
xsubckt_733_nand2_x0 67 66 242 261 281 nand2_x0
xsubckt_1081_nor3_x0 67 66 2096 2097 2098 792 nor3_x0
xsubckt_2330_dff_x1 67 66 108 186 80 dff_x1
xsubckt_1974_nand3_x0 67 66 1215 794 941 185 nand3_x0
xsubckt_1612_or21nand_x0 67 66 1576 1627 1632 1636 or21nand_x0
xsubckt_1295_nexor2_x0 67 66 1934 35 1886 nexor2_x0
xsubckt_638_or2_x1 67 66 133 331 378 or2_x1
xsubckt_163_and21nor_x0 67 66 774 780 776 775 and21nor_x0
xsubckt_212_and2_x1 67 66 727 728 729 and2_x1
xsubckt_664_or21nand_x0 67 66 306 330 320 313 or21nand_x0
xsubckt_920_or2_x1 67 66 2252 10 74 or2_x1
xsubckt_945_and3_x1 67 66 2228 2229 2236 2246 and3_x1
xsubckt_1273_nand3_x0 67 66 1908 1910 1911 807 nand3_x0
xsubckt_2243_or21nand_x0 67 66 926 927 795 1112 or21nand_x0
xsubckt_2160_mux2_x1 67 66 1016 19 65 119 mux2_x1
xsubckt_2148_nand2_x0 67 66 1028 1034 864 nand2_x0
xsubckt_599_nand2_x0 67 66 367 44 61 nand2_x0
xsubckt_366_nand2_x0 67 66 588 589 1112 nand2_x0
xsubckt_1269_nand3_x0 67 66 1912 1914 1915 1917 nand3_x0
xsubckt_2251_and21nor_x0 67 66 918 922 1543 779 and21nor_x0
xsubckt_1882_nand3_x0 67 66 1314 767 89 184 nand3_x0
xsubckt_1699_and4_x1 67 66 1493 73 14 1123 1134 and4_x1
xsubckt_323_and3_x1 67 66 172 625 626 1112 and3_x1
xsubckt_66_inv_x0 67 66 79 868 inv_x0
xsubckt_237_mux2_x1 67 66 704 2381 65 165 mux2_x1
xsubckt_1045_and3_x1 67 66 2131 2132 2134 2182 and3_x1
xsubckt_2201_nand2_x0 67 66 971 683 83 nand2_x0
xsubckt_2151_and21nor_x0 67 66 1024 1068 1072 1076 and21nor_x0
xsubckt_1778_nor2_x0 67 66 1415 1416 1418 nor2_x0
xsubckt_1535_nexor2_x0 67 66 1702 854 1651 nexor2_x0
xsubckt_1511_nand3_x0 67 66 1675 1680 1686 85 nand3_x0
xsubckt_1442_and21nor_x0 67 66 1742 857 2169 1743 and21nor_x0
xsubckt_486_and2_x1 67 66 475 84 85 and2_x1
xsubckt_402_nexor2_x0 67 66 88 89 555 nexor2_x0
xsubckt_644_nexor2_x0 67 66 326 328 325 nexor2_x0
xsubckt_675_and2_x1 67 66 297 30 15 and2_x1
xsubckt_2363_dff_x1 67 66 91 186 0 dff_x1
xsubckt_2244_or21nand_x0 67 66 116 926 929 950 or21nand_x0
xsubckt_1939_nand2_x0 67 66 1253 1255 24 nand2_x0
xsubckt_1912_or2_x1 67 66 1281 1282 779 or2_x1
xsubckt_1866_nand3_x0 67 66 1329 1330 1331 796 nand3_x0
xsubckt_1604_and4_x1 67 66 1584 1591 1592 1593 890 and4_x1
xsubckt_33_inv_x0 67 66 59 951 inv_x0
xsubckt_725_and21nor_x0 67 66 249 271 270 269 and21nor_x0
xsubckt_910_xor2_x0 67 66 11 29 2261 xor2_x0
xsubckt_2281_dff_x1 67 66 181 186 187 dff_x1
xsubckt_1853_and21nor_x0 67 66 1342 1359 1348 1343 and21nor_x0
xsubckt_1371_and2_x1 67 66 1812 1813 1814 and2_x1
xsubckt_1350_and21nor_x0 67 66 1832 1889 1896 1900 and21nor_x0
xsubckt_732_nor3_x0 67 66 243 262 279 282 nor3_x0
xsubckt_932_nand3_x0 67 66 2240 2241 2242 583 nand3_x0
xsubckt_1012_or2_x1 67 66 2163 2164 65 or2_x1
xsubckt_1080_and3_x1 67 66 2097 767 26 184 and3_x1
xsubckt_2219_and21nor_x0 67 66 952 953 954 65 and21nor_x0
xsubckt_478_nexor2_x0 67 66 483 486 482 nexor2_x0
xsubckt_849_nand3_x0 67 66 2319 2321 2323 2328 nand3_x0
xsubckt_913_and2_x1 67 66 2258 2260 2261 and2_x1
xsubckt_984_and2_x1 67 66 2191 2192 579 and2_x1
xsubckt_1089_or21nand_x0 67 66 2088 2094 2109 60 or21nand_x0
xsubckt_1218_nand4_x0 67 66 1962 76 185 184 183 nand4_x0
xsubckt_1473_or21nand_x0 67 66 1712 1748 1756 1757 or21nand_x0
xsubckt_589_nand3_x0 67 66 377 683 61 182 nand3_x0
xsubckt_307_nand3_x0 67 66 639 2386 2385 2384 nand3_x0
xsubckt_1059_nor2_x0 67 66 2117 14 15 nor2_x0
xsubckt_1082_or3_x1 67 66 2095 2097 2098 792 or3_x1
xsubckt_1226_and3_x1 67 66 1954 806 80 1091 and3_x1
xsubckt_2338_dff_x1 67 66 138 186 47 dff_x1
xsubckt_2153_nexor2_x0 67 66 1024 1025 1022 nexor2_x0
xsubckt_2037_and21nor_x0 67 66 1147 2169 1790 1148 and21nor_x0
xsubckt_1858_and21nor_x0 67 66 1337 1341 1345 877 and21nor_x0
xsubckt_1829_or21nand_x0 67 66 1365 1430 1432 1433 or21nand_x0
xsubckt_1602_and2_x1 67 66 1586 1589 83 and2_x1
xsubckt_1496_nand2_x0 67 66 1689 1690 796 nand2_x0
xsubckt_1440_nexor2_x0 67 66 1791 32 1744 nexor2_x0
xsubckt_578_or21nand_x0 67 66 387 45 578 582 or21nand_x0
xsubckt_64_inv_x0 67 66 80 870 inv_x0
xsubckt_1167_nand3_x0 67 66 2012 794 875 185 nand3_x0
xsubckt_1991_nexor2_x0 67 66 1199 1201 1196 nexor2_x0
xsubckt_1328_nand3_x0 67 66 1854 2209 75 1069 nand3_x0
xsubckt_350_nexor2_x0 67 66 601 1155 600 nexor2_x0
xsubckt_1093_or21nand_x0 67 66 2084 2183 2133 2134 or21nand_x0
xsubckt_1094_nexor2_x0 67 66 2085 2086 2083 nexor2_x0
xsubckt_1233_and21nor_x0 67 66 1947 1949 1966 994 and21nor_x0
xsubckt_2260_or21nand_x0 67 66 908 924 923 910 or21nand_x0
xsubckt_2189_or21nand_x0 67 66 984 985 795 1112 or21nand_x0
xsubckt_2130_and21nor_x0 67 66 1047 2169 1660 1049 and21nor_x0
xsubckt_1696_nand2_x0 67 66 1496 1497 2177 nand2_x0
xsubckt_1593_and21nor_x0 67 66 1595 2178 1598 1596 and21nor_x0
xsubckt_1377_and21nor_x0 67 66 1806 791 1811 1808 and21nor_x0
xsubckt_500_or2_x1 67 66 461 35 86 or2_x1
xsubckt_114_nor2_x0 67 66 820 2395 2394 nor2_x0
xsubckt_184_nexor2_x0 67 66 756 760 754 nexor2_x0
xsubckt_228_nand2_x0 67 66 712 1101 2389 nand2_x0
xsubckt_1208_and2_x1 67 66 1971 1972 1101 and2_x1
xsubckt_1222_nand3_x0 67 66 1958 748 868 183 nand3_x0
xsubckt_2241_or21nand_x0 67 66 928 955 967 968 or21nand_x0
xsubckt_1752_or21nand_x0 67 66 1441 1449 1447 1444 or21nand_x0
xsubckt_1617_nand2_x0 67 66 1572 48 65 nand2_x0
xsubckt_1510_and3_x1 67 66 1676 1680 1686 85 and3_x1
xsubckt_1504_and2_x1 67 66 1682 1683 791 and2_x1
xsubckt_1425_or2_x1 67 66 1759 1763 920 or2_x1
xsubckt_463_nand2_x0 67 66 497 513 515 nand2_x0
xsubckt_1239_and21nor_x0 67 66 1941 1988 1991 1995 and21nor_x0
xsubckt_1553_nand2_x0 67 66 1634 1637 84 nand2_x0
xsubckt_453_and21nor_x0 67 66 506 37 577 583 and21nor_x0
xsubckt_299_or21nand_x0 67 66 646 1241 661 647 or21nand_x0
xsubckt_781_xor2_x0 67 66 76 77 196 xor2_x0
xsubckt_875_and21nor_x0 67 66 2294 578 2296 2295 and21nor_x0
xsubckt_1168_nand4_x0 67 66 2011 77 185 184 183 nand4_x0
xsubckt_2180_or21nand_x0 67 66 993 2171 1615 995 or21nand_x0
xsubckt_1875_and21nor_x0 67 66 1320 1324 1323 1321 and21nor_x0
xsubckt_1596_or21nand_x0 67 66 1592 183 184 29 or21nand_x0
xsubckt_1582_and2_x1 67 66 1606 1623 882 and2_x1
xsubckt_1372_or21nand_x0 67 66 1811 1818 1816 1812 or21nand_x0
xsubckt_1297_nand4_x0 67 66 1884 73 3 71 72 nand4_x0
xsubckt_546_and21nor_x0 67 66 417 443 441 442 and21nor_x0
xsubckt_168_nand2_x0 67 66 770 1080 183 nand2_x0
xsubckt_771_nand2_x0 67 66 205 206 583 nand2_x0
xsubckt_1026_nand2_x0 67 66 2150 2152 804 nand2_x0
xsubckt_1084_or21nand_x0 67 66 2093 2104 2099 2096 or21nand_x0
xsubckt_2152_or21nand_x0 67 66 1023 1070 1071 1075 or21nand_x0
xsubckt_1867_or21nand_x0 67 66 1328 1411 1386 1387 or21nand_x0
xsubckt_1419_nand3_x0 67 66 1765 806 76 1091 nand3_x0
xsubckt_544_and2_x1 67 66 419 33 84 and2_x1
xsubckt_479_nand2_x0 67 66 481 482 583 nand2_x0
xsubckt_647_nand3_x0 67 66 322 338 352 353 nand3_x0
xsubckt_2170_and2_x1 67 66 1004 1008 76 and2_x1
xsubckt_1873_nand2_x0 67 66 1322 37 72 nand2_x0
xsubckt_1564_and4_x1 67 66 1623 1745 883 884 885 and4_x1
xsubckt_1514_and3_x1 67 66 1672 1680 1686 894 and3_x1
xsubckt_1374_nand2_x0 67 66 1809 1811 791 nand2_x0
xsubckt_583_and2_x1 67 66 382 383 384 and2_x1
xsubckt_502_xor2_x0 67 66 35 86 459 xor2_x0
xsubckt_492_and21nor_x0 67 66 469 493 492 491 and21nor_x0
xsubckt_104_or21nand_x0 67 66 830 832 2388 2387 or21nand_x0
xsubckt_204_and2_x1 67 66 735 736 737 and2_x1
xsubckt_207_nor2_x0 67 66 732 733 735 nor2_x0
xsubckt_1845_nand2_x0 67 66 1350 1352 804 nand2_x0
xsubckt_1584_nand2_x0 67 66 1604 2169 852 nand2_x0
xsubckt_1513_nand2_x0 67 66 1673 1679 85 nand2_x0
xsubckt_465_nexor2_x0 67 66 85 86 495 nexor2_x0
xsubckt_158_nand2_x0 67 66 779 187 2392 nand2_x0
xsubckt_810_nexor2_x0 67 66 2357 2360 2356 nexor2_x0
xsubckt_1017_nand3_x0 67 66 2159 2209 872 1069 nand3_x0
xsubckt_2117_and21nor_x0 67 66 1061 1062 1065 1698 and21nor_x0
xsubckt_2038_and21nor_x0 67 66 1146 1147 1150 1784 and21nor_x0
xsubckt_2016_and3_x1 67 66 1170 767 86 184 and3_x1
xsubckt_1970_nand2_x0 67 66 1219 1221 804 nand2_x0
xsubckt_1762_nexor2_x0 67 66 1438 28 1431 nexor2_x0
xsubckt_1354_and21nor_x0 67 66 1828 1893 1895 1898 and21nor_x0
xsubckt_468_or2_x1 67 66 492 36 56 or2_x1
xsubckt_145_and2_x1 67 66 792 794 185 and2_x1
xsubckt_130_and2_x1 67 66 806 185 184 and2_x1
xsubckt_94_inv_x0 67 66 70 840 inv_x0
xsubckt_29_inv_x0 67 66 57 994 inv_x0
xsubckt_199_nor2_x0 67 66 740 743 1166 nor2_x0
xsubckt_236_mux2_x1 67 66 705 707 813 704 mux2_x1
xsubckt_933_and21nor_x0 67 66 2239 2240 2247 587 and21nor_x0
xsubckt_1000_nand2_x0 67 66 2175 73 71 nand2_x0
xsubckt_2361_dff_x1 67 66 93 186 2 dff_x1
xsubckt_1720_and21nor_x0 67 66 1472 1015 184 183 and21nor_x0
xsubckt_1654_and21nor_x0 67 66 1536 1539 1544 779 and21nor_x0
xsubckt_426_nand2_x0 67 66 532 533 534 nand2_x0
xsubckt_411_or21nand_x0 67 66 546 564 563 562 or21nand_x0
xsubckt_196_mux2_x1 67 66 183 745 747 743 mux2_x1
xsubckt_275_or21nand_x0 67 66 667 668 673 813 or21nand_x0
xsubckt_714_xor2_x0 67 66 79 80 260 xor2_x0
xsubckt_927_nand2_x0 67 66 2245 10 29 nand2_x0
xsubckt_1171_and3_x1 67 66 2008 2009 2010 2011 and3_x1
xsubckt_2274_nand2_x0 67 66 898 68 69 nand2_x0
xsubckt_2013_and2_x1 67 66 1173 1174 804 and2_x1
xsubckt_1716_or21nand_x0 67 66 1476 1479 1487 807 or21nand_x0
xsubckt_1518_and21nor_x0 67 66 1668 1691 1713 1716 and21nor_x0
xsubckt_247_and21nor_x0 67 66 694 721 709 701 and21nor_x0
xsubckt_742_or21nand_x0 67 66 233 256 254 255 or21nand_x0
xsubckt_755_nand2_x0 67 66 221 77 78 nand2_x0
xsubckt_1432_and21nor_x0 67 66 1752 1777 1800 1803 and21nor_x0
xsubckt_627_nexor2_x0 67 66 342 345 341 nexor2_x0
xsubckt_475_nor2_x0 67 66 485 36 87 nor2_x0
xsubckt_460_nand2_x0 67 66 499 500 583 nand2_x0
xsubckt_118_nand2_x0 67 66 816 818 1306 nand2_x0
xsubckt_91_inv_x0 67 66 49 843 inv_x0
xsubckt_789_nand2_x0 67 66 188 3 81 nand2_x0
xsubckt_815_nand2_x0 67 66 2351 2 77 nand2_x0
xsubckt_2261_or21nand_x0 67 66 907 908 917 1112 or21nand_x0
xsubckt_2232_nand2_x0 67 66 938 1554 2172 nand2_x0
xsubckt_1946_nexor2_x0 67 66 1247 1249 1245 nexor2_x0
xsubckt_1879_nor2_x0 67 66 1316 1317 796 nor2_x0
xsubckt_1783_or21nand_x0 67 66 1411 1427 1431 1435 or21nand_x0
xsubckt_1677_and21nor_x0 67 66 1514 1515 1516 771 and21nor_x0
xsubckt_1393_nexor2_x0 67 66 1869 33 1790 nexor2_x0
xsubckt_413_and2_x1 67 66 544 39 56 and2_x1
xsubckt_115_and3_x1 67 66 819 820 825 826 and3_x1
xsubckt_32_inv_x0 67 66 89 962 inv_x0
xsubckt_713_nand2_x0 67 66 261 79 80 nand2_x0
xsubckt_1013_nor2_x0 67 66 154 2163 2181 nor2_x0
xsubckt_2097_and3_x1 67 66 1083 794 85 185 and3_x1
xsubckt_2008_nand4_x0 67 66 1179 61 185 184 183 nand4_x0
xsubckt_1799_and3_x1 67 66 1395 794 1015 185 and3_x1
xsubckt_1610_or21nand_x0 67 66 1578 779 1579 1594 or21nand_x0
xsubckt_1411_and2_x1 67 66 1773 846 65 and2_x1
xsubckt_527_nand2_x0 67 66 436 453 474 nand2_x0
xsubckt_462_mux2_x1 67 66 498 512 587 128 mux2_x1
xsubckt_760_or2_x1 67 66 216 4 24 or2_x1
xsubckt_1122_nand4_x0 67 66 2056 870 185 1080 183 nand4_x0
xsubckt_2228_nexor2_x0 67 66 949 74 943 nexor2_x0
xsubckt_1489_and2_x1 67 66 1696 1697 779 and2_x1
xsubckt_63_inv_x0 67 66 27 871 inv_x0
xsubckt_287_nor2_x0 67 66 657 661 1241 nor2_x0
xsubckt_667_mux2_x1 67 66 61 304 586 131 mux2_x1
xsubckt_978_nand3_x0 67 66 2197 748 877 183 nand3_x0
xsubckt_1032_nand3_x0 67 66 2144 767 871 184 nand3_x0
xsubckt_1056_nexor2_x0 67 66 46 47 2120 nexor2_x0
xsubckt_1247_nexor2_x0 67 66 1979 36 1933 nexor2_x0
xsubckt_1263_nand3_x0 67 66 1918 794 872 185 nand3_x0
xsubckt_2034_nand3_x0 67 66 1150 1794 1795 2172 nand3_x0
xsubckt_1933_and21nor_x0 67 66 1259 1264 1262 1260 and21nor_x0
xsubckt_1773_nand2_x0 67 66 1420 39 72 nand2_x0
xsubckt_510_xor2_x0 67 66 83 84 452 xor2_x0
xsubckt_1043_and21nor_x0 67 66 2133 2140 2161 62 and21nor_x0
xsubckt_2213_nexor2_x0 67 66 960 961 958 nexor2_x0
xsubckt_1791_nand3_x0 67 66 1403 1405 1406 768 nand3_x0
xsubckt_1592_nand2_x0 67 66 1596 1597 779 nand2_x0
xsubckt_1445_and4_x1 67 66 1739 1880 857 859 861 and4_x1
xsubckt_522_xor2_x0 67 66 34 85 440 xor2_x0
xsubckt_7_inv_x0 67 66 2387 1231 inv_x0
xsubckt_761_and2_x1 67 66 215 4 24 and2_x1
xsubckt_1256_nexor2_x0 67 66 1982 865 1924 nexor2_x0
xsubckt_2343_dff_x1 67 66 127 186 36 dff_x1
xsubckt_1860_nexor2_x0 67 66 1340 26 1335 nexor2_x0
xsubckt_1815_nexor2_x0 67 66 1389 27 1379 nexor2_x0
xsubckt_1811_nand3_x0 67 66 1383 1390 1394 27 nand3_x0
xsubckt_79_inv_x0 67 66 13 855 inv_x0
xsubckt_231_or21nand_x0 67 66 709 740 735 719 or21nand_x0
xsubckt_1107_nexor2_x0 67 66 2117 7 2070 nexor2_x0
xsubckt_1158_and2_x1 67 66 2020 2021 1101 and2_x1
xsubckt_2234_and21nor_x0 67 66 936 2169 1560 937 and21nor_x0
xsubckt_2143_nand3_x0 67 66 1033 1035 1038 864 nand3_x0
xsubckt_2091_or2_x1 67 66 1089 1090 886 or2_x1
xsubckt_1801_and2_x1 67 66 1393 1410 791 and2_x1
xsubckt_1767_or21nand_x0 67 66 1426 1508 1463 1464 or21nand_x0
xsubckt_1653_nand2_x0 67 66 1537 1538 1543 nand2_x0
xsubckt_96_inv_x0 67 66 64 838 inv_x0
xsubckt_641_xor2_x0 67 66 41 61 328 xor2_x0
xsubckt_976_and2_x1 67 66 2199 2200 746 and2_x1
xsubckt_1099_or21nand_x0 67 66 2078 47 46 39 or21nand_x0
xsubckt_2054_and4_x1 67 66 1129 73 887 1123 72 and4_x1
xsubckt_1797_and21nor_x0 67 66 1397 1403 1401 1398 and21nor_x0
xsubckt_1772_and2_x1 67 66 1421 1424 2177 and2_x1
xsubckt_1645_or21nand_x0 67 66 148 1545 1548 1572 or21nand_x0
xsubckt_1380_and21nor_x0 67 66 1803 1807 1809 941 and21nor_x0
xsubckt_398_and21nor_x0 67 66 558 582 566 559 and21nor_x0
xsubckt_154_nand2_x0 67 66 783 803 1187 nand2_x0
xsubckt_11_inv_x0 67 66 2399 1187 inv_x0
xsubckt_242_or21nand_x0 67 66 699 717 719 720 or21nand_x0
xsubckt_1127_nand3_x0 67 66 2051 767 25 184 nand3_x0
xsubckt_1192_nexor2_x0 67 66 1989 1990 1987 nexor2_x0
xsubckt_1834_nand3_x0 67 66 1361 767 56 184 nand3_x0
xsubckt_142_nand2_x0 67 66 795 187 1306 nand2_x0
xsubckt_809_xor2_x0 67 66 2 80 2357 xor2_x0
xsubckt_843_and21nor_x0 67 66 2324 2363 2330 2326 and21nor_x0
xsubckt_965_nand3_x0 67 66 2210 794 30 185 nand3_x0
xsubckt_1178_and3_x1 67 66 2001 767 24 184 and3_x1
xsubckt_2211_and21nor_x0 67 66 960 1000 1001 1004 and21nor_x0
xsubckt_2071_and3_x1 67 66 1110 1114 1125 79 and3_x1
xsubckt_1957_and21nor_x0 67 66 1233 780 1242 1234 and21nor_x0
xsubckt_1502_mux2_x1 67 66 74 1685 804 1684 mux2_x1
xsubckt_670_and4_x1 67 66 301 794 26 182 185 and4_x1
xsubckt_885_nand3_x0 67 66 2285 683 29 182 nand3_x0
xsubckt_1027_and21nor_x0 67 66 2149 2156 2154 2150 and21nor_x0
xsubckt_1091_nexor2_x0 67 66 2092 60 2086 nexor2_x0
xsubckt_2287_dff_x1 67 66 157 186 183 dff_x1
xsubckt_1666_or21nand_x0 67 66 1524 1530 1527 1525 or21nand_x0
xsubckt_449_nand2_x0 67 66 510 37 57 nand2_x0
xsubckt_337_or3_x1 67 66 612 622 661 1284 or3_x1
xsubckt_131_nand2_x0 67 66 805 185 184 nand2_x0
xsubckt_763_nexor2_x0 67 66 214 217 213 nexor2_x0
xsubckt_988_nand2_x0 67 66 2187 2189 791 nand2_x0
xsubckt_2162_or2_x1 67 66 1013 745 886 or2_x1
xsubckt_1894_and21nor_x0 67 66 1301 1302 1304 1313 and21nor_x0
xsubckt_666_nand2_x0 67 66 304 305 308 nand2_x0
xsubckt_678_and2_x1 67 66 294 28 14 and2_x1
xsubckt_829_and2_x1 67 66 2338 1 76 and2_x1
xsubckt_951_or2_x1 67 66 100 2223 2286 or2_x1
xsubckt_2139_nand2_x0 67 66 1038 1311 794 nand2_x0
xsubckt_2063_and3_x1 67 66 1119 85 184 1091 and3_x1
xsubckt_1787_nand2_x0 67 66 1407 86 185 nand2_x0
xsubckt_1628_and3_x1 67 66 1561 1623 881 882 and3_x1
xsubckt_1512_and21nor_x0 67 66 1674 1680 1686 894 and21nor_x0
xsubckt_533_nor2_x0 67 66 430 431 435 nor2_x0
xsubckt_828_or2_x1 67 66 2339 1 76 or2_x1
xsubckt_1202_nand2_x0 67 66 1977 1978 2172 nand2_x0
xsubckt_2286_dff_x1 67 66 158 186 184 dff_x1
xsubckt_2116_and21nor_x0 67 66 1062 2172 1701 1063 and21nor_x0
xsubckt_1461_nor4_x0 67 66 1724 1725 1726 1727 1769 nor4_x0
xsubckt_1368_nor2_x0 67 66 1815 78 183 nor2_x0
xsubckt_430_nexor2_x0 67 66 38 58 528 nexor2_x0
xsubckt_373_nand3_x0 67 66 582 794 182 185 nand3_x0
xsubckt_723_or21nand_x0 67 66 251 869 578 582 or21nand_x0
xsubckt_1002_nand3_x0 67 66 2173 73 1123 1134 nand3_x0
xsubckt_1072_mux2_x1 67 66 873 184 183 2105 mux2_x1
xsubckt_2302_dff_x1 67 66 171 186 2395 dff_x1
xsubckt_2264_and2_x1 67 66 176 906 70 and2_x1
xsubckt_2216_or21nand_x0 67 66 955 986 1001 1006 or21nand_x0
xsubckt_2018_and21nor_x0 67 66 1168 1181 1172 1170 and21nor_x0
xsubckt_1705_and3_x1 67 66 1487 1488 1080 183 and3_x1
xsubckt_1679_and3_x1 67 66 1512 767 60 184 and3_x1
xsubckt_371_xor2_x0 67 66 57 56 584 xor2_x0
xsubckt_5_inv_x0 67 66 2385 1252 inv_x0
xsubckt_777_or21nand_x0 67 66 200 79 77 78 or21nand_x0
xsubckt_1029_nand3_x0 67 66 2147 806 26 1091 nand3_x0
xsubckt_2279_dff_x1 67 66 180 186 65 dff_x1
xsubckt_2132_nand4_x0 67 66 1045 73 884 1123 72 nand4_x0
xsubckt_1968_and21nor_x0 67 66 1222 1227 1224 1223 and21nor_x0
xsubckt_1949_nexor2_x0 67 66 1244 1248 1242 nexor2_x0
xsubckt_1872_and21nor_x0 67 66 1323 1978 2169 2178 and21nor_x0
xsubckt_1591_nand4_x0 67 66 1597 73 882 1123 1134 nand4_x0
xsubckt_1471_nexor2_x0 67 66 1719 902 1714 nexor2_x0
xsubckt_1459_and4_x1 67 66 1726 856 185 1080 183 and4_x1
xsubckt_1361_nand3_x0 67 66 1822 2209 74 1069 nand3_x0
xsubckt_560_and2_x1 67 66 404 405 578 and2_x1
xsubckt_384_nexor2_x0 67 66 585 962 572 nexor2_x0
xsubckt_82_inv_x0 67 66 10 852 inv_x0
xsubckt_19_inv_x0 67 66 187 1101 inv_x0
xsubckt_219_or21nand_x0 67 66 721 748 183 2389 or21nand_x0
xsubckt_1083_and21nor_x0 67 66 2094 2103 2100 2095 and21nor_x0
xsubckt_1215_nand3_x0 67 66 1965 2209 77 1069 nand3_x0
xsubckt_2070_or21nand_x0 67 66 1111 1115 1126 868 or21nand_x0
xsubckt_1981_and3_x1 67 66 1207 1212 1215 81 and3_x1
xsubckt_1902_nexor2_x0 67 66 1298 25 1292 nexor2_x0
xsubckt_1004_nand2_x0 67 66 2171 2176 1134 nand2_x0
xsubckt_1098_nexor2_x0 67 66 2081 2086 2079 nexor2_x0
xsubckt_1220_and3_x1 67 66 1960 1961 1962 1965 and3_x1
xsubckt_1865_nand2_x0 67 66 1330 1333 1334 nand2_x0
xsubckt_1395_and21nor_x0 67 66 1788 71 73 88 and21nor_x0
xsubckt_420_or21nand_x0 67 66 538 554 555 557 or21nand_x0
xsubckt_715_or2_x1 67 66 259 260 263 or2_x1
xsubckt_764_and2_x1 67 66 212 213 578 and2_x1
xsubckt_1041_and3_x1 67 66 2135 2140 2161 62 and3_x1
xsubckt_1119_mux2_x1 67 66 871 184 183 2059 mux2_x1
xsubckt_1157_nand4_x0 67 66 2021 73 38 1123 1134 nand4_x0
xsubckt_1184_and21nor_x0 67 66 1995 1997 2012 1015 and21nor_x0
xsubckt_1248_and2_x1 67 66 1932 2169 865 and2_x1
xsubckt_2337_dff_x1 67 66 115 186 29 dff_x1
xsubckt_1793_nand3_x0 67 66 1401 1484 1080 183 nand3_x0
xsubckt_358_or2_x1 67 66 594 182 187 or2_x1
xsubckt_116_and4_x1 67 66 818 820 825 826 1155 and4_x1
xsubckt_171_nor2_x0 67 66 767 185 183 nor2_x0
xsubckt_179_and21nor_x0 67 66 759 783 785 787 and21nor_x0
xsubckt_703_or2_x1 67 66 270 7 24 or2_x1
xsubckt_1007_nand3_x0 67 66 2168 73 71 72 nand3_x0
xsubckt_1053_nand4_x0 67 66 2123 73 14 71 72 nand4_x0
xsubckt_1270_nand3_x0 67 66 1911 748 866 183 nand3_x0
xsubckt_2135_nand3_x0 67 66 1042 767 890 184 nand3_x0
xsubckt_1832_and21nor_x0 67 66 113 1363 1367 65 and21nor_x0
xsubckt_1484_nexor2_x0 67 66 1739 13 1701 nexor2_x0
xsubckt_1457_nand3_x0 67 66 1728 767 862 184 nand3_x0
xsubckt_1431_nexor2_x0 67 66 1763 920 1753 nexor2_x0
xsubckt_640_nand2_x0 67 66 329 41 61 nand2_x0
xsubckt_98_nor3_x0 67 66 836 2391 2399 2398 nor3_x0
xsubckt_59_inv_x0 67 66 25 875 inv_x0
xsubckt_318_or21nand_x0 67 66 629 639 661 2397 or21nand_x0
xsubckt_691_or21nand_x0 67 66 282 81 25 24 or21nand_x0
xsubckt_833_nand2_x0 67 66 2334 2335 583 nand2_x0
xsubckt_877_xor2_x0 67 66 13 74 2292 xor2_x0
xsubckt_1062_and2_x1 67 66 2114 2115 2173 and2_x1
xsubckt_1199_and21nor_x0 67 66 1980 72 1981 2179 and21nor_x0
xsubckt_1206_and2_x1 67 66 1973 1974 1977 and2_x1
xsubckt_2229_or21nand_x0 67 66 942 960 964 965 or21nand_x0
xsubckt_2175_and21nor_x0 67 66 999 1023 1028 1031 and21nor_x0
xsubckt_2112_or2_x1 67 66 1066 1067 779 or2_x1
xsubckt_519_and21nor_x0 67 66 443 462 461 460 and21nor_x0
xsubckt_21_inv_x0 67 66 184 1080 inv_x0
xsubckt_740_nand2_x0 67 66 235 5 25 nand2_x0
xsubckt_826_and2_x1 67 66 2341 2342 578 and2_x1
xsubckt_1241_nexor2_x0 67 66 1941 1942 1939 nexor2_x0
xsubckt_2369_dff_x1 67 66 99 186 8 dff_x1
xsubckt_2004_and21nor_x0 67 66 1182 780 1192 1183 and21nor_x0
xsubckt_156_nand2_x0 67 66 781 782 796 nand2_x0
xsubckt_153_and2_x1 67 66 784 803 1187 and2_x1
xsubckt_248_or21nand_x0 67 66 693 722 710 700 or21nand_x0
xsubckt_925_or21nand_x0 67 66 2247 577 2249 2248 or21nand_x0
xsubckt_1070_nand4_x0 67 66 2107 79 185 184 183 nand4_x0
xsubckt_2131_nand4_x0 67 66 1046 73 854 1123 1134 nand4_x0
xsubckt_2040_and2_x1 67 66 1143 1145 779 and2_x1
xsubckt_1748_nand3_x0 67 66 1445 748 56 183 nand3_x0
xsubckt_1529_and21nor_x0 67 66 1657 854 2169 1658 and21nor_x0
xsubckt_331_mux2_x1 67 66 824 619 813 617 mux2_x1
xsubckt_52_inv_x0 67 66 42 882 inv_x0
xsubckt_161_nexor2_x0 67 66 778 786 776 nexor2_x0
xsubckt_166_and3_x1 67 66 174 772 797 1112 and3_x1
xsubckt_302_and21nor_x0 67 66 643 644 646 649 and21nor_x0
xsubckt_2272_and2_x1 67 66 181 900 70 and2_x1
xsubckt_2200_or21nand_x0 67 66 972 183 184 61 or21nand_x0
xsubckt_1794_nand3_x0 67 66 1400 748 89 183 nand3_x0
xsubckt_1707_and2_x1 67 66 1485 88 185 and2_x1
xsubckt_493_nor2_x0 67 66 468 35 89 nor2_x0
xsubckt_681_nexor2_x0 67 66 293 296 291 nexor2_x0
xsubckt_1180_or3_x1 67 66 1999 2001 2002 792 or3_x1
xsubckt_1545_nand2_x0 67 66 1642 794 76 nand2_x0
xsubckt_1493_or21nand_x0 67 66 1692 1751 1760 1761 or21nand_x0
xsubckt_1452_or2_x1 67 66 1732 1733 65 or2_x1
xsubckt_543_or2_x1 67 66 420 33 84 or2_x1
xsubckt_3_inv_x0 67 66 2396 1273 inv_x0
xsubckt_1055_xor2_x0 67 66 46 47 2121 xor2_x0
xsubckt_1112_nand2_x0 67 66 2065 2066 1112 nand2_x0
xsubckt_1221_nand3_x0 67 66 1959 1961 1962 1965 nand3_x0
xsubckt_2259_or21nand_x0 67 66 910 916 914 911 or21nand_x0
xsubckt_2079_and21nor_x0 67 66 1102 1152 1156 1160 and21nor_x0
xsubckt_552_xor2_x0 67 66 61 82 412 xor2_x0
xsubckt_1011_nor3_x0 67 66 2164 2165 2166 2167 nor3_x0
xsubckt_2263_or21nand_x0 67 66 906 839 69 848 or21nand_x0
xsubckt_1910_or21nand_x0 67 66 1283 1328 1335 1336 or21nand_x0
xsubckt_1868_and21nor_x0 67 66 1327 1412 1385 1388 and21nor_x0
xsubckt_1595_nand3_x0 67 66 1593 794 74 185 nand3_x0
xsubckt_1385_and21nor_x0 67 66 1798 1837 1832 1836 and21nor_x0
xsubckt_554_nexor2_x0 67 66 411 413 410 nexor2_x0
xsubckt_45_inv_x0 67 66 33 889 inv_x0
xsubckt_1069_nand3_x0 67 66 2108 794 871 185 nand3_x0
xsubckt_1087_nand3_x0 67 66 2090 2093 2108 60 nand3_x0
xsubckt_1100_nor3_x0 67 66 2077 39 46 47 nor3_x0
xsubckt_1104_and2_x1 67 66 2073 2175 60 and2_x1
xsubckt_2082_and21nor_x0 67 66 1098 780 1099 1127 and21nor_x0
xsubckt_1765_nexor2_x0 67 66 1430 1432 1428 nexor2_x0
xsubckt_1722_or21nand_x0 67 66 1470 1069 1473 1474 or21nand_x0
xsubckt_1618_mux2_x1 67 66 74 29 682 1571 mux2_x1
xsubckt_1552_and2_x1 67 66 1635 1637 84 and2_x1
xsubckt_86_inv_x0 67 66 73 848 inv_x0
xsubckt_165_nand2_x0 67 66 772 773 813 nand2_x0
xsubckt_278_or2_x1 67 66 664 665 666 or2_x1
xsubckt_1258_nand2_x0 67 66 1922 1923 1929 nand2_x0
xsubckt_2313_dff_x1 67 66 141 186 89 dff_x1
xsubckt_2296_dff_x1 67 66 163 186 2387 dff_x1
xsubckt_1731_nexor2_x0 67 66 1463 1507 1461 nexor2_x0
xsubckt_1660_and21nor_x0 67 66 1530 2172 1534 1531 and21nor_x0
xsubckt_1364_nand3_x0 67 66 1819 1916 1080 183 nand3_x0
xsubckt_436_nand2_x0 67 66 522 38 89 nand2_x0
xsubckt_252_nand2_x0 67 66 689 690 692 nand2_x0
xsubckt_861_nand2_x0 67 66 2307 0 75 nand2_x0
xsubckt_894_nor2_x0 67 66 2276 12 29 nor2_x0
xsubckt_2044_or21nand_x0 67 66 1139 1197 1207 1208 or21nand_x0
xsubckt_1961_nand3_x0 67 66 1229 767 87 184 nand3_x0
xsubckt_1726_nand2_x0 67 66 1466 1469 30 nand2_x0
xsubckt_1607_and21nor_x0 67 66 1581 1630 1632 1635 and21nor_x0
xsubckt_1439_and4_x1 67 66 1745 1887 887 889 891 and4_x1
xsubckt_1302_nand4_x0 67 66 1879 2019 863 865 867 nand4_x0
xsubckt_598_nor2_x0 67 66 368 44 61 nor2_x0
xsubckt_103_and21nor_x0 67 66 831 833 1220 1231 and21nor_x0
xsubckt_71_inv_x0 67 66 3 863 inv_x0
xsubckt_194_and21nor_x0 67 66 745 185 184 183 and21nor_x0
xsubckt_1009_and3_x1 67 66 2166 73 47 1134 and3_x1
xsubckt_1183_and2_x1 67 66 1996 1997 2012 and2_x1
xsubckt_2090_or21nand_x0 67 66 1090 185 184 183 or21nand_x0
xsubckt_1963_nand4_x0 67 66 1227 82 185 184 183 nand4_x0
xsubckt_1918_nand2_x0 67 66 1275 1276 1277 nand2_x0
xsubckt_1916_nand4_x0 67 66 1277 73 4 1123 1134 nand4_x0
xsubckt_1877_nand2_x0 67 66 1318 1319 779 nand2_x0
xsubckt_1828_and21nor_x0 67 66 1366 1429 1431 1434 and21nor_x0
xsubckt_1768_nexor2_x0 67 66 1427 1431 1425 nexor2_x0
xsubckt_1434_nexor2_x0 67 66 1752 1754 1750 nexor2_x0
xsubckt_1389_or21nand_x0 67 66 1794 2 1879 1 or21nand_x0
xsubckt_1305_nand2_x0 67 66 1876 1877 1881 nand2_x0
xsubckt_579_and21nor_x0 67 66 386 578 388 387 and21nor_x0
xsubckt_405_and21nor_x0 67 66 552 571 570 569 and21nor_x0
xsubckt_342_nand2_x0 67 66 607 608 2394 nand2_x0
xsubckt_279_and2_x1 67 66 663 664 1112 and2_x1
xsubckt_1105_nor4_x0 67 66 2072 2073 2074 2075 2178 nor4_x0
xsubckt_2349_dff_x1 67 66 135 186 44 dff_x1
xsubckt_2204_nand4_x0 67 66 968 971 972 974 860 nand4_x0
xsubckt_2088_mux2_x1 67 66 1093 21 65 107 mux2_x1
xsubckt_1934_nand3_x0 67 66 1258 794 962 185 nand3_x0
xsubckt_1760_nand2_x0 67 66 1433 1437 28 nand2_x0
xsubckt_1527_nexor2_x0 67 66 1709 884 1659 nexor2_x0
xsubckt_1384_or21nand_x0 67 66 1799 1838 1831 1835 or21nand_x0
xsubckt_417_and21nor_x0 67 66 540 542 583 587 and21nor_x0
xsubckt_361_and3_x1 67 66 159 592 593 1112 and3_x1
xsubckt_918_mux2_x1 67 66 29 2254 586 102 mux2_x1
xsubckt_1186_and3_x1 67 66 1993 1997 2012 58 and3_x1
xsubckt_2195_nand4_x0 67 66 978 73 852 1123 1134 nand4_x0
xsubckt_1892_nand3_x0 67 66 1303 748 87 183 nand3_x0
xsubckt_1548_nand3_x0 67 66 1639 1641 1642 1643 nand3_x0
xsubckt_1363_nand4_x0 67 66 1820 1821 1822 1823 768 nand4_x0
xsubckt_1294_and4_x1 67 66 1887 2029 893 895 909 and4_x1
xsubckt_1291_and21nor_x0 67 66 1890 1936 1942 1945 and21nor_x0
xsubckt_551_or21nand_x0 67 66 413 435 434 433 or21nand_x0
xsubckt_423_xor2_x0 67 66 87 88 535 xor2_x0
xsubckt_421_nor2_x0 67 66 537 87 88 nor2_x0
xsubckt_160_nand2_x0 67 66 777 803 2399 nand2_x0
xsubckt_83_inv_x0 67 66 9 851 inv_x0
xsubckt_18_inv_x0 67 66 65 1112 inv_x0
xsubckt_858_or21nand_x0 67 66 2310 577 2312 2311 or21nand_x0
xsubckt_2303_dff_x1 67 66 170 186 2394 dff_x1
xsubckt_2084_or21nand_x0 67 66 1096 1139 1156 1157 or21nand_x0
xsubckt_1895_nand3_x0 67 66 1300 794 1005 185 nand3_x0
xsubckt_1450_nand2_x0 67 66 1734 1735 1101 nand2_x0
xsubckt_488_xor2_x0 67 66 84 85 473 xor2_x0
xsubckt_973_and4_x1 67 66 2202 2203 2204 2205 768 and4_x1
xsubckt_979_and2_x1 67 66 2196 2197 804 and2_x1
xsubckt_1018_nand2_x0 67 66 2158 2208 878 nand2_x0
xsubckt_1033_and2_x1 67 66 2143 2144 791 and2_x1
xsubckt_1187_nand3_x0 67 66 1992 1997 2012 58 nand3_x0
xsubckt_2069_and21nor_x0 67 66 1113 1114 1125 79 and21nor_x0
xsubckt_1657_nand2_x0 67 66 1533 2169 850 nand2_x0
xsubckt_220_nand3_x0 67 66 720 747 1091 2389 nand3_x0
xsubckt_737_or21nand_x0 67 66 238 243 242 239 or21nand_x0
xsubckt_878_and21nor_x0 67 66 2291 2309 2307 2308 and21nor_x0
xsubckt_2203_nand3_x0 67 66 969 971 972 974 nand3_x0
xsubckt_2138_mux2_x1 67 66 83 1040 579 1039 mux2_x1
xsubckt_1954_and4_x1 67 66 1236 73 3 1123 1134 and4_x1
xsubckt_1810_and3_x1 67 66 1384 1390 1394 27 and3_x1
xsubckt_1624_nexor2_x0 67 66 1571 888 1565 nexor2_x0
xsubckt_604_nand2_x0 67 66 135 363 377 nand2_x0
xsubckt_461_and2_x1 67 66 498 499 505 and2_x1
xsubckt_132_nand2_x0 67 66 804 806 1091 nand2_x0
xsubckt_890_nexor2_x0 67 66 2281 2284 2280 nexor2_x0
xsubckt_1871_and21nor_x0 67 66 1324 2172 1981 1325 and21nor_x0
xsubckt_1758_nand2_x0 67 66 1435 1438 28 nand2_x0
xsubckt_1609_nexor2_x0 67 66 1581 1582 1579 nexor2_x0
xsubckt_1453_and21nor_x0 67 66 1731 780 1746 1732 and21nor_x0
xsubckt_1285_nexor2_x0 67 66 1901 1005 1896 nexor2_x0
xsubckt_497_and2_x1 67 66 464 465 578 and2_x1
xsubckt_107_or2_x1 67 66 827 2385 2384 or2_x1
xsubckt_14_inv_x0 67 66 2393 1155 inv_x0
xsubckt_721_nexor2_x0 67 66 6 26 253 nexor2_x0
xsubckt_1074_nand3_x0 67 66 2103 2105 2106 2107 nand3_x0
xsubckt_1106_nor3_x0 67 66 2071 7 14 15 nor3_x0
xsubckt_1163_or21nand_x0 67 66 2015 2016 2022 1112 or21nand_x0
xsubckt_2255_or21nand_x0 67 66 914 2168 1534 915 or21nand_x0
xsubckt_1856_and3_x1 67 66 1339 1341 1345 26 and3_x1
xsubckt_356_and21nor_x0 67 66 595 2393 597 706 and21nor_x0
xsubckt_351_nexor2_x0 67 66 819 1155 599 nexor2_x0
xsubckt_966_and2_x1 67 66 2209 184 183 and2_x1
xsubckt_1092_and21nor_x0 67 66 2085 2182 2132 2135 and21nor_x0
xsubckt_2098_and3_x1 67 66 1082 794 894 185 and3_x1
xsubckt_1958_and21nor_x0 67 66 1232 1245 796 65 and21nor_x0
xsubckt_1870_and2_x1 67 66 1325 2175 26 and2_x1
xsubckt_1733_nexor2_x0 67 66 1463 1505 1459 nexor2_x0
xsubckt_1723_and21nor_x0 67 66 1469 1471 1476 1491 and21nor_x0
xsubckt_1637_nand4_x0 67 66 1552 73 881 1123 1134 nand4_x0
xsubckt_1600_nand2_x0 67 66 1588 1589 890 nand2_x0
xsubckt_78_inv_x0 67 66 29 856 inv_x0
xsubckt_193_nand2_x0 67 66 746 748 183 nand2_x0
xsubckt_1275_and3_x1 67 66 1906 767 80 184 and3_x1
xsubckt_1822_nand3_x0 67 66 1372 1373 73 1123 nand3_x0
xsubckt_1766_and21nor_x0 67 66 1427 1507 1462 1465 and21nor_x0
xsubckt_1658_nand2_x0 67 66 1532 2175 886 nand2_x0
xsubckt_357_and2_x1 67 66 168 595 596 and2_x1
xsubckt_119_nexor2_x0 67 66 818 2392 815 nexor2_x0
xsubckt_281_nand3_x0 67 66 662 674 681 796 nand3_x0
xsubckt_646_or21nand_x0 67 66 323 577 325 324 or21nand_x0
xsubckt_707_and21nor_x0 67 66 266 267 583 587 and21nor_x0
xsubckt_1408_nand2_x0 67 66 1775 1776 796 nand2_x0
xsubckt_632_xor2_x0 67 66 42 61 336 xor2_x0
xsubckt_652_nand2_x0 67 66 317 318 583 nand2_x0
xsubckt_708_or21nand_x0 67 66 265 583 272 266 or21nand_x0
xsubckt_744_and21nor_x0 67 66 231 5 577 583 and21nor_x0
xsubckt_769_nexor2_x0 67 66 4 79 207 nexor2_x0
xsubckt_775_nor2_x0 67 66 202 219 238 nor2_x0
xsubckt_1097_or21nand_x0 67 66 2080 2127 2137 2138 or21nand_x0
xsubckt_1245_nexor2_x0 67 66 1937 1943 1935 nexor2_x0
xsubckt_1921_nand3_x0 67 66 1271 1272 1281 1286 nand3_x0
xsubckt_1738_nand3_x0 67 66 1455 767 58 184 nand3_x0
xsubckt_1287_and21nor_x0 67 66 1894 1940 1943 1947 and21nor_x0
xsubckt_57_inv_x0 67 66 26 877 inv_x0
xsubckt_183_or21nand_x0 67 66 755 777 785 788 or21nand_x0
xsubckt_1051_nand3_x0 67 66 2125 2127 2132 2134 nand3_x0
xsubckt_2230_and21nor_x0 67 66 940 959 963 966 and21nor_x0
xsubckt_1792_and3_x1 67 66 1402 1484 1080 183 and3_x1
xsubckt_1505_mux2_x1 67 66 75 1684 579 1681 mux2_x1
xsubckt_539_or21nand_x0 67 66 424 450 448 449 or21nand_x0
xsubckt_385_and2_x1 67 66 571 62 47 and2_x1
xsubckt_377_and3_x1 67 66 578 767 182 184 and3_x1
xsubckt_30_inv_x0 67 66 46 983 inv_x0
xsubckt_9_inv_x0 67 66 2389 1209 inv_x0
xsubckt_768_nand2_x0 67 66 208 4 79 nand2_x0
xsubckt_1006_and3_x1 67 66 2169 73 71 72 and3_x1
xsubckt_1854_or21nand_x0 67 66 1341 1360 1349 1344 or21nand_x0
xsubckt_1573_and21nor_x0 67 66 1614 72 1615 2179 and21nor_x0
xsubckt_615_and21nor_x0 67 66 352 369 367 368 and21nor_x0
xsubckt_442_nand2_x0 67 66 517 536 557 nand2_x0
xsubckt_914_nand2_x0 67 66 2257 2260 2261 nand2_x0
xsubckt_930_or21nand_x0 67 66 2242 2263 2258 2244 or21nand_x0
xsubckt_2304_dff_x1 67 66 169 186 2393 dff_x1
xsubckt_1585_nand2_x0 67 66 1603 2175 890 nand2_x0
xsubckt_635_nand3_x0 67 66 333 335 349 354 nand3_x0
xsubckt_506_and21nor_x0 67 66 126 586 456 470 and21nor_x0
xsubckt_102_or21nand_x0 67 66 832 836 1166 1209 or21nand_x0
xsubckt_729_nexor2_x0 67 66 246 249 245 nexor2_x0
xsubckt_2227_nexor2_x0 67 66 949 858 944 nexor2_x0
xsubckt_2222_mux2_x1 67 66 82 61 682 949 mux2_x1
xsubckt_2196_nand4_x0 67 66 977 73 882 1123 72 nand4_x0
xsubckt_1906_nand2_x0 67 66 1288 1290 1291 nand2_x0
xsubckt_1730_nexor2_x0 67 66 1469 30 1462 nexor2_x0
xsubckt_1399_and3_x1 67 66 1784 73 889 1123 and3_x1
xsubckt_1360_nand4_x0 67 66 1823 29 185 184 183 nand4_x0
xsubckt_381_and3_x1 67 66 574 576 581 47 and3_x1
xsubckt_297_nor2_x0 67 66 648 2386 2385 nor2_x0
xsubckt_749_and21nor_x0 67 66 226 249 247 248 and21nor_x0
xsubckt_1501_mux2_x1 67 66 77 29 183 1685 mux2_x1
xsubckt_1367_nand2_x0 67 66 1816 1817 807 nand2_x0
xsubckt_410_mux2_x1 67 66 39 548 578 547 mux2_x1
xsubckt_346_and3_x1 67 66 604 605 623 2397 and3_x1
xsubckt_1896_nand2_x0 67 66 1299 1314 791 nand2_x0
xsubckt_1694_mux2_x1 67 66 878 2120 2169 1498 mux2_x1
xsubckt_1641_and21nor_x0 67 66 1548 780 1562 1549 and21nor_x0
xsubckt_1537_nor2_x0 67 66 1649 1650 1655 nor2_x0
xsubckt_1348_nor2_x0 67 66 1834 1840 1842 nor2_x0
xsubckt_480_or21nand_x0 67 66 480 488 487 481 or21nand_x0
xsubckt_68_inv_x0 67 66 78 866 inv_x0
xsubckt_185_nor2_x0 67 66 753 187 2391 nor2_x0
xsubckt_857_and21nor_x0 67 66 2311 857 577 583 and21nor_x0
xsubckt_1078_or3_x1 67 66 2099 2101 2102 808 or3_x1
xsubckt_1223_nand4_x0 67 66 1957 866 185 1080 183 nand4_x0
xsubckt_1563_or21nand_x0 67 66 1624 1626 1633 796 or21nand_x0
xsubckt_1407_nexor2_x0 67 66 1778 1801 1776 nexor2_x0
xsubckt_432_or21nand_x0 67 66 526 930 578 582 or21nand_x0
xsubckt_739_nor2_x0 67 66 236 5 25 nor2_x0
xsubckt_835_and2_x1 67 66 2332 2362 193 and2_x1
xsubckt_1151_nexor2_x0 67 66 2077 930 2027 nexor2_x0
xsubckt_2365_dff_x1 67 66 103 186 12 dff_x1
xsubckt_2072_nand3_x0 67 66 1109 1114 1125 79 nand3_x0
xsubckt_1688_nand3_x0 67 66 1503 73 879 1134 nand3_x0
xsubckt_1565_nexor2_x0 67 66 1661 43 1622 nexor2_x0
xsubckt_1362_nand2_x0 67 66 1821 2208 80 nand2_x0
xsubckt_581_xor2_x0 67 66 45 82 384 xor2_x0
xsubckt_354_nand2_x0 67 66 597 603 2392 nand2_x0
xsubckt_169_and3_x1 67 66 769 185 1080 183 and3_x1
xsubckt_232_nand3_x0 67 66 708 709 711 796 nand3_x0
xsubckt_863_nexor2_x0 67 66 2306 2309 2305 nexor2_x0
xsubckt_1254_and3_x1 67 66 1926 2019 865 867 and3_x1
.ends cordic_cor
